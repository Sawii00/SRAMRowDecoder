ADE simulation setup
Run mode: Single Run, Sweeps and Corners
Tests:
  project_common:INV_tb:1: project_common/INV_tb/schematic, simulator spectre
    Outputs: "/I"; "/O"; delay(?wf1 VT("/A<0>") ?value1 0.5 ?edge1 "rising" ?nth1 1 ?td1 0.0 ?tol1 nil ?wf2 VT("/WL<1>") ?value2 0.5 ?edge2 "rising" ?nth2 1 ?tol2 nil ?td2 nil ?stop nil ?multiple nil); delay(?wf1 VT("/net07") ?value1 0.5 ?edge1 "rising" ?nth1 1 ?td1 0.0 ?tol1 nil ?wf2 VT("/net3") ?value2 0.5 ?edge2 "rising" ?nth2 1 ?tol2 nil ?td2 nil ?stop nil ?multiple nil); 50-50; fall_time; rise_time; /O; /I
Global variables:
  cap_val = 0
