// File: /home/edauser0/ayigit/RowDecoder_Project/CDS_VISIO/project_pex/Post_L4_256t4_Text/spectreText/spectre.scs
// Created: Tue Dec 21 12:53:14 2021
// Program "Calibre xRC"
// Version "v2020.1_17.9"
//
simulator lang=spectre
include "/home/edauser0/ayigit/RowDecoder_Project/CDS_VISIO/project_pex/Post_L4_256t4_Text/spectreText/spectre.scs.pex"
subckt Post_L4_256t4_Text (  SEL3\<3\> WLSEL\<1023\> SEL2\<3\> WLSEL\<1022\> \
 SEL1\<3\> WLSEL\<1021\> SEL0\<3\> WLSEL\<1020\> WLSEL\<1019\> WLSEL\<1018\> \
 WLSEL\<1017\> SEL0\<2\> WLSEL\<1016\> WLSEL\<1015\> WLSEL\<1014\> \
 WLSEL\<1013\> SEL0\<1\> WLSEL\<1012\> WLSEL\<1011\> WLSEL\<1010\> \
 WLSEL\<1009\> SEL0\<0\> WLSEL\<1008\> WLSEL\<1007\> WLSEL\<1006\> SEL1\<2\> \
 WLSEL\<1005\> WLSEL\<1004\> WLSEL\<1003\> WLSEL\<1002\> WLSEL\<1001\> \
 WLSEL\<1000\> WLSEL\<999\> WLSEL\<998\> WLSEL\<997\> WLSEL\<996\> \
 WLSEL\<995\> WLSEL\<994\> WLSEL\<993\> WLSEL\<992\> WLSEL\<991\> WLSEL\<990\> \
 SEL1\<1\> WLSEL\<989\> WLSEL\<988\> WLSEL\<987\> WLSEL\<986\> WLSEL\<985\> \
 WLSEL\<984\> WLSEL\<983\> WLSEL\<982\> WLSEL\<981\> WLSEL\<980\> WLSEL\<979\> \
 WLSEL\<978\> WLSEL\<977\> WLSEL\<976\> WLSEL\<975\> WLSEL\<974\> SEL1\<0\> \
 WLSEL\<973\> WLSEL\<972\> WLSEL\<971\> WLSEL\<970\> WLSEL\<969\> WLSEL\<968\> \
 WLSEL\<967\> WLSEL\<966\> WLSEL\<965\> WLSEL\<964\> WLSEL\<963\> WLSEL\<962\> \
 WLSEL\<961\> WLSEL\<960\> WLSEL\<959\> SEL2\<2\> WLSEL\<958\> WLSEL\<957\> \
 WLSEL\<956\> WLSEL\<955\> WLSEL\<954\> WLSEL\<953\> WLSEL\<952\> WLSEL\<951\> \
 WLSEL\<950\> WLSEL\<949\> WLSEL\<948\> WLSEL\<947\> WLSEL\<946\> WLSEL\<945\> \
 WLSEL\<944\> WLSEL\<943\> WLSEL\<942\> WLSEL\<941\> WLSEL\<940\> WLSEL\<939\> \
 WLSEL\<938\> WLSEL\<937\> WLSEL\<936\> WLSEL\<935\> WLSEL\<934\> WLSEL\<933\> \
 WLSEL\<932\> WLSEL\<931\> WLSEL\<930\> WLSEL\<929\> WLSEL\<928\> WLSEL\<927\> \
 WLSEL\<926\> WLSEL\<925\> WLSEL\<924\> WLSEL\<923\> WLSEL\<922\> WLSEL\<921\> \
 WLSEL\<920\> WLSEL\<919\> WLSEL\<918\> WLSEL\<917\> WLSEL\<916\> WLSEL\<915\> \
 WLSEL\<914\> WLSEL\<913\> WLSEL\<912\> WLSEL\<911\> WLSEL\<910\> WLSEL\<909\> \
 WLSEL\<908\> WLSEL\<907\> WLSEL\<906\> WLSEL\<905\> WLSEL\<904\> WLSEL\<903\> \
 WLSEL\<902\> WLSEL\<901\> WLSEL\<900\> WLSEL\<899\> WLSEL\<898\> WLSEL\<897\> \
 WLSEL\<896\> WLSEL\<895\> SEL2\<1\> WLSEL\<894\> WLSEL\<893\> WLSEL\<892\> \
 WLSEL\<891\> WLSEL\<890\> WLSEL\<889\> WLSEL\<888\> WLSEL\<887\> WLSEL\<886\> \
 WLSEL\<885\> WLSEL\<884\> WLSEL\<883\> WLSEL\<882\> WLSEL\<881\> WLSEL\<880\> \
 WLSEL\<879\> WLSEL\<878\> WLSEL\<877\> WLSEL\<876\> WLSEL\<875\> WLSEL\<874\> \
 WLSEL\<873\> WLSEL\<872\> WLSEL\<871\> WLSEL\<870\> WLSEL\<869\> WLSEL\<868\> \
 WLSEL\<867\> WLSEL\<866\> WLSEL\<865\> WLSEL\<864\> WLSEL\<863\> WLSEL\<862\> \
 WLSEL\<861\> WLSEL\<860\> WLSEL\<859\> WLSEL\<858\> WLSEL\<857\> WLSEL\<856\> \
 WLSEL\<855\> WLSEL\<854\> WLSEL\<853\> WLSEL\<852\> WLSEL\<851\> WLSEL\<850\> \
 WLSEL\<849\> WLSEL\<848\> WLSEL\<847\> WLSEL\<846\> WLSEL\<845\> WLSEL\<844\> \
 WLSEL\<843\> WLSEL\<842\> WLSEL\<841\> WLSEL\<840\> WLSEL\<839\> WLSEL\<838\> \
 WLSEL\<837\> WLSEL\<836\> WLSEL\<835\> WLSEL\<834\> WLSEL\<833\> WLSEL\<832\> \
 WLSEL\<831\> SEL2\<0\> WLSEL\<830\> WLSEL\<829\> WLSEL\<828\> WLSEL\<827\> \
 WLSEL\<826\> WLSEL\<825\> WLSEL\<824\> WLSEL\<823\> WLSEL\<822\> WLSEL\<821\> \
 WLSEL\<820\> WLSEL\<819\> WLSEL\<818\> WLSEL\<817\> WLSEL\<816\> WLSEL\<815\> \
 WLSEL\<814\> WLSEL\<813\> WLSEL\<812\> WLSEL\<811\> WLSEL\<810\> WLSEL\<809\> \
 WLSEL\<808\> WLSEL\<807\> WLSEL\<806\> WLSEL\<805\> WLSEL\<804\> WLSEL\<803\> \
 WLSEL\<802\> WLSEL\<801\> WLSEL\<800\> WLSEL\<799\> WLSEL\<798\> WLSEL\<797\> \
 WLSEL\<796\> WLSEL\<795\> WLSEL\<794\> WLSEL\<793\> WLSEL\<792\> WLSEL\<791\> \
 WLSEL\<790\> WLSEL\<789\> WLSEL\<788\> WLSEL\<787\> WLSEL\<786\> WLSEL\<785\> \
 WLSEL\<784\> WLSEL\<783\> WLSEL\<782\> WLSEL\<781\> WLSEL\<780\> WLSEL\<779\> \
 WLSEL\<778\> WLSEL\<777\> WLSEL\<776\> WLSEL\<775\> WLSEL\<774\> WLSEL\<773\> \
 WLSEL\<772\> WLSEL\<771\> WLSEL\<770\> WLSEL\<769\> WLSEL\<768\> SEL3\<2\> \
 WLSEL\<767\> WLSEL\<766\> WLSEL\<765\> WLSEL\<764\> WLSEL\<763\> WLSEL\<762\> \
 WLSEL\<761\> WLSEL\<760\> WLSEL\<759\> WLSEL\<758\> WLSEL\<757\> WLSEL\<756\> \
 WLSEL\<755\> WLSEL\<754\> WLSEL\<753\> WLSEL\<752\> WLSEL\<751\> WLSEL\<750\> \
 WLSEL\<749\> WLSEL\<748\> WLSEL\<747\> WLSEL\<746\> WLSEL\<745\> WLSEL\<744\> \
 WLSEL\<743\> WLSEL\<742\> WLSEL\<741\> WLSEL\<740\> WLSEL\<739\> WLSEL\<738\> \
 WLSEL\<737\> WLSEL\<736\> WLSEL\<735\> WLSEL\<734\> WLSEL\<733\> WLSEL\<732\> \
 WLSEL\<731\> WLSEL\<730\> WLSEL\<729\> WLSEL\<728\> WLSEL\<727\> WLSEL\<726\> \
 WLSEL\<725\> WLSEL\<724\> WLSEL\<723\> WLSEL\<722\> WLSEL\<721\> WLSEL\<720\> \
 WLSEL\<719\> WLSEL\<718\> WLSEL\<717\> WLSEL\<716\> WLSEL\<715\> WLSEL\<714\> \
 WLSEL\<713\> WLSEL\<712\> WLSEL\<711\> WLSEL\<710\> WLSEL\<709\> WLSEL\<708\> \
 WLSEL\<707\> WLSEL\<706\> WLSEL\<705\> WLSEL\<704\> WLSEL\<703\> WLSEL\<702\> \
 WLSEL\<701\> WLSEL\<700\> WLSEL\<699\> WLSEL\<698\> WLSEL\<697\> WLSEL\<696\> \
 WLSEL\<695\> WLSEL\<694\> WLSEL\<693\> WLSEL\<692\> WLSEL\<691\> WLSEL\<690\> \
 WLSEL\<689\> WLSEL\<688\> WLSEL\<687\> WLSEL\<686\> WLSEL\<685\> WLSEL\<684\> \
 WLSEL\<683\> WLSEL\<682\> WLSEL\<681\> WLSEL\<680\> WLSEL\<679\> WLSEL\<678\> \
 WLSEL\<677\> WLSEL\<676\> WLSEL\<675\> WLSEL\<674\> WLSEL\<673\> WLSEL\<672\> \
 WLSEL\<671\> WLSEL\<670\> WLSEL\<669\> WLSEL\<668\> WLSEL\<667\> WLSEL\<666\> \
 WLSEL\<665\> WLSEL\<664\> WLSEL\<663\> WLSEL\<662\> WLSEL\<661\> WLSEL\<660\> \
 WLSEL\<659\> WLSEL\<658\> WLSEL\<657\> WLSEL\<656\> WLSEL\<655\> WLSEL\<654\> \
 WLSEL\<653\> WLSEL\<652\> WLSEL\<651\> WLSEL\<650\> WLSEL\<649\> WLSEL\<648\> \
 WLSEL\<647\> WLSEL\<646\> WLSEL\<645\> WLSEL\<644\> WLSEL\<643\> WLSEL\<642\> \
 WLSEL\<641\> WLSEL\<640\> WLSEL\<639\> WLSEL\<638\> WLSEL\<637\> WLSEL\<636\> \
 WLSEL\<635\> WLSEL\<634\> WLSEL\<633\> WLSEL\<632\> WLSEL\<631\> WLSEL\<630\> \
 WLSEL\<629\> WLSEL\<628\> WLSEL\<627\> WLSEL\<626\> WLSEL\<625\> WLSEL\<624\> \
 WLSEL\<623\> WLSEL\<622\> WLSEL\<621\> WLSEL\<620\> WLSEL\<619\> WLSEL\<618\> \
 WLSEL\<617\> WLSEL\<616\> WLSEL\<615\> WLSEL\<614\> WLSEL\<613\> WLSEL\<612\> \
 WLSEL\<611\> WLSEL\<610\> WLSEL\<609\> WLSEL\<608\> WLSEL\<607\> WLSEL\<606\> \
 WLSEL\<605\> WLSEL\<604\> WLSEL\<603\> WLSEL\<602\> WLSEL\<601\> WLSEL\<600\> \
 WLSEL\<599\> WLSEL\<598\> WLSEL\<597\> WLSEL\<596\> WLSEL\<595\> WLSEL\<594\> \
 WLSEL\<593\> WLSEL\<592\> WLSEL\<591\> WLSEL\<590\> WLSEL\<589\> WLSEL\<588\> \
 WLSEL\<587\> WLSEL\<586\> WLSEL\<585\> WLSEL\<584\> WLSEL\<583\> WLSEL\<582\> \
 WLSEL\<581\> WLSEL\<580\> WLSEL\<579\> WLSEL\<578\> WLSEL\<577\> WLSEL\<576\> \
 WLSEL\<575\> WLSEL\<574\> WLSEL\<573\> WLSEL\<572\> WLSEL\<571\> WLSEL\<570\> \
 WLSEL\<569\> WLSEL\<568\> WLSEL\<567\> WLSEL\<566\> WLSEL\<565\> WLSEL\<564\> \
 WLSEL\<563\> WLSEL\<562\> WLSEL\<561\> WLSEL\<560\> WLSEL\<559\> WLSEL\<558\> \
 WLSEL\<557\> WLSEL\<556\> WLSEL\<555\> WLSEL\<554\> WLSEL\<553\> WLSEL\<552\> \
 WLSEL\<551\> WLSEL\<550\> WLSEL\<549\> WLSEL\<548\> WLSEL\<547\> WLSEL\<546\> \
 WLSEL\<545\> WLSEL\<544\> WLSEL\<543\> WLSEL\<542\> WLSEL\<541\> WLSEL\<540\> \
 WLSEL\<539\> WLSEL\<538\> WLSEL\<537\> WLSEL\<536\> WLSEL\<535\> WLSEL\<534\> \
 WLSEL\<533\> WLSEL\<532\> WLSEL\<531\> WLSEL\<530\> WLSEL\<529\> WLSEL\<528\> \
 WLSEL\<527\> WLSEL\<526\> WLSEL\<525\> WLSEL\<524\> WLSEL\<523\> WLSEL\<522\> \
 WLSEL\<521\> WLSEL\<520\> WLSEL\<519\> WLSEL\<518\> WLSEL\<517\> WLSEL\<516\> \
 WLSEL\<515\> WLSEL\<514\> WLSEL\<513\> WLSEL\<512\> SEL3\<1\> WLSEL\<511\> \
 WLSEL\<510\> WLSEL\<509\> WLSEL\<508\> WLSEL\<507\> WLSEL\<506\> WLSEL\<505\> \
 WLSEL\<504\> WLSEL\<503\> WLSEL\<502\> WLSEL\<501\> WLSEL\<500\> WLSEL\<499\> \
 WLSEL\<498\> WLSEL\<497\> WLSEL\<496\> WLSEL\<495\> WLSEL\<494\> WLSEL\<493\> \
 WLSEL\<492\> WLSEL\<491\> WLSEL\<490\> WLSEL\<489\> WLSEL\<488\> WLSEL\<487\> \
 WLSEL\<486\> WLSEL\<485\> WLSEL\<484\> WLSEL\<483\> WLSEL\<482\> WLSEL\<481\> \
 WLSEL\<480\> WLSEL\<479\> WLSEL\<478\> WLSEL\<477\> WLSEL\<476\> WLSEL\<475\> \
 WLSEL\<474\> WLSEL\<473\> WLSEL\<472\> WLSEL\<471\> WLSEL\<470\> WLSEL\<469\> \
 WLSEL\<468\> WLSEL\<467\> WLSEL\<466\> WLSEL\<465\> WLSEL\<464\> WLSEL\<463\> \
 WLSEL\<462\> WLSEL\<461\> WLSEL\<460\> WLSEL\<459\> WLSEL\<458\> WLSEL\<457\> \
 WLSEL\<456\> WLSEL\<455\> WLSEL\<454\> WLSEL\<453\> WLSEL\<452\> WLSEL\<451\> \
 WLSEL\<450\> WLSEL\<449\> WLSEL\<448\> WLSEL\<447\> WLSEL\<446\> WLSEL\<445\> \
 WLSEL\<444\> WLSEL\<443\> WLSEL\<442\> WLSEL\<441\> WLSEL\<440\> WLSEL\<439\> \
 WLSEL\<438\> WLSEL\<437\> WLSEL\<436\> WLSEL\<435\> WLSEL\<434\> WLSEL\<433\> \
 WLSEL\<432\> WLSEL\<431\> WLSEL\<430\> WLSEL\<429\> WLSEL\<428\> WLSEL\<427\> \
 WLSEL\<426\> WLSEL\<425\> WLSEL\<424\> WLSEL\<423\> WLSEL\<422\> WLSEL\<421\> \
 WLSEL\<420\> WLSEL\<419\> WLSEL\<418\> WLSEL\<417\> WLSEL\<416\> WLSEL\<415\> \
 WLSEL\<414\> WLSEL\<413\> WLSEL\<412\> WLSEL\<411\> WLSEL\<410\> WLSEL\<409\> \
 WLSEL\<408\> WLSEL\<407\> WLSEL\<406\> WLSEL\<405\> WLSEL\<404\> WLSEL\<403\> \
 WLSEL\<402\> WLSEL\<401\> WLSEL\<400\> WLSEL\<399\> WLSEL\<398\> WLSEL\<397\> \
 WLSEL\<396\> WLSEL\<395\> WLSEL\<394\> WLSEL\<393\> WLSEL\<392\> WLSEL\<391\> \
 WLSEL\<390\> WLSEL\<389\> WLSEL\<388\> WLSEL\<387\> WLSEL\<386\> WLSEL\<385\> \
 WLSEL\<384\> WLSEL\<383\> WLSEL\<382\> WLSEL\<381\> WLSEL\<380\> WLSEL\<379\> \
 WLSEL\<378\> WLSEL\<377\> WLSEL\<376\> WLSEL\<375\> WLSEL\<374\> WLSEL\<373\> \
 WLSEL\<372\> WLSEL\<371\> WLSEL\<370\> WLSEL\<369\> WLSEL\<368\> WLSEL\<367\> \
 WLSEL\<366\> WLSEL\<365\> WLSEL\<364\> WLSEL\<363\> WLSEL\<362\> WLSEL\<361\> \
 WLSEL\<360\> WLSEL\<359\> WLSEL\<358\> WLSEL\<357\> WLSEL\<356\> WLSEL\<355\> \
 WLSEL\<354\> WLSEL\<353\> WLSEL\<352\> WLSEL\<351\> WLSEL\<350\> WLSEL\<349\> \
 WLSEL\<348\> WLSEL\<347\> WLSEL\<346\> WLSEL\<345\> WLSEL\<344\> WLSEL\<343\> \
 WLSEL\<342\> WLSEL\<341\> WLSEL\<340\> WLSEL\<339\> WLSEL\<338\> WLSEL\<337\> \
 WLSEL\<336\> WLSEL\<335\> WLSEL\<334\> WLSEL\<333\> WLSEL\<332\> WLSEL\<331\> \
 WLSEL\<330\> WLSEL\<329\> WLSEL\<328\> WLSEL\<327\> WLSEL\<326\> WLSEL\<325\> \
 WLSEL\<324\> WLSEL\<323\> WLSEL\<322\> WLSEL\<321\> WLSEL\<320\> WLSEL\<319\> \
 WLSEL\<318\> WLSEL\<317\> WLSEL\<316\> WLSEL\<315\> WLSEL\<314\> WLSEL\<313\> \
 WLSEL\<312\> WLSEL\<311\> WLSEL\<310\> WLSEL\<309\> WLSEL\<308\> WLSEL\<307\> \
 WLSEL\<306\> WLSEL\<305\> WLSEL\<304\> WLSEL\<303\> WLSEL\<302\> WLSEL\<301\> \
 WLSEL\<300\> WLSEL\<299\> WLSEL\<298\> WLSEL\<297\> WLSEL\<296\> WLSEL\<295\> \
 WLSEL\<294\> WLSEL\<293\> WLSEL\<292\> WLSEL\<291\> WLSEL\<290\> WLSEL\<289\> \
 WLSEL\<288\> WLSEL\<287\> WLSEL\<286\> WLSEL\<285\> WLSEL\<284\> WLSEL\<283\> \
 WLSEL\<282\> WLSEL\<281\> WLSEL\<280\> WLSEL\<279\> WLSEL\<278\> WLSEL\<277\> \
 WLSEL\<276\> WLSEL\<275\> WLSEL\<274\> WLSEL\<273\> WLSEL\<272\> WLSEL\<271\> \
 WLSEL\<270\> WLSEL\<269\> WLSEL\<268\> WLSEL\<267\> WLSEL\<266\> WLSEL\<265\> \
 WLSEL\<264\> WLSEL\<263\> WLSEL\<262\> WLSEL\<261\> WLSEL\<260\> WLSEL\<259\> \
 WLSEL\<258\> WLSEL\<257\> WLSEL\<256\> SEL3\<0\> WLSEL\<255\> WLSEL\<254\> \
 WLSEL\<253\> WLSEL\<252\> WLSEL\<251\> WLSEL\<250\> WLSEL\<249\> WLSEL\<248\> \
 WLSEL\<247\> WLSEL\<246\> WLSEL\<245\> WLSEL\<244\> WLSEL\<243\> WLSEL\<242\> \
 WLSEL\<241\> WLSEL\<240\> WLSEL\<239\> WLSEL\<238\> WLSEL\<237\> WLSEL\<236\> \
 WLSEL\<235\> WLSEL\<234\> WLSEL\<233\> WLSEL\<232\> WLSEL\<231\> WLSEL\<230\> \
 WLSEL\<229\> WLSEL\<228\> WLSEL\<227\> WLSEL\<226\> WLSEL\<225\> WLSEL\<224\> \
 WLSEL\<223\> WLSEL\<222\> WLSEL\<221\> WLSEL\<220\> WLSEL\<219\> WLSEL\<218\> \
 WLSEL\<217\> WLSEL\<216\> WLSEL\<215\> WLSEL\<214\> WLSEL\<213\> WLSEL\<212\> \
 WLSEL\<211\> WLSEL\<210\> WLSEL\<209\> WLSEL\<208\> WLSEL\<207\> WLSEL\<206\> \
 WLSEL\<205\> WLSEL\<204\> WLSEL\<203\> WLSEL\<202\> WLSEL\<201\> WLSEL\<200\> \
 WLSEL\<199\> WLSEL\<198\> WLSEL\<197\> WLSEL\<196\> WLSEL\<195\> WLSEL\<194\> \
 WLSEL\<193\> WLSEL\<192\> WLSEL\<191\> WLSEL\<190\> WLSEL\<189\> WLSEL\<188\> \
 WLSEL\<187\> WLSEL\<186\> WLSEL\<185\> WLSEL\<184\> WLSEL\<183\> WLSEL\<182\> \
 WLSEL\<181\> WLSEL\<180\> WLSEL\<179\> WLSEL\<178\> WLSEL\<177\> WLSEL\<176\> \
 WLSEL\<175\> WLSEL\<174\> WLSEL\<173\> WLSEL\<172\> WLSEL\<171\> WLSEL\<170\> \
 WLSEL\<169\> WLSEL\<168\> WLSEL\<167\> WLSEL\<166\> WLSEL\<165\> WLSEL\<164\> \
 WLSEL\<163\> WLSEL\<162\> WLSEL\<161\> WLSEL\<160\> WLSEL\<159\> WLSEL\<158\> \
 WLSEL\<157\> WLSEL\<156\> WLSEL\<155\> WLSEL\<154\> WLSEL\<153\> WLSEL\<152\> \
 WLSEL\<151\> WLSEL\<150\> WLSEL\<149\> WLSEL\<148\> WLSEL\<147\> WLSEL\<146\> \
 WLSEL\<145\> WLSEL\<144\> WLSEL\<143\> WLSEL\<142\> WLSEL\<141\> WLSEL\<140\> \
 WLSEL\<139\> WLSEL\<138\> WLSEL\<137\> WLSEL\<136\> WLSEL\<135\> WLSEL\<134\> \
 WLSEL\<133\> WLSEL\<132\> WLSEL\<131\> WLSEL\<130\> WLSEL\<129\> WLSEL\<128\> \
 WLSEL\<127\> WLSEL\<126\> WLSEL\<125\> WLSEL\<124\> WLSEL\<123\> WLSEL\<122\> \
 WLSEL\<121\> WLSEL\<120\> WLSEL\<119\> WLSEL\<118\> WLSEL\<117\> WLSEL\<116\> \
 WLSEL\<115\> WLSEL\<114\> WLSEL\<113\> WLSEL\<112\> WLSEL\<111\> WLSEL\<110\> \
 WLSEL\<109\> WLSEL\<108\> WLSEL\<107\> WLSEL\<106\> WLSEL\<105\> WLSEL\<104\> \
 WLSEL\<103\> WLSEL\<102\> WLSEL\<101\> WLSEL\<100\> WLSEL\<99\> WLSEL\<98\> \
 WLSEL\<97\> WLSEL\<96\> WLSEL\<95\> WLSEL\<94\> WLSEL\<93\> WLSEL\<92\> \
 WLSEL\<91\> WLSEL\<90\> WLSEL\<89\> WLSEL\<88\> WLSEL\<87\> WLSEL\<86\> \
 WLSEL\<85\> WLSEL\<84\> WLSEL\<83\> WLSEL\<82\> WLSEL\<81\> WLSEL\<80\> \
 WLSEL\<79\> WLSEL\<78\> WLSEL\<77\> WLSEL\<76\> WLSEL\<75\> WLSEL\<74\> \
 WLSEL\<73\> WLSEL\<72\> WLSEL\<71\> WLSEL\<70\> WLSEL\<69\> WLSEL\<68\> \
 WLSEL\<67\> WLSEL\<66\> WLSEL\<65\> WLSEL\<64\> WLSEL\<63\> WLSEL\<62\> \
 WLSEL\<61\> WLSEL\<60\> WLSEL\<59\> WLSEL\<58\> WLSEL\<57\> WLSEL\<56\> \
 WLSEL\<55\> WLSEL\<54\> WLSEL\<53\> WLSEL\<52\> WLSEL\<51\> WLSEL\<50\> \
 WLSEL\<49\> WLSEL\<48\> WLSEL\<47\> WLSEL\<46\> WLSEL\<45\> WLSEL\<44\> \
 WLSEL\<43\> WLSEL\<42\> WLSEL\<41\> WLSEL\<40\> WLSEL\<39\> WLSEL\<38\> \
 WLSEL\<37\> WLSEL\<36\> WLSEL\<35\> WLSEL\<34\> WLSEL\<33\> WLSEL\<32\> \
 WLSEL\<31\> WLSEL\<30\> WLSEL\<29\> WLSEL\<28\> WLSEL\<27\> WLSEL\<26\> \
 WLSEL\<25\> WLSEL\<24\> WLSEL\<23\> WLSEL\<22\> WLSEL\<21\> WLSEL\<20\> \
 WLSEL\<19\> WLSEL\<18\> WLSEL\<17\> WLSEL\<16\> WLSEL\<15\> WLSEL\<14\> \
 WLSEL\<13\> WLSEL\<12\> WLSEL\<11\> WLSEL\<10\> WLSEL\<9\> WLSEL\<8\> \
 WLSEL\<7\> WLSEL\<6\> WLSEL\<5\> WLSEL\<4\> WLSEL\<3\> WLSEL\<2\> WLSEL\<1\> \
 WLSEL\<0\> )
//
// WLSEL<0>	WLSEL<0>
// WLSEL<1>	WLSEL<1>
// WLSEL<2>	WLSEL<2>
// WLSEL<3>	WLSEL<3>
// WLSEL<4>	WLSEL<4>
// WLSEL<5>	WLSEL<5>
// WLSEL<6>	WLSEL<6>
// WLSEL<7>	WLSEL<7>
// WLSEL<8>	WLSEL<8>
// WLSEL<9>	WLSEL<9>
// WLSEL<10>	WLSEL<10>
// WLSEL<11>	WLSEL<11>
// WLSEL<12>	WLSEL<12>
// WLSEL<13>	WLSEL<13>
// WLSEL<14>	WLSEL<14>
// WLSEL<15>	WLSEL<15>
// WLSEL<16>	WLSEL<16>
// WLSEL<17>	WLSEL<17>
// WLSEL<18>	WLSEL<18>
// WLSEL<19>	WLSEL<19>
// WLSEL<20>	WLSEL<20>
// WLSEL<21>	WLSEL<21>
// WLSEL<22>	WLSEL<22>
// WLSEL<23>	WLSEL<23>
// WLSEL<24>	WLSEL<24>
// WLSEL<25>	WLSEL<25>
// WLSEL<26>	WLSEL<26>
// WLSEL<27>	WLSEL<27>
// WLSEL<28>	WLSEL<28>
// WLSEL<29>	WLSEL<29>
// WLSEL<30>	WLSEL<30>
// WLSEL<31>	WLSEL<31>
// WLSEL<32>	WLSEL<32>
// WLSEL<33>	WLSEL<33>
// WLSEL<34>	WLSEL<34>
// WLSEL<35>	WLSEL<35>
// WLSEL<36>	WLSEL<36>
// WLSEL<37>	WLSEL<37>
// WLSEL<38>	WLSEL<38>
// WLSEL<39>	WLSEL<39>
// WLSEL<40>	WLSEL<40>
// WLSEL<41>	WLSEL<41>
// WLSEL<42>	WLSEL<42>
// WLSEL<43>	WLSEL<43>
// WLSEL<44>	WLSEL<44>
// WLSEL<45>	WLSEL<45>
// WLSEL<46>	WLSEL<46>
// WLSEL<47>	WLSEL<47>
// WLSEL<48>	WLSEL<48>
// WLSEL<49>	WLSEL<49>
// WLSEL<50>	WLSEL<50>
// WLSEL<51>	WLSEL<51>
// WLSEL<52>	WLSEL<52>
// WLSEL<53>	WLSEL<53>
// WLSEL<54>	WLSEL<54>
// WLSEL<55>	WLSEL<55>
// WLSEL<56>	WLSEL<56>
// WLSEL<57>	WLSEL<57>
// WLSEL<58>	WLSEL<58>
// WLSEL<59>	WLSEL<59>
// WLSEL<60>	WLSEL<60>
// WLSEL<61>	WLSEL<61>
// WLSEL<62>	WLSEL<62>
// WLSEL<63>	WLSEL<63>
// WLSEL<64>	WLSEL<64>
// WLSEL<65>	WLSEL<65>
// WLSEL<66>	WLSEL<66>
// WLSEL<67>	WLSEL<67>
// WLSEL<68>	WLSEL<68>
// WLSEL<69>	WLSEL<69>
// WLSEL<70>	WLSEL<70>
// WLSEL<71>	WLSEL<71>
// WLSEL<72>	WLSEL<72>
// WLSEL<73>	WLSEL<73>
// WLSEL<74>	WLSEL<74>
// WLSEL<75>	WLSEL<75>
// WLSEL<76>	WLSEL<76>
// WLSEL<77>	WLSEL<77>
// WLSEL<78>	WLSEL<78>
// WLSEL<79>	WLSEL<79>
// WLSEL<80>	WLSEL<80>
// WLSEL<81>	WLSEL<81>
// WLSEL<82>	WLSEL<82>
// WLSEL<83>	WLSEL<83>
// WLSEL<84>	WLSEL<84>
// WLSEL<85>	WLSEL<85>
// WLSEL<86>	WLSEL<86>
// WLSEL<87>	WLSEL<87>
// WLSEL<88>	WLSEL<88>
// WLSEL<89>	WLSEL<89>
// WLSEL<90>	WLSEL<90>
// WLSEL<91>	WLSEL<91>
// WLSEL<92>	WLSEL<92>
// WLSEL<93>	WLSEL<93>
// WLSEL<94>	WLSEL<94>
// WLSEL<95>	WLSEL<95>
// WLSEL<96>	WLSEL<96>
// WLSEL<97>	WLSEL<97>
// WLSEL<98>	WLSEL<98>
// WLSEL<99>	WLSEL<99>
// WLSEL<100>	WLSEL<100>
// WLSEL<101>	WLSEL<101>
// WLSEL<102>	WLSEL<102>
// WLSEL<103>	WLSEL<103>
// WLSEL<104>	WLSEL<104>
// WLSEL<105>	WLSEL<105>
// WLSEL<106>	WLSEL<106>
// WLSEL<107>	WLSEL<107>
// WLSEL<108>	WLSEL<108>
// WLSEL<109>	WLSEL<109>
// WLSEL<110>	WLSEL<110>
// WLSEL<111>	WLSEL<111>
// WLSEL<112>	WLSEL<112>
// WLSEL<113>	WLSEL<113>
// WLSEL<114>	WLSEL<114>
// WLSEL<115>	WLSEL<115>
// WLSEL<116>	WLSEL<116>
// WLSEL<117>	WLSEL<117>
// WLSEL<118>	WLSEL<118>
// WLSEL<119>	WLSEL<119>
// WLSEL<120>	WLSEL<120>
// WLSEL<121>	WLSEL<121>
// WLSEL<122>	WLSEL<122>
// WLSEL<123>	WLSEL<123>
// WLSEL<124>	WLSEL<124>
// WLSEL<125>	WLSEL<125>
// WLSEL<126>	WLSEL<126>
// WLSEL<127>	WLSEL<127>
// WLSEL<128>	WLSEL<128>
// WLSEL<129>	WLSEL<129>
// WLSEL<130>	WLSEL<130>
// WLSEL<131>	WLSEL<131>
// WLSEL<132>	WLSEL<132>
// WLSEL<133>	WLSEL<133>
// WLSEL<134>	WLSEL<134>
// WLSEL<135>	WLSEL<135>
// WLSEL<136>	WLSEL<136>
// WLSEL<137>	WLSEL<137>
// WLSEL<138>	WLSEL<138>
// WLSEL<139>	WLSEL<139>
// WLSEL<140>	WLSEL<140>
// WLSEL<141>	WLSEL<141>
// WLSEL<142>	WLSEL<142>
// WLSEL<143>	WLSEL<143>
// WLSEL<144>	WLSEL<144>
// WLSEL<145>	WLSEL<145>
// WLSEL<146>	WLSEL<146>
// WLSEL<147>	WLSEL<147>
// WLSEL<148>	WLSEL<148>
// WLSEL<149>	WLSEL<149>
// WLSEL<150>	WLSEL<150>
// WLSEL<151>	WLSEL<151>
// WLSEL<152>	WLSEL<152>
// WLSEL<153>	WLSEL<153>
// WLSEL<154>	WLSEL<154>
// WLSEL<155>	WLSEL<155>
// WLSEL<156>	WLSEL<156>
// WLSEL<157>	WLSEL<157>
// WLSEL<158>	WLSEL<158>
// WLSEL<159>	WLSEL<159>
// WLSEL<160>	WLSEL<160>
// WLSEL<161>	WLSEL<161>
// WLSEL<162>	WLSEL<162>
// WLSEL<163>	WLSEL<163>
// WLSEL<164>	WLSEL<164>
// WLSEL<165>	WLSEL<165>
// WLSEL<166>	WLSEL<166>
// WLSEL<167>	WLSEL<167>
// WLSEL<168>	WLSEL<168>
// WLSEL<169>	WLSEL<169>
// WLSEL<170>	WLSEL<170>
// WLSEL<171>	WLSEL<171>
// WLSEL<172>	WLSEL<172>
// WLSEL<173>	WLSEL<173>
// WLSEL<174>	WLSEL<174>
// WLSEL<175>	WLSEL<175>
// WLSEL<176>	WLSEL<176>
// WLSEL<177>	WLSEL<177>
// WLSEL<178>	WLSEL<178>
// WLSEL<179>	WLSEL<179>
// WLSEL<180>	WLSEL<180>
// WLSEL<181>	WLSEL<181>
// WLSEL<182>	WLSEL<182>
// WLSEL<183>	WLSEL<183>
// WLSEL<184>	WLSEL<184>
// WLSEL<185>	WLSEL<185>
// WLSEL<186>	WLSEL<186>
// WLSEL<187>	WLSEL<187>
// WLSEL<188>	WLSEL<188>
// WLSEL<189>	WLSEL<189>
// WLSEL<190>	WLSEL<190>
// WLSEL<191>	WLSEL<191>
// WLSEL<192>	WLSEL<192>
// WLSEL<193>	WLSEL<193>
// WLSEL<194>	WLSEL<194>
// WLSEL<195>	WLSEL<195>
// WLSEL<196>	WLSEL<196>
// WLSEL<197>	WLSEL<197>
// WLSEL<198>	WLSEL<198>
// WLSEL<199>	WLSEL<199>
// WLSEL<200>	WLSEL<200>
// WLSEL<201>	WLSEL<201>
// WLSEL<202>	WLSEL<202>
// WLSEL<203>	WLSEL<203>
// WLSEL<204>	WLSEL<204>
// WLSEL<205>	WLSEL<205>
// WLSEL<206>	WLSEL<206>
// WLSEL<207>	WLSEL<207>
// WLSEL<208>	WLSEL<208>
// WLSEL<209>	WLSEL<209>
// WLSEL<210>	WLSEL<210>
// WLSEL<211>	WLSEL<211>
// WLSEL<212>	WLSEL<212>
// WLSEL<213>	WLSEL<213>
// WLSEL<214>	WLSEL<214>
// WLSEL<215>	WLSEL<215>
// WLSEL<216>	WLSEL<216>
// WLSEL<217>	WLSEL<217>
// WLSEL<218>	WLSEL<218>
// WLSEL<219>	WLSEL<219>
// WLSEL<220>	WLSEL<220>
// WLSEL<221>	WLSEL<221>
// WLSEL<222>	WLSEL<222>
// WLSEL<223>	WLSEL<223>
// WLSEL<224>	WLSEL<224>
// WLSEL<225>	WLSEL<225>
// WLSEL<226>	WLSEL<226>
// WLSEL<227>	WLSEL<227>
// WLSEL<228>	WLSEL<228>
// WLSEL<229>	WLSEL<229>
// WLSEL<230>	WLSEL<230>
// WLSEL<231>	WLSEL<231>
// WLSEL<232>	WLSEL<232>
// WLSEL<233>	WLSEL<233>
// WLSEL<234>	WLSEL<234>
// WLSEL<235>	WLSEL<235>
// WLSEL<236>	WLSEL<236>
// WLSEL<237>	WLSEL<237>
// WLSEL<238>	WLSEL<238>
// WLSEL<239>	WLSEL<239>
// WLSEL<240>	WLSEL<240>
// WLSEL<241>	WLSEL<241>
// WLSEL<242>	WLSEL<242>
// WLSEL<243>	WLSEL<243>
// WLSEL<244>	WLSEL<244>
// WLSEL<245>	WLSEL<245>
// WLSEL<246>	WLSEL<246>
// WLSEL<247>	WLSEL<247>
// WLSEL<248>	WLSEL<248>
// WLSEL<249>	WLSEL<249>
// WLSEL<250>	WLSEL<250>
// WLSEL<251>	WLSEL<251>
// WLSEL<252>	WLSEL<252>
// WLSEL<253>	WLSEL<253>
// WLSEL<254>	WLSEL<254>
// WLSEL<255>	WLSEL<255>
// SEL3<0>	SEL3<0>
// WLSEL<256>	WLSEL<256>
// WLSEL<257>	WLSEL<257>
// WLSEL<258>	WLSEL<258>
// WLSEL<259>	WLSEL<259>
// WLSEL<260>	WLSEL<260>
// WLSEL<261>	WLSEL<261>
// WLSEL<262>	WLSEL<262>
// WLSEL<263>	WLSEL<263>
// WLSEL<264>	WLSEL<264>
// WLSEL<265>	WLSEL<265>
// WLSEL<266>	WLSEL<266>
// WLSEL<267>	WLSEL<267>
// WLSEL<268>	WLSEL<268>
// WLSEL<269>	WLSEL<269>
// WLSEL<270>	WLSEL<270>
// WLSEL<271>	WLSEL<271>
// WLSEL<272>	WLSEL<272>
// WLSEL<273>	WLSEL<273>
// WLSEL<274>	WLSEL<274>
// WLSEL<275>	WLSEL<275>
// WLSEL<276>	WLSEL<276>
// WLSEL<277>	WLSEL<277>
// WLSEL<278>	WLSEL<278>
// WLSEL<279>	WLSEL<279>
// WLSEL<280>	WLSEL<280>
// WLSEL<281>	WLSEL<281>
// WLSEL<282>	WLSEL<282>
// WLSEL<283>	WLSEL<283>
// WLSEL<284>	WLSEL<284>
// WLSEL<285>	WLSEL<285>
// WLSEL<286>	WLSEL<286>
// WLSEL<287>	WLSEL<287>
// WLSEL<288>	WLSEL<288>
// WLSEL<289>	WLSEL<289>
// WLSEL<290>	WLSEL<290>
// WLSEL<291>	WLSEL<291>
// WLSEL<292>	WLSEL<292>
// WLSEL<293>	WLSEL<293>
// WLSEL<294>	WLSEL<294>
// WLSEL<295>	WLSEL<295>
// WLSEL<296>	WLSEL<296>
// WLSEL<297>	WLSEL<297>
// WLSEL<298>	WLSEL<298>
// WLSEL<299>	WLSEL<299>
// WLSEL<300>	WLSEL<300>
// WLSEL<301>	WLSEL<301>
// WLSEL<302>	WLSEL<302>
// WLSEL<303>	WLSEL<303>
// WLSEL<304>	WLSEL<304>
// WLSEL<305>	WLSEL<305>
// WLSEL<306>	WLSEL<306>
// WLSEL<307>	WLSEL<307>
// WLSEL<308>	WLSEL<308>
// WLSEL<309>	WLSEL<309>
// WLSEL<310>	WLSEL<310>
// WLSEL<311>	WLSEL<311>
// WLSEL<312>	WLSEL<312>
// WLSEL<313>	WLSEL<313>
// WLSEL<314>	WLSEL<314>
// WLSEL<315>	WLSEL<315>
// WLSEL<316>	WLSEL<316>
// WLSEL<317>	WLSEL<317>
// WLSEL<318>	WLSEL<318>
// WLSEL<319>	WLSEL<319>
// WLSEL<320>	WLSEL<320>
// WLSEL<321>	WLSEL<321>
// WLSEL<322>	WLSEL<322>
// WLSEL<323>	WLSEL<323>
// WLSEL<324>	WLSEL<324>
// WLSEL<325>	WLSEL<325>
// WLSEL<326>	WLSEL<326>
// WLSEL<327>	WLSEL<327>
// WLSEL<328>	WLSEL<328>
// WLSEL<329>	WLSEL<329>
// WLSEL<330>	WLSEL<330>
// WLSEL<331>	WLSEL<331>
// WLSEL<332>	WLSEL<332>
// WLSEL<333>	WLSEL<333>
// WLSEL<334>	WLSEL<334>
// WLSEL<335>	WLSEL<335>
// WLSEL<336>	WLSEL<336>
// WLSEL<337>	WLSEL<337>
// WLSEL<338>	WLSEL<338>
// WLSEL<339>	WLSEL<339>
// WLSEL<340>	WLSEL<340>
// WLSEL<341>	WLSEL<341>
// WLSEL<342>	WLSEL<342>
// WLSEL<343>	WLSEL<343>
// WLSEL<344>	WLSEL<344>
// WLSEL<345>	WLSEL<345>
// WLSEL<346>	WLSEL<346>
// WLSEL<347>	WLSEL<347>
// WLSEL<348>	WLSEL<348>
// WLSEL<349>	WLSEL<349>
// WLSEL<350>	WLSEL<350>
// WLSEL<351>	WLSEL<351>
// WLSEL<352>	WLSEL<352>
// WLSEL<353>	WLSEL<353>
// WLSEL<354>	WLSEL<354>
// WLSEL<355>	WLSEL<355>
// WLSEL<356>	WLSEL<356>
// WLSEL<357>	WLSEL<357>
// WLSEL<358>	WLSEL<358>
// WLSEL<359>	WLSEL<359>
// WLSEL<360>	WLSEL<360>
// WLSEL<361>	WLSEL<361>
// WLSEL<362>	WLSEL<362>
// WLSEL<363>	WLSEL<363>
// WLSEL<364>	WLSEL<364>
// WLSEL<365>	WLSEL<365>
// WLSEL<366>	WLSEL<366>
// WLSEL<367>	WLSEL<367>
// WLSEL<368>	WLSEL<368>
// WLSEL<369>	WLSEL<369>
// WLSEL<370>	WLSEL<370>
// WLSEL<371>	WLSEL<371>
// WLSEL<372>	WLSEL<372>
// WLSEL<373>	WLSEL<373>
// WLSEL<374>	WLSEL<374>
// WLSEL<375>	WLSEL<375>
// WLSEL<376>	WLSEL<376>
// WLSEL<377>	WLSEL<377>
// WLSEL<378>	WLSEL<378>
// WLSEL<379>	WLSEL<379>
// WLSEL<380>	WLSEL<380>
// WLSEL<381>	WLSEL<381>
// WLSEL<382>	WLSEL<382>
// WLSEL<383>	WLSEL<383>
// WLSEL<384>	WLSEL<384>
// WLSEL<385>	WLSEL<385>
// WLSEL<386>	WLSEL<386>
// WLSEL<387>	WLSEL<387>
// WLSEL<388>	WLSEL<388>
// WLSEL<389>	WLSEL<389>
// WLSEL<390>	WLSEL<390>
// WLSEL<391>	WLSEL<391>
// WLSEL<392>	WLSEL<392>
// WLSEL<393>	WLSEL<393>
// WLSEL<394>	WLSEL<394>
// WLSEL<395>	WLSEL<395>
// WLSEL<396>	WLSEL<396>
// WLSEL<397>	WLSEL<397>
// WLSEL<398>	WLSEL<398>
// WLSEL<399>	WLSEL<399>
// WLSEL<400>	WLSEL<400>
// WLSEL<401>	WLSEL<401>
// WLSEL<402>	WLSEL<402>
// WLSEL<403>	WLSEL<403>
// WLSEL<404>	WLSEL<404>
// WLSEL<405>	WLSEL<405>
// WLSEL<406>	WLSEL<406>
// WLSEL<407>	WLSEL<407>
// WLSEL<408>	WLSEL<408>
// WLSEL<409>	WLSEL<409>
// WLSEL<410>	WLSEL<410>
// WLSEL<411>	WLSEL<411>
// WLSEL<412>	WLSEL<412>
// WLSEL<413>	WLSEL<413>
// WLSEL<414>	WLSEL<414>
// WLSEL<415>	WLSEL<415>
// WLSEL<416>	WLSEL<416>
// WLSEL<417>	WLSEL<417>
// WLSEL<418>	WLSEL<418>
// WLSEL<419>	WLSEL<419>
// WLSEL<420>	WLSEL<420>
// WLSEL<421>	WLSEL<421>
// WLSEL<422>	WLSEL<422>
// WLSEL<423>	WLSEL<423>
// WLSEL<424>	WLSEL<424>
// WLSEL<425>	WLSEL<425>
// WLSEL<426>	WLSEL<426>
// WLSEL<427>	WLSEL<427>
// WLSEL<428>	WLSEL<428>
// WLSEL<429>	WLSEL<429>
// WLSEL<430>	WLSEL<430>
// WLSEL<431>	WLSEL<431>
// WLSEL<432>	WLSEL<432>
// WLSEL<433>	WLSEL<433>
// WLSEL<434>	WLSEL<434>
// WLSEL<435>	WLSEL<435>
// WLSEL<436>	WLSEL<436>
// WLSEL<437>	WLSEL<437>
// WLSEL<438>	WLSEL<438>
// WLSEL<439>	WLSEL<439>
// WLSEL<440>	WLSEL<440>
// WLSEL<441>	WLSEL<441>
// WLSEL<442>	WLSEL<442>
// WLSEL<443>	WLSEL<443>
// WLSEL<444>	WLSEL<444>
// WLSEL<445>	WLSEL<445>
// WLSEL<446>	WLSEL<446>
// WLSEL<447>	WLSEL<447>
// WLSEL<448>	WLSEL<448>
// WLSEL<449>	WLSEL<449>
// WLSEL<450>	WLSEL<450>
// WLSEL<451>	WLSEL<451>
// WLSEL<452>	WLSEL<452>
// WLSEL<453>	WLSEL<453>
// WLSEL<454>	WLSEL<454>
// WLSEL<455>	WLSEL<455>
// WLSEL<456>	WLSEL<456>
// WLSEL<457>	WLSEL<457>
// WLSEL<458>	WLSEL<458>
// WLSEL<459>	WLSEL<459>
// WLSEL<460>	WLSEL<460>
// WLSEL<461>	WLSEL<461>
// WLSEL<462>	WLSEL<462>
// WLSEL<463>	WLSEL<463>
// WLSEL<464>	WLSEL<464>
// WLSEL<465>	WLSEL<465>
// WLSEL<466>	WLSEL<466>
// WLSEL<467>	WLSEL<467>
// WLSEL<468>	WLSEL<468>
// WLSEL<469>	WLSEL<469>
// WLSEL<470>	WLSEL<470>
// WLSEL<471>	WLSEL<471>
// WLSEL<472>	WLSEL<472>
// WLSEL<473>	WLSEL<473>
// WLSEL<474>	WLSEL<474>
// WLSEL<475>	WLSEL<475>
// WLSEL<476>	WLSEL<476>
// WLSEL<477>	WLSEL<477>
// WLSEL<478>	WLSEL<478>
// WLSEL<479>	WLSEL<479>
// WLSEL<480>	WLSEL<480>
// WLSEL<481>	WLSEL<481>
// WLSEL<482>	WLSEL<482>
// WLSEL<483>	WLSEL<483>
// WLSEL<484>	WLSEL<484>
// WLSEL<485>	WLSEL<485>
// WLSEL<486>	WLSEL<486>
// WLSEL<487>	WLSEL<487>
// WLSEL<488>	WLSEL<488>
// WLSEL<489>	WLSEL<489>
// WLSEL<490>	WLSEL<490>
// WLSEL<491>	WLSEL<491>
// WLSEL<492>	WLSEL<492>
// WLSEL<493>	WLSEL<493>
// WLSEL<494>	WLSEL<494>
// WLSEL<495>	WLSEL<495>
// WLSEL<496>	WLSEL<496>
// WLSEL<497>	WLSEL<497>
// WLSEL<498>	WLSEL<498>
// WLSEL<499>	WLSEL<499>
// WLSEL<500>	WLSEL<500>
// WLSEL<501>	WLSEL<501>
// WLSEL<502>	WLSEL<502>
// WLSEL<503>	WLSEL<503>
// WLSEL<504>	WLSEL<504>
// WLSEL<505>	WLSEL<505>
// WLSEL<506>	WLSEL<506>
// WLSEL<507>	WLSEL<507>
// WLSEL<508>	WLSEL<508>
// WLSEL<509>	WLSEL<509>
// WLSEL<510>	WLSEL<510>
// WLSEL<511>	WLSEL<511>
// SEL3<1>	SEL3<1>
// WLSEL<512>	WLSEL<512>
// WLSEL<513>	WLSEL<513>
// WLSEL<514>	WLSEL<514>
// WLSEL<515>	WLSEL<515>
// WLSEL<516>	WLSEL<516>
// WLSEL<517>	WLSEL<517>
// WLSEL<518>	WLSEL<518>
// WLSEL<519>	WLSEL<519>
// WLSEL<520>	WLSEL<520>
// WLSEL<521>	WLSEL<521>
// WLSEL<522>	WLSEL<522>
// WLSEL<523>	WLSEL<523>
// WLSEL<524>	WLSEL<524>
// WLSEL<525>	WLSEL<525>
// WLSEL<526>	WLSEL<526>
// WLSEL<527>	WLSEL<527>
// WLSEL<528>	WLSEL<528>
// WLSEL<529>	WLSEL<529>
// WLSEL<530>	WLSEL<530>
// WLSEL<531>	WLSEL<531>
// WLSEL<532>	WLSEL<532>
// WLSEL<533>	WLSEL<533>
// WLSEL<534>	WLSEL<534>
// WLSEL<535>	WLSEL<535>
// WLSEL<536>	WLSEL<536>
// WLSEL<537>	WLSEL<537>
// WLSEL<538>	WLSEL<538>
// WLSEL<539>	WLSEL<539>
// WLSEL<540>	WLSEL<540>
// WLSEL<541>	WLSEL<541>
// WLSEL<542>	WLSEL<542>
// WLSEL<543>	WLSEL<543>
// WLSEL<544>	WLSEL<544>
// WLSEL<545>	WLSEL<545>
// WLSEL<546>	WLSEL<546>
// WLSEL<547>	WLSEL<547>
// WLSEL<548>	WLSEL<548>
// WLSEL<549>	WLSEL<549>
// WLSEL<550>	WLSEL<550>
// WLSEL<551>	WLSEL<551>
// WLSEL<552>	WLSEL<552>
// WLSEL<553>	WLSEL<553>
// WLSEL<554>	WLSEL<554>
// WLSEL<555>	WLSEL<555>
// WLSEL<556>	WLSEL<556>
// WLSEL<557>	WLSEL<557>
// WLSEL<558>	WLSEL<558>
// WLSEL<559>	WLSEL<559>
// WLSEL<560>	WLSEL<560>
// WLSEL<561>	WLSEL<561>
// WLSEL<562>	WLSEL<562>
// WLSEL<563>	WLSEL<563>
// WLSEL<564>	WLSEL<564>
// WLSEL<565>	WLSEL<565>
// WLSEL<566>	WLSEL<566>
// WLSEL<567>	WLSEL<567>
// WLSEL<568>	WLSEL<568>
// WLSEL<569>	WLSEL<569>
// WLSEL<570>	WLSEL<570>
// WLSEL<571>	WLSEL<571>
// WLSEL<572>	WLSEL<572>
// WLSEL<573>	WLSEL<573>
// WLSEL<574>	WLSEL<574>
// WLSEL<575>	WLSEL<575>
// WLSEL<576>	WLSEL<576>
// WLSEL<577>	WLSEL<577>
// WLSEL<578>	WLSEL<578>
// WLSEL<579>	WLSEL<579>
// WLSEL<580>	WLSEL<580>
// WLSEL<581>	WLSEL<581>
// WLSEL<582>	WLSEL<582>
// WLSEL<583>	WLSEL<583>
// WLSEL<584>	WLSEL<584>
// WLSEL<585>	WLSEL<585>
// WLSEL<586>	WLSEL<586>
// WLSEL<587>	WLSEL<587>
// WLSEL<588>	WLSEL<588>
// WLSEL<589>	WLSEL<589>
// WLSEL<590>	WLSEL<590>
// WLSEL<591>	WLSEL<591>
// WLSEL<592>	WLSEL<592>
// WLSEL<593>	WLSEL<593>
// WLSEL<594>	WLSEL<594>
// WLSEL<595>	WLSEL<595>
// WLSEL<596>	WLSEL<596>
// WLSEL<597>	WLSEL<597>
// WLSEL<598>	WLSEL<598>
// WLSEL<599>	WLSEL<599>
// WLSEL<600>	WLSEL<600>
// WLSEL<601>	WLSEL<601>
// WLSEL<602>	WLSEL<602>
// WLSEL<603>	WLSEL<603>
// WLSEL<604>	WLSEL<604>
// WLSEL<605>	WLSEL<605>
// WLSEL<606>	WLSEL<606>
// WLSEL<607>	WLSEL<607>
// WLSEL<608>	WLSEL<608>
// WLSEL<609>	WLSEL<609>
// WLSEL<610>	WLSEL<610>
// WLSEL<611>	WLSEL<611>
// WLSEL<612>	WLSEL<612>
// WLSEL<613>	WLSEL<613>
// WLSEL<614>	WLSEL<614>
// WLSEL<615>	WLSEL<615>
// WLSEL<616>	WLSEL<616>
// WLSEL<617>	WLSEL<617>
// WLSEL<618>	WLSEL<618>
// WLSEL<619>	WLSEL<619>
// WLSEL<620>	WLSEL<620>
// WLSEL<621>	WLSEL<621>
// WLSEL<622>	WLSEL<622>
// WLSEL<623>	WLSEL<623>
// WLSEL<624>	WLSEL<624>
// WLSEL<625>	WLSEL<625>
// WLSEL<626>	WLSEL<626>
// WLSEL<627>	WLSEL<627>
// WLSEL<628>	WLSEL<628>
// WLSEL<629>	WLSEL<629>
// WLSEL<630>	WLSEL<630>
// WLSEL<631>	WLSEL<631>
// WLSEL<632>	WLSEL<632>
// WLSEL<633>	WLSEL<633>
// WLSEL<634>	WLSEL<634>
// WLSEL<635>	WLSEL<635>
// WLSEL<636>	WLSEL<636>
// WLSEL<637>	WLSEL<637>
// WLSEL<638>	WLSEL<638>
// WLSEL<639>	WLSEL<639>
// WLSEL<640>	WLSEL<640>
// WLSEL<641>	WLSEL<641>
// WLSEL<642>	WLSEL<642>
// WLSEL<643>	WLSEL<643>
// WLSEL<644>	WLSEL<644>
// WLSEL<645>	WLSEL<645>
// WLSEL<646>	WLSEL<646>
// WLSEL<647>	WLSEL<647>
// WLSEL<648>	WLSEL<648>
// WLSEL<649>	WLSEL<649>
// WLSEL<650>	WLSEL<650>
// WLSEL<651>	WLSEL<651>
// WLSEL<652>	WLSEL<652>
// WLSEL<653>	WLSEL<653>
// WLSEL<654>	WLSEL<654>
// WLSEL<655>	WLSEL<655>
// WLSEL<656>	WLSEL<656>
// WLSEL<657>	WLSEL<657>
// WLSEL<658>	WLSEL<658>
// WLSEL<659>	WLSEL<659>
// WLSEL<660>	WLSEL<660>
// WLSEL<661>	WLSEL<661>
// WLSEL<662>	WLSEL<662>
// WLSEL<663>	WLSEL<663>
// WLSEL<664>	WLSEL<664>
// WLSEL<665>	WLSEL<665>
// WLSEL<666>	WLSEL<666>
// WLSEL<667>	WLSEL<667>
// WLSEL<668>	WLSEL<668>
// WLSEL<669>	WLSEL<669>
// WLSEL<670>	WLSEL<670>
// WLSEL<671>	WLSEL<671>
// WLSEL<672>	WLSEL<672>
// WLSEL<673>	WLSEL<673>
// WLSEL<674>	WLSEL<674>
// WLSEL<675>	WLSEL<675>
// WLSEL<676>	WLSEL<676>
// WLSEL<677>	WLSEL<677>
// WLSEL<678>	WLSEL<678>
// WLSEL<679>	WLSEL<679>
// WLSEL<680>	WLSEL<680>
// WLSEL<681>	WLSEL<681>
// WLSEL<682>	WLSEL<682>
// WLSEL<683>	WLSEL<683>
// WLSEL<684>	WLSEL<684>
// WLSEL<685>	WLSEL<685>
// WLSEL<686>	WLSEL<686>
// WLSEL<687>	WLSEL<687>
// WLSEL<688>	WLSEL<688>
// WLSEL<689>	WLSEL<689>
// WLSEL<690>	WLSEL<690>
// WLSEL<691>	WLSEL<691>
// WLSEL<692>	WLSEL<692>
// WLSEL<693>	WLSEL<693>
// WLSEL<694>	WLSEL<694>
// WLSEL<695>	WLSEL<695>
// WLSEL<696>	WLSEL<696>
// WLSEL<697>	WLSEL<697>
// WLSEL<698>	WLSEL<698>
// WLSEL<699>	WLSEL<699>
// WLSEL<700>	WLSEL<700>
// WLSEL<701>	WLSEL<701>
// WLSEL<702>	WLSEL<702>
// WLSEL<703>	WLSEL<703>
// WLSEL<704>	WLSEL<704>
// WLSEL<705>	WLSEL<705>
// WLSEL<706>	WLSEL<706>
// WLSEL<707>	WLSEL<707>
// WLSEL<708>	WLSEL<708>
// WLSEL<709>	WLSEL<709>
// WLSEL<710>	WLSEL<710>
// WLSEL<711>	WLSEL<711>
// WLSEL<712>	WLSEL<712>
// WLSEL<713>	WLSEL<713>
// WLSEL<714>	WLSEL<714>
// WLSEL<715>	WLSEL<715>
// WLSEL<716>	WLSEL<716>
// WLSEL<717>	WLSEL<717>
// WLSEL<718>	WLSEL<718>
// WLSEL<719>	WLSEL<719>
// WLSEL<720>	WLSEL<720>
// WLSEL<721>	WLSEL<721>
// WLSEL<722>	WLSEL<722>
// WLSEL<723>	WLSEL<723>
// WLSEL<724>	WLSEL<724>
// WLSEL<725>	WLSEL<725>
// WLSEL<726>	WLSEL<726>
// WLSEL<727>	WLSEL<727>
// WLSEL<728>	WLSEL<728>
// WLSEL<729>	WLSEL<729>
// WLSEL<730>	WLSEL<730>
// WLSEL<731>	WLSEL<731>
// WLSEL<732>	WLSEL<732>
// WLSEL<733>	WLSEL<733>
// WLSEL<734>	WLSEL<734>
// WLSEL<735>	WLSEL<735>
// WLSEL<736>	WLSEL<736>
// WLSEL<737>	WLSEL<737>
// WLSEL<738>	WLSEL<738>
// WLSEL<739>	WLSEL<739>
// WLSEL<740>	WLSEL<740>
// WLSEL<741>	WLSEL<741>
// WLSEL<742>	WLSEL<742>
// WLSEL<743>	WLSEL<743>
// WLSEL<744>	WLSEL<744>
// WLSEL<745>	WLSEL<745>
// WLSEL<746>	WLSEL<746>
// WLSEL<747>	WLSEL<747>
// WLSEL<748>	WLSEL<748>
// WLSEL<749>	WLSEL<749>
// WLSEL<750>	WLSEL<750>
// WLSEL<751>	WLSEL<751>
// WLSEL<752>	WLSEL<752>
// WLSEL<753>	WLSEL<753>
// WLSEL<754>	WLSEL<754>
// WLSEL<755>	WLSEL<755>
// WLSEL<756>	WLSEL<756>
// WLSEL<757>	WLSEL<757>
// WLSEL<758>	WLSEL<758>
// WLSEL<759>	WLSEL<759>
// WLSEL<760>	WLSEL<760>
// WLSEL<761>	WLSEL<761>
// WLSEL<762>	WLSEL<762>
// WLSEL<763>	WLSEL<763>
// WLSEL<764>	WLSEL<764>
// WLSEL<765>	WLSEL<765>
// WLSEL<766>	WLSEL<766>
// WLSEL<767>	WLSEL<767>
// SEL3<2>	SEL3<2>
// WLSEL<768>	WLSEL<768>
// WLSEL<769>	WLSEL<769>
// WLSEL<770>	WLSEL<770>
// WLSEL<771>	WLSEL<771>
// WLSEL<772>	WLSEL<772>
// WLSEL<773>	WLSEL<773>
// WLSEL<774>	WLSEL<774>
// WLSEL<775>	WLSEL<775>
// WLSEL<776>	WLSEL<776>
// WLSEL<777>	WLSEL<777>
// WLSEL<778>	WLSEL<778>
// WLSEL<779>	WLSEL<779>
// WLSEL<780>	WLSEL<780>
// WLSEL<781>	WLSEL<781>
// WLSEL<782>	WLSEL<782>
// WLSEL<783>	WLSEL<783>
// WLSEL<784>	WLSEL<784>
// WLSEL<785>	WLSEL<785>
// WLSEL<786>	WLSEL<786>
// WLSEL<787>	WLSEL<787>
// WLSEL<788>	WLSEL<788>
// WLSEL<789>	WLSEL<789>
// WLSEL<790>	WLSEL<790>
// WLSEL<791>	WLSEL<791>
// WLSEL<792>	WLSEL<792>
// WLSEL<793>	WLSEL<793>
// WLSEL<794>	WLSEL<794>
// WLSEL<795>	WLSEL<795>
// WLSEL<796>	WLSEL<796>
// WLSEL<797>	WLSEL<797>
// WLSEL<798>	WLSEL<798>
// WLSEL<799>	WLSEL<799>
// WLSEL<800>	WLSEL<800>
// WLSEL<801>	WLSEL<801>
// WLSEL<802>	WLSEL<802>
// WLSEL<803>	WLSEL<803>
// WLSEL<804>	WLSEL<804>
// WLSEL<805>	WLSEL<805>
// WLSEL<806>	WLSEL<806>
// WLSEL<807>	WLSEL<807>
// WLSEL<808>	WLSEL<808>
// WLSEL<809>	WLSEL<809>
// WLSEL<810>	WLSEL<810>
// WLSEL<811>	WLSEL<811>
// WLSEL<812>	WLSEL<812>
// WLSEL<813>	WLSEL<813>
// WLSEL<814>	WLSEL<814>
// WLSEL<815>	WLSEL<815>
// WLSEL<816>	WLSEL<816>
// WLSEL<817>	WLSEL<817>
// WLSEL<818>	WLSEL<818>
// WLSEL<819>	WLSEL<819>
// WLSEL<820>	WLSEL<820>
// WLSEL<821>	WLSEL<821>
// WLSEL<822>	WLSEL<822>
// WLSEL<823>	WLSEL<823>
// WLSEL<824>	WLSEL<824>
// WLSEL<825>	WLSEL<825>
// WLSEL<826>	WLSEL<826>
// WLSEL<827>	WLSEL<827>
// WLSEL<828>	WLSEL<828>
// WLSEL<829>	WLSEL<829>
// WLSEL<830>	WLSEL<830>
// SEL2<0>	SEL2<0>
// WLSEL<831>	WLSEL<831>
// WLSEL<832>	WLSEL<832>
// WLSEL<833>	WLSEL<833>
// WLSEL<834>	WLSEL<834>
// WLSEL<835>	WLSEL<835>
// WLSEL<836>	WLSEL<836>
// WLSEL<837>	WLSEL<837>
// WLSEL<838>	WLSEL<838>
// WLSEL<839>	WLSEL<839>
// WLSEL<840>	WLSEL<840>
// WLSEL<841>	WLSEL<841>
// WLSEL<842>	WLSEL<842>
// WLSEL<843>	WLSEL<843>
// WLSEL<844>	WLSEL<844>
// WLSEL<845>	WLSEL<845>
// WLSEL<846>	WLSEL<846>
// WLSEL<847>	WLSEL<847>
// WLSEL<848>	WLSEL<848>
// WLSEL<849>	WLSEL<849>
// WLSEL<850>	WLSEL<850>
// WLSEL<851>	WLSEL<851>
// WLSEL<852>	WLSEL<852>
// WLSEL<853>	WLSEL<853>
// WLSEL<854>	WLSEL<854>
// WLSEL<855>	WLSEL<855>
// WLSEL<856>	WLSEL<856>
// WLSEL<857>	WLSEL<857>
// WLSEL<858>	WLSEL<858>
// WLSEL<859>	WLSEL<859>
// WLSEL<860>	WLSEL<860>
// WLSEL<861>	WLSEL<861>
// WLSEL<862>	WLSEL<862>
// WLSEL<863>	WLSEL<863>
// WLSEL<864>	WLSEL<864>
// WLSEL<865>	WLSEL<865>
// WLSEL<866>	WLSEL<866>
// WLSEL<867>	WLSEL<867>
// WLSEL<868>	WLSEL<868>
// WLSEL<869>	WLSEL<869>
// WLSEL<870>	WLSEL<870>
// WLSEL<871>	WLSEL<871>
// WLSEL<872>	WLSEL<872>
// WLSEL<873>	WLSEL<873>
// WLSEL<874>	WLSEL<874>
// WLSEL<875>	WLSEL<875>
// WLSEL<876>	WLSEL<876>
// WLSEL<877>	WLSEL<877>
// WLSEL<878>	WLSEL<878>
// WLSEL<879>	WLSEL<879>
// WLSEL<880>	WLSEL<880>
// WLSEL<881>	WLSEL<881>
// WLSEL<882>	WLSEL<882>
// WLSEL<883>	WLSEL<883>
// WLSEL<884>	WLSEL<884>
// WLSEL<885>	WLSEL<885>
// WLSEL<886>	WLSEL<886>
// WLSEL<887>	WLSEL<887>
// WLSEL<888>	WLSEL<888>
// WLSEL<889>	WLSEL<889>
// WLSEL<890>	WLSEL<890>
// WLSEL<891>	WLSEL<891>
// WLSEL<892>	WLSEL<892>
// WLSEL<893>	WLSEL<893>
// WLSEL<894>	WLSEL<894>
// SEL2<1>	SEL2<1>
// WLSEL<895>	WLSEL<895>
// WLSEL<896>	WLSEL<896>
// WLSEL<897>	WLSEL<897>
// WLSEL<898>	WLSEL<898>
// WLSEL<899>	WLSEL<899>
// WLSEL<900>	WLSEL<900>
// WLSEL<901>	WLSEL<901>
// WLSEL<902>	WLSEL<902>
// WLSEL<903>	WLSEL<903>
// WLSEL<904>	WLSEL<904>
// WLSEL<905>	WLSEL<905>
// WLSEL<906>	WLSEL<906>
// WLSEL<907>	WLSEL<907>
// WLSEL<908>	WLSEL<908>
// WLSEL<909>	WLSEL<909>
// WLSEL<910>	WLSEL<910>
// WLSEL<911>	WLSEL<911>
// WLSEL<912>	WLSEL<912>
// WLSEL<913>	WLSEL<913>
// WLSEL<914>	WLSEL<914>
// WLSEL<915>	WLSEL<915>
// WLSEL<916>	WLSEL<916>
// WLSEL<917>	WLSEL<917>
// WLSEL<918>	WLSEL<918>
// WLSEL<919>	WLSEL<919>
// WLSEL<920>	WLSEL<920>
// WLSEL<921>	WLSEL<921>
// WLSEL<922>	WLSEL<922>
// WLSEL<923>	WLSEL<923>
// WLSEL<924>	WLSEL<924>
// WLSEL<925>	WLSEL<925>
// WLSEL<926>	WLSEL<926>
// WLSEL<927>	WLSEL<927>
// WLSEL<928>	WLSEL<928>
// WLSEL<929>	WLSEL<929>
// WLSEL<930>	WLSEL<930>
// WLSEL<931>	WLSEL<931>
// WLSEL<932>	WLSEL<932>
// WLSEL<933>	WLSEL<933>
// WLSEL<934>	WLSEL<934>
// WLSEL<935>	WLSEL<935>
// WLSEL<936>	WLSEL<936>
// WLSEL<937>	WLSEL<937>
// WLSEL<938>	WLSEL<938>
// WLSEL<939>	WLSEL<939>
// WLSEL<940>	WLSEL<940>
// WLSEL<941>	WLSEL<941>
// WLSEL<942>	WLSEL<942>
// WLSEL<943>	WLSEL<943>
// WLSEL<944>	WLSEL<944>
// WLSEL<945>	WLSEL<945>
// WLSEL<946>	WLSEL<946>
// WLSEL<947>	WLSEL<947>
// WLSEL<948>	WLSEL<948>
// WLSEL<949>	WLSEL<949>
// WLSEL<950>	WLSEL<950>
// WLSEL<951>	WLSEL<951>
// WLSEL<952>	WLSEL<952>
// WLSEL<953>	WLSEL<953>
// WLSEL<954>	WLSEL<954>
// WLSEL<955>	WLSEL<955>
// WLSEL<956>	WLSEL<956>
// WLSEL<957>	WLSEL<957>
// WLSEL<958>	WLSEL<958>
// SEL2<2>	SEL2<2>
// WLSEL<959>	WLSEL<959>
// WLSEL<960>	WLSEL<960>
// WLSEL<961>	WLSEL<961>
// WLSEL<962>	WLSEL<962>
// WLSEL<963>	WLSEL<963>
// WLSEL<964>	WLSEL<964>
// WLSEL<965>	WLSEL<965>
// WLSEL<966>	WLSEL<966>
// WLSEL<967>	WLSEL<967>
// WLSEL<968>	WLSEL<968>
// WLSEL<969>	WLSEL<969>
// WLSEL<970>	WLSEL<970>
// WLSEL<971>	WLSEL<971>
// WLSEL<972>	WLSEL<972>
// WLSEL<973>	WLSEL<973>
// SEL1<0>	SEL1<0>
// WLSEL<974>	WLSEL<974>
// WLSEL<975>	WLSEL<975>
// WLSEL<976>	WLSEL<976>
// WLSEL<977>	WLSEL<977>
// WLSEL<978>	WLSEL<978>
// WLSEL<979>	WLSEL<979>
// WLSEL<980>	WLSEL<980>
// WLSEL<981>	WLSEL<981>
// WLSEL<982>	WLSEL<982>
// WLSEL<983>	WLSEL<983>
// WLSEL<984>	WLSEL<984>
// WLSEL<985>	WLSEL<985>
// WLSEL<986>	WLSEL<986>
// WLSEL<987>	WLSEL<987>
// WLSEL<988>	WLSEL<988>
// WLSEL<989>	WLSEL<989>
// SEL1<1>	SEL1<1>
// WLSEL<990>	WLSEL<990>
// WLSEL<991>	WLSEL<991>
// WLSEL<992>	WLSEL<992>
// WLSEL<993>	WLSEL<993>
// WLSEL<994>	WLSEL<994>
// WLSEL<995>	WLSEL<995>
// WLSEL<996>	WLSEL<996>
// WLSEL<997>	WLSEL<997>
// WLSEL<998>	WLSEL<998>
// WLSEL<999>	WLSEL<999>
// WLSEL<1000>	WLSEL<1000>
// WLSEL<1001>	WLSEL<1001>
// WLSEL<1002>	WLSEL<1002>
// WLSEL<1003>	WLSEL<1003>
// WLSEL<1004>	WLSEL<1004>
// WLSEL<1005>	WLSEL<1005>
// SEL1<2>	SEL1<2>
// WLSEL<1006>	WLSEL<1006>
// WLSEL<1007>	WLSEL<1007>
// WLSEL<1008>	WLSEL<1008>
// SEL0<0>	SEL0<0>
// WLSEL<1009>	WLSEL<1009>
// WLSEL<1010>	WLSEL<1010>
// WLSEL<1011>	WLSEL<1011>
// WLSEL<1012>	WLSEL<1012>
// SEL0<1>	SEL0<1>
// WLSEL<1013>	WLSEL<1013>
// WLSEL<1014>	WLSEL<1014>
// WLSEL<1015>	WLSEL<1015>
// WLSEL<1016>	WLSEL<1016>
// SEL0<2>	SEL0<2>
// WLSEL<1017>	WLSEL<1017>
// WLSEL<1018>	WLSEL<1018>
// WLSEL<1019>	WLSEL<1019>
// WLSEL<1020>	WLSEL<1020>
// SEL0<3>	SEL0<3>
// WLSEL<1021>	WLSEL<1021>
// SEL1<3>	SEL1<3>
// WLSEL<1022>	WLSEL<1022>
// SEL2<3>	SEL2<3>
// WLSEL<1023>	WLSEL<1023>
// SEL3<3>	SEL3<3>
XXI2\<3\>\/XI2\<3\>\/XI2\<3\>\/XI2\<3\>\/RR2 (  \
 N_SEL3\<3\>_XI2\<3\>\/XI2\<3\>\/XI2\<3\>\/XI2\<3\>\/RR2_pos WLSEL\<1023\> ) \
 R_1X_LL w=1e-07 l=1e-07   res=0.149966
XXI2\<3\>\/XI2\<3\>\/XI2\<3\>\/XI2\<3\>\/RR1 (  \
 N_SEL2\<3\>_XI2\<3\>\/XI2\<3\>\/XI2\<3\>\/XI2\<3\>\/RR1_pos WLSEL\<1022\> ) \
 R_1X_LL w=1e-07 l=1e-07   res=0.149966
XXI2\<3\>\/XI2\<3\>\/XI2\<3\>\/XI2\<3\>\/RR0 (  \
 N_SEL1\<3\>_XI2\<3\>\/XI2\<3\>\/XI2\<3\>\/XI2\<3\>\/RR0_pos WLSEL\<1021\> ) \
 R_1X_LL w=1e-07 l=1e-07   res=0.149966
XXI2\<3\>\/XI2\<3\>\/XI2\<3\>\/XI2\<3\>\/RI2 (  \
 N_SEL0\<3\>_XI2\<3\>\/XI2\<3\>\/XI2\<3\>\/XI2\<3\>\/RI2_pos WLSEL\<1020\> ) \
 R_1X_LL w=1e-07 l=1e-07   res=0.149966
XXI2\<3\>\/XI2\<3\>\/XI2\<3\>\/XI2\<2\>\/RR2 (  \
 N_SEL3\<3\>_XI2\<3\>\/XI2\<3\>\/XI2\<3\>\/XI2\<2\>\/RR2_pos WLSEL\<1019\> ) \
 R_1X_LL w=1e-07 l=1e-07   res=0.149966
XXI2\<3\>\/XI2\<3\>\/XI2\<3\>\/XI2\<2\>\/RR1 (  \
 N_SEL2\<3\>_XI2\<3\>\/XI2\<3\>\/XI2\<3\>\/XI2\<2\>\/RR1_pos WLSEL\<1018\> ) \
 R_1X_LL w=1e-07 l=1e-07   res=0.149966
XXI2\<3\>\/XI2\<3\>\/XI2\<3\>\/XI2\<2\>\/RR0 (  \
 N_SEL1\<3\>_XI2\<3\>\/XI2\<3\>\/XI2\<3\>\/XI2\<2\>\/RR0_pos WLSEL\<1017\> ) \
 R_1X_LL w=1e-07 l=1e-07   res=0.149966
XXI2\<3\>\/XI2\<3\>\/XI2\<3\>\/XI2\<2\>\/RI2 (  \
 N_SEL0\<2\>_XI2\<3\>\/XI2\<3\>\/XI2\<3\>\/XI2\<2\>\/RI2_pos WLSEL\<1016\> ) \
 R_1X_LL w=1e-07 l=1e-07   res=0.149966
XXI2\<3\>\/XI2\<3\>\/XI2\<3\>\/XI2\<1\>\/RR2 (  \
 N_SEL3\<3\>_XI2\<3\>\/XI2\<3\>\/XI2\<3\>\/XI2\<1\>\/RR2_pos WLSEL\<1015\> ) \
 R_1X_LL w=1e-07 l=1e-07   res=0.149966
XXI2\<3\>\/XI2\<3\>\/XI2\<3\>\/XI2\<1\>\/RR1 (  \
 N_SEL2\<3\>_XI2\<3\>\/XI2\<3\>\/XI2\<3\>\/XI2\<1\>\/RR1_pos WLSEL\<1014\> ) \
 R_1X_LL w=1e-07 l=1e-07   res=0.149966
XXI2\<3\>\/XI2\<3\>\/XI2\<3\>\/XI2\<1\>\/RR0 (  \
 N_SEL1\<3\>_XI2\<3\>\/XI2\<3\>\/XI2\<3\>\/XI2\<1\>\/RR0_pos WLSEL\<1013\> ) \
 R_1X_LL w=1e-07 l=1e-07   res=0.149966
XXI2\<3\>\/XI2\<3\>\/XI2\<3\>\/XI2\<1\>\/RI2 (  \
 N_SEL0\<1\>_XI2\<3\>\/XI2\<3\>\/XI2\<3\>\/XI2\<1\>\/RI2_pos WLSEL\<1012\> ) \
 R_1X_LL w=1e-07 l=1e-07   res=0.149966
XXI2\<3\>\/XI2\<3\>\/XI2\<3\>\/XI2\<0\>\/RR2 (  \
 N_SEL3\<3\>_XI2\<3\>\/XI2\<3\>\/XI2\<3\>\/XI2\<0\>\/RR2_pos WLSEL\<1011\> ) \
 R_1X_LL w=1e-07 l=1e-07   res=0.149966
XXI2\<3\>\/XI2\<3\>\/XI2\<3\>\/XI2\<0\>\/RR1 (  \
 N_SEL2\<3\>_XI2\<3\>\/XI2\<3\>\/XI2\<3\>\/XI2\<0\>\/RR1_pos WLSEL\<1010\> ) \
 R_1X_LL w=1e-07 l=1e-07   res=0.149966
XXI2\<3\>\/XI2\<3\>\/XI2\<3\>\/XI2\<0\>\/RR0 (  \
 N_SEL1\<3\>_XI2\<3\>\/XI2\<3\>\/XI2\<3\>\/XI2\<0\>\/RR0_pos WLSEL\<1009\> ) \
 R_1X_LL w=1e-07 l=1e-07   res=0.149966
XXI2\<3\>\/XI2\<3\>\/XI2\<3\>\/XI2\<0\>\/RI2 (  \
 N_SEL0\<0\>_XI2\<3\>\/XI2\<3\>\/XI2\<3\>\/XI2\<0\>\/RI2_pos WLSEL\<1008\> ) \
 R_1X_LL w=1e-07 l=1e-07   res=0.149966
XXI2\<3\>\/XI2\<3\>\/XI2\<2\>\/XI2\<3\>\/RR2 (  \
 N_SEL3\<3\>_XI2\<3\>\/XI2\<3\>\/XI2\<2\>\/XI2\<3\>\/RR2_pos WLSEL\<1007\> ) \
 R_1X_LL w=1e-07 l=1e-07   res=0.149966
XXI2\<3\>\/XI2\<3\>\/XI2\<2\>\/XI2\<3\>\/RR1 (  \
 N_SEL2\<3\>_XI2\<3\>\/XI2\<3\>\/XI2\<2\>\/XI2\<3\>\/RR1_pos WLSEL\<1006\> ) \
 R_1X_LL w=1e-07 l=1e-07   res=0.149966
XXI2\<3\>\/XI2\<3\>\/XI2\<2\>\/XI2\<3\>\/RR0 (  \
 N_SEL1\<2\>_XI2\<3\>\/XI2\<3\>\/XI2\<2\>\/XI2\<3\>\/RR0_pos WLSEL\<1005\> ) \
 R_1X_LL w=1e-07 l=1e-07   res=0.149966
XXI2\<3\>\/XI2\<3\>\/XI2\<2\>\/XI2\<3\>\/RI2 (  \
 N_SEL0\<3\>_XI2\<3\>\/XI2\<3\>\/XI2\<2\>\/XI2\<3\>\/RI2_pos WLSEL\<1004\> ) \
 R_1X_LL w=1e-07 l=1e-07   res=0.149966
XXI2\<3\>\/XI2\<3\>\/XI2\<2\>\/XI2\<2\>\/RR2 (  \
 N_SEL3\<3\>_XI2\<3\>\/XI2\<3\>\/XI2\<2\>\/XI2\<2\>\/RR2_pos WLSEL\<1003\> ) \
 R_1X_LL w=1e-07 l=1e-07   res=0.149966
XXI2\<3\>\/XI2\<3\>\/XI2\<2\>\/XI2\<2\>\/RR1 (  \
 N_SEL2\<3\>_XI2\<3\>\/XI2\<3\>\/XI2\<2\>\/XI2\<2\>\/RR1_pos WLSEL\<1002\> ) \
 R_1X_LL w=1e-07 l=1e-07   res=0.149966
XXI2\<3\>\/XI2\<3\>\/XI2\<2\>\/XI2\<2\>\/RR0 (  \
 N_SEL1\<2\>_XI2\<3\>\/XI2\<3\>\/XI2\<2\>\/XI2\<2\>\/RR0_pos WLSEL\<1001\> ) \
 R_1X_LL w=1e-07 l=1e-07   res=0.149966
XXI2\<3\>\/XI2\<3\>\/XI2\<2\>\/XI2\<2\>\/RI2 (  \
 N_SEL0\<2\>_XI2\<3\>\/XI2\<3\>\/XI2\<2\>\/XI2\<2\>\/RI2_pos WLSEL\<1000\> ) \
 R_1X_LL w=1e-07 l=1e-07   res=0.149966
XXI2\<3\>\/XI2\<3\>\/XI2\<2\>\/XI2\<1\>\/RR2 (  \
 N_SEL3\<3\>_XI2\<3\>\/XI2\<3\>\/XI2\<2\>\/XI2\<1\>\/RR2_pos WLSEL\<999\> ) \
 R_1X_LL w=1e-07 l=1e-07   res=0.149966
XXI2\<3\>\/XI2\<3\>\/XI2\<2\>\/XI2\<1\>\/RR1 (  \
 N_SEL2\<3\>_XI2\<3\>\/XI2\<3\>\/XI2\<2\>\/XI2\<1\>\/RR1_pos WLSEL\<998\> ) \
 R_1X_LL w=1e-07 l=1e-07   res=0.149966
XXI2\<3\>\/XI2\<3\>\/XI2\<2\>\/XI2\<1\>\/RR0 (  \
 N_SEL1\<2\>_XI2\<3\>\/XI2\<3\>\/XI2\<2\>\/XI2\<1\>\/RR0_pos WLSEL\<997\> ) \
 R_1X_LL w=1e-07 l=1e-07   res=0.149966
XXI2\<3\>\/XI2\<3\>\/XI2\<2\>\/XI2\<1\>\/RI2 (  \
 N_SEL0\<1\>_XI2\<3\>\/XI2\<3\>\/XI2\<2\>\/XI2\<1\>\/RI2_pos WLSEL\<996\> ) \
 R_1X_LL w=1e-07 l=1e-07   res=0.149966
XXI2\<3\>\/XI2\<3\>\/XI2\<2\>\/XI2\<0\>\/RR2 (  \
 N_SEL3\<3\>_XI2\<3\>\/XI2\<3\>\/XI2\<2\>\/XI2\<0\>\/RR2_pos WLSEL\<995\> ) \
 R_1X_LL w=1e-07 l=1e-07   res=0.149966
XXI2\<3\>\/XI2\<3\>\/XI2\<2\>\/XI2\<0\>\/RR1 (  \
 N_SEL2\<3\>_XI2\<3\>\/XI2\<3\>\/XI2\<2\>\/XI2\<0\>\/RR1_pos WLSEL\<994\> ) \
 R_1X_LL w=1e-07 l=1e-07   res=0.149966
XXI2\<3\>\/XI2\<3\>\/XI2\<2\>\/XI2\<0\>\/RR0 (  \
 N_SEL1\<2\>_XI2\<3\>\/XI2\<3\>\/XI2\<2\>\/XI2\<0\>\/RR0_pos WLSEL\<993\> ) \
 R_1X_LL w=1e-07 l=1e-07   res=0.149966
XXI2\<3\>\/XI2\<3\>\/XI2\<2\>\/XI2\<0\>\/RI2 (  \
 N_SEL0\<0\>_XI2\<3\>\/XI2\<3\>\/XI2\<2\>\/XI2\<0\>\/RI2_pos WLSEL\<992\> ) \
 R_1X_LL w=1e-07 l=1e-07   res=0.149966
XXI2\<3\>\/XI2\<3\>\/XI2\<1\>\/XI2\<3\>\/RR2 (  \
 N_SEL3\<3\>_XI2\<3\>\/XI2\<3\>\/XI2\<1\>\/XI2\<3\>\/RR2_pos WLSEL\<991\> ) \
 R_1X_LL w=1e-07 l=1e-07   res=0.149966
XXI2\<3\>\/XI2\<3\>\/XI2\<1\>\/XI2\<3\>\/RR1 (  \
 N_SEL2\<3\>_XI2\<3\>\/XI2\<3\>\/XI2\<1\>\/XI2\<3\>\/RR1_pos WLSEL\<990\> ) \
 R_1X_LL w=1e-07 l=1e-07   res=0.149966
XXI2\<3\>\/XI2\<3\>\/XI2\<1\>\/XI2\<3\>\/RR0 (  \
 N_SEL1\<1\>_XI2\<3\>\/XI2\<3\>\/XI2\<1\>\/XI2\<3\>\/RR0_pos WLSEL\<989\> ) \
 R_1X_LL w=1e-07 l=1e-07   res=0.149966
XXI2\<3\>\/XI2\<3\>\/XI2\<1\>\/XI2\<3\>\/RI2 (  \
 N_SEL0\<3\>_XI2\<3\>\/XI2\<3\>\/XI2\<1\>\/XI2\<3\>\/RI2_pos WLSEL\<988\> ) \
 R_1X_LL w=1e-07 l=1e-07   res=0.149966
XXI2\<3\>\/XI2\<3\>\/XI2\<1\>\/XI2\<2\>\/RR2 (  \
 N_SEL3\<3\>_XI2\<3\>\/XI2\<3\>\/XI2\<1\>\/XI2\<2\>\/RR2_pos WLSEL\<987\> ) \
 R_1X_LL w=1e-07 l=1e-07   res=0.149966
XXI2\<3\>\/XI2\<3\>\/XI2\<1\>\/XI2\<2\>\/RR1 (  \
 N_SEL2\<3\>_XI2\<3\>\/XI2\<3\>\/XI2\<1\>\/XI2\<2\>\/RR1_pos WLSEL\<986\> ) \
 R_1X_LL w=1e-07 l=1e-07   res=0.149966
XXI2\<3\>\/XI2\<3\>\/XI2\<1\>\/XI2\<2\>\/RR0 (  \
 N_SEL1\<1\>_XI2\<3\>\/XI2\<3\>\/XI2\<1\>\/XI2\<2\>\/RR0_pos WLSEL\<985\> ) \
 R_1X_LL w=1e-07 l=1e-07   res=0.149966
XXI2\<3\>\/XI2\<3\>\/XI2\<1\>\/XI2\<2\>\/RI2 (  \
 N_SEL0\<2\>_XI2\<3\>\/XI2\<3\>\/XI2\<1\>\/XI2\<2\>\/RI2_pos WLSEL\<984\> ) \
 R_1X_LL w=1e-07 l=1e-07   res=0.149966
XXI2\<3\>\/XI2\<3\>\/XI2\<1\>\/XI2\<1\>\/RR2 (  \
 N_SEL3\<3\>_XI2\<3\>\/XI2\<3\>\/XI2\<1\>\/XI2\<1\>\/RR2_pos WLSEL\<983\> ) \
 R_1X_LL w=1e-07 l=1e-07   res=0.149966
XXI2\<3\>\/XI2\<3\>\/XI2\<1\>\/XI2\<1\>\/RR1 (  \
 N_SEL2\<3\>_XI2\<3\>\/XI2\<3\>\/XI2\<1\>\/XI2\<1\>\/RR1_pos WLSEL\<982\> ) \
 R_1X_LL w=1e-07 l=1e-07   res=0.149966
XXI2\<3\>\/XI2\<3\>\/XI2\<1\>\/XI2\<1\>\/RR0 (  \
 N_SEL1\<1\>_XI2\<3\>\/XI2\<3\>\/XI2\<1\>\/XI2\<1\>\/RR0_pos WLSEL\<981\> ) \
 R_1X_LL w=1e-07 l=1e-07   res=0.149966
XXI2\<3\>\/XI2\<3\>\/XI2\<1\>\/XI2\<1\>\/RI2 (  \
 N_SEL0\<1\>_XI2\<3\>\/XI2\<3\>\/XI2\<1\>\/XI2\<1\>\/RI2_pos WLSEL\<980\> ) \
 R_1X_LL w=1e-07 l=1e-07   res=0.149966
XXI2\<3\>\/XI2\<3\>\/XI2\<1\>\/XI2\<0\>\/RR2 (  \
 N_SEL3\<3\>_XI2\<3\>\/XI2\<3\>\/XI2\<1\>\/XI2\<0\>\/RR2_pos WLSEL\<979\> ) \
 R_1X_LL w=1e-07 l=1e-07   res=0.149966
XXI2\<3\>\/XI2\<3\>\/XI2\<1\>\/XI2\<0\>\/RR1 (  \
 N_SEL2\<3\>_XI2\<3\>\/XI2\<3\>\/XI2\<1\>\/XI2\<0\>\/RR1_pos WLSEL\<978\> ) \
 R_1X_LL w=1e-07 l=1e-07   res=0.149966
XXI2\<3\>\/XI2\<3\>\/XI2\<1\>\/XI2\<0\>\/RR0 (  \
 N_SEL1\<1\>_XI2\<3\>\/XI2\<3\>\/XI2\<1\>\/XI2\<0\>\/RR0_pos WLSEL\<977\> ) \
 R_1X_LL w=1e-07 l=1e-07   res=0.149966
XXI2\<3\>\/XI2\<3\>\/XI2\<1\>\/XI2\<0\>\/RI2 (  \
 N_SEL0\<0\>_XI2\<3\>\/XI2\<3\>\/XI2\<1\>\/XI2\<0\>\/RI2_pos WLSEL\<976\> ) \
 R_1X_LL w=1e-07 l=1e-07   res=0.149966
XXI2\<3\>\/XI2\<3\>\/XI2\<0\>\/XI2\<3\>\/RR2 (  \
 N_SEL3\<3\>_XI2\<3\>\/XI2\<3\>\/XI2\<0\>\/XI2\<3\>\/RR2_pos WLSEL\<975\> ) \
 R_1X_LL w=1e-07 l=1e-07   res=0.149966
XXI2\<3\>\/XI2\<3\>\/XI2\<0\>\/XI2\<3\>\/RR1 (  \
 N_SEL2\<3\>_XI2\<3\>\/XI2\<3\>\/XI2\<0\>\/XI2\<3\>\/RR1_pos WLSEL\<974\> ) \
 R_1X_LL w=1e-07 l=1e-07   res=0.149966
XXI2\<3\>\/XI2\<3\>\/XI2\<0\>\/XI2\<3\>\/RR0 (  \
 N_SEL1\<0\>_XI2\<3\>\/XI2\<3\>\/XI2\<0\>\/XI2\<3\>\/RR0_pos WLSEL\<973\> ) \
 R_1X_LL w=1e-07 l=1e-07   res=0.149966
XXI2\<3\>\/XI2\<3\>\/XI2\<0\>\/XI2\<3\>\/RI2 (  \
 N_SEL0\<3\>_XI2\<3\>\/XI2\<3\>\/XI2\<0\>\/XI2\<3\>\/RI2_pos WLSEL\<972\> ) \
 R_1X_LL w=1e-07 l=1e-07   res=0.149966
XXI2\<3\>\/XI2\<3\>\/XI2\<0\>\/XI2\<2\>\/RR2 (  \
 N_SEL3\<3\>_XI2\<3\>\/XI2\<3\>\/XI2\<0\>\/XI2\<2\>\/RR2_pos WLSEL\<971\> ) \
 R_1X_LL w=1e-07 l=1e-07   res=0.149966
XXI2\<3\>\/XI2\<3\>\/XI2\<0\>\/XI2\<2\>\/RR1 (  \
 N_SEL2\<3\>_XI2\<3\>\/XI2\<3\>\/XI2\<0\>\/XI2\<2\>\/RR1_pos WLSEL\<970\> ) \
 R_1X_LL w=1e-07 l=1e-07   res=0.149966
XXI2\<3\>\/XI2\<3\>\/XI2\<0\>\/XI2\<2\>\/RR0 (  \
 N_SEL1\<0\>_XI2\<3\>\/XI2\<3\>\/XI2\<0\>\/XI2\<2\>\/RR0_pos WLSEL\<969\> ) \
 R_1X_LL w=1e-07 l=1e-07   res=0.149966
XXI2\<3\>\/XI2\<3\>\/XI2\<0\>\/XI2\<2\>\/RI2 (  \
 N_SEL0\<2\>_XI2\<3\>\/XI2\<3\>\/XI2\<0\>\/XI2\<2\>\/RI2_pos WLSEL\<968\> ) \
 R_1X_LL w=1e-07 l=1e-07   res=0.149966
XXI2\<3\>\/XI2\<3\>\/XI2\<0\>\/XI2\<1\>\/RR2 (  \
 N_SEL3\<3\>_XI2\<3\>\/XI2\<3\>\/XI2\<0\>\/XI2\<1\>\/RR2_pos WLSEL\<967\> ) \
 R_1X_LL w=1e-07 l=1e-07   res=0.149966
XXI2\<3\>\/XI2\<3\>\/XI2\<0\>\/XI2\<1\>\/RR1 (  \
 N_SEL2\<3\>_XI2\<3\>\/XI2\<3\>\/XI2\<0\>\/XI2\<1\>\/RR1_pos WLSEL\<966\> ) \
 R_1X_LL w=1e-07 l=1e-07   res=0.149966
XXI2\<3\>\/XI2\<3\>\/XI2\<0\>\/XI2\<1\>\/RR0 (  \
 N_SEL1\<0\>_XI2\<3\>\/XI2\<3\>\/XI2\<0\>\/XI2\<1\>\/RR0_pos WLSEL\<965\> ) \
 R_1X_LL w=1e-07 l=1e-07   res=0.149966
XXI2\<3\>\/XI2\<3\>\/XI2\<0\>\/XI2\<1\>\/RI2 (  \
 N_SEL0\<1\>_XI2\<3\>\/XI2\<3\>\/XI2\<0\>\/XI2\<1\>\/RI2_pos WLSEL\<964\> ) \
 R_1X_LL w=1e-07 l=1e-07   res=0.149966
XXI2\<3\>\/XI2\<3\>\/XI2\<0\>\/XI2\<0\>\/RR2 (  \
 N_SEL3\<3\>_XI2\<3\>\/XI2\<3\>\/XI2\<0\>\/XI2\<0\>\/RR2_pos WLSEL\<963\> ) \
 R_1X_LL w=1e-07 l=1e-07   res=0.149966
XXI2\<3\>\/XI2\<3\>\/XI2\<0\>\/XI2\<0\>\/RR1 (  \
 N_SEL2\<3\>_XI2\<3\>\/XI2\<3\>\/XI2\<0\>\/XI2\<0\>\/RR1_pos WLSEL\<962\> ) \
 R_1X_LL w=1e-07 l=1e-07   res=0.149966
XXI2\<3\>\/XI2\<3\>\/XI2\<0\>\/XI2\<0\>\/RR0 (  \
 N_SEL1\<0\>_XI2\<3\>\/XI2\<3\>\/XI2\<0\>\/XI2\<0\>\/RR0_pos WLSEL\<961\> ) \
 R_1X_LL w=1e-07 l=1e-07   res=0.149966
XXI2\<3\>\/XI2\<3\>\/XI2\<0\>\/XI2\<0\>\/RI2 (  \
 N_SEL0\<0\>_XI2\<3\>\/XI2\<3\>\/XI2\<0\>\/XI2\<0\>\/RI2_pos WLSEL\<960\> ) \
 R_1X_LL w=1e-07 l=1e-07   res=0.149966
XXI2\<3\>\/XI2\<2\>\/XI2\<3\>\/XI2\<3\>\/RR2 (  \
 N_SEL3\<3\>_XI2\<3\>\/XI2\<2\>\/XI2\<3\>\/XI2\<3\>\/RR2_pos WLSEL\<959\> ) \
 R_1X_LL w=1e-07 l=1e-07   res=0.149966
XXI2\<3\>\/XI2\<2\>\/XI2\<3\>\/XI2\<3\>\/RR1 (  \
 N_SEL2\<2\>_XI2\<3\>\/XI2\<2\>\/XI2\<3\>\/XI2\<3\>\/RR1_pos WLSEL\<958\> ) \
 R_1X_LL w=1e-07 l=1e-07   res=0.149966
XXI2\<3\>\/XI2\<2\>\/XI2\<3\>\/XI2\<3\>\/RR0 (  \
 N_SEL1\<3\>_XI2\<3\>\/XI2\<2\>\/XI2\<3\>\/XI2\<3\>\/RR0_pos WLSEL\<957\> ) \
 R_1X_LL w=1e-07 l=1e-07   res=0.149966
XXI2\<3\>\/XI2\<2\>\/XI2\<3\>\/XI2\<3\>\/RI2 (  \
 N_SEL0\<3\>_XI2\<3\>\/XI2\<2\>\/XI2\<3\>\/XI2\<3\>\/RI2_pos WLSEL\<956\> ) \
 R_1X_LL w=1e-07 l=1e-07   res=0.149966
XXI2\<3\>\/XI2\<2\>\/XI2\<3\>\/XI2\<2\>\/RR2 (  \
 N_SEL3\<3\>_XI2\<3\>\/XI2\<2\>\/XI2\<3\>\/XI2\<2\>\/RR2_pos WLSEL\<955\> ) \
 R_1X_LL w=1e-07 l=1e-07   res=0.149966
XXI2\<3\>\/XI2\<2\>\/XI2\<3\>\/XI2\<2\>\/RR1 (  \
 N_SEL2\<2\>_XI2\<3\>\/XI2\<2\>\/XI2\<3\>\/XI2\<2\>\/RR1_pos WLSEL\<954\> ) \
 R_1X_LL w=1e-07 l=1e-07   res=0.149966
XXI2\<3\>\/XI2\<2\>\/XI2\<3\>\/XI2\<2\>\/RR0 (  \
 N_SEL1\<3\>_XI2\<3\>\/XI2\<2\>\/XI2\<3\>\/XI2\<2\>\/RR0_pos WLSEL\<953\> ) \
 R_1X_LL w=1e-07 l=1e-07   res=0.149966
XXI2\<3\>\/XI2\<2\>\/XI2\<3\>\/XI2\<2\>\/RI2 (  \
 N_SEL0\<2\>_XI2\<3\>\/XI2\<2\>\/XI2\<3\>\/XI2\<2\>\/RI2_pos WLSEL\<952\> ) \
 R_1X_LL w=1e-07 l=1e-07   res=0.149966
XXI2\<3\>\/XI2\<2\>\/XI2\<3\>\/XI2\<1\>\/RR2 (  \
 N_SEL3\<3\>_XI2\<3\>\/XI2\<2\>\/XI2\<3\>\/XI2\<1\>\/RR2_pos WLSEL\<951\> ) \
 R_1X_LL w=1e-07 l=1e-07   res=0.149966
XXI2\<3\>\/XI2\<2\>\/XI2\<3\>\/XI2\<1\>\/RR1 (  \
 N_SEL2\<2\>_XI2\<3\>\/XI2\<2\>\/XI2\<3\>\/XI2\<1\>\/RR1_pos WLSEL\<950\> ) \
 R_1X_LL w=1e-07 l=1e-07   res=0.149966
XXI2\<3\>\/XI2\<2\>\/XI2\<3\>\/XI2\<1\>\/RR0 (  \
 N_SEL1\<3\>_XI2\<3\>\/XI2\<2\>\/XI2\<3\>\/XI2\<1\>\/RR0_pos WLSEL\<949\> ) \
 R_1X_LL w=1e-07 l=1e-07   res=0.149966
XXI2\<3\>\/XI2\<2\>\/XI2\<3\>\/XI2\<1\>\/RI2 (  \
 N_SEL0\<1\>_XI2\<3\>\/XI2\<2\>\/XI2\<3\>\/XI2\<1\>\/RI2_pos WLSEL\<948\> ) \
 R_1X_LL w=1e-07 l=1e-07   res=0.149966
XXI2\<3\>\/XI2\<2\>\/XI2\<3\>\/XI2\<0\>\/RR2 (  \
 N_SEL3\<3\>_XI2\<3\>\/XI2\<2\>\/XI2\<3\>\/XI2\<0\>\/RR2_pos WLSEL\<947\> ) \
 R_1X_LL w=1e-07 l=1e-07   res=0.149966
XXI2\<3\>\/XI2\<2\>\/XI2\<3\>\/XI2\<0\>\/RR1 (  \
 N_SEL2\<2\>_XI2\<3\>\/XI2\<2\>\/XI2\<3\>\/XI2\<0\>\/RR1_pos WLSEL\<946\> ) \
 R_1X_LL w=1e-07 l=1e-07   res=0.149966
XXI2\<3\>\/XI2\<2\>\/XI2\<3\>\/XI2\<0\>\/RR0 (  \
 N_SEL1\<3\>_XI2\<3\>\/XI2\<2\>\/XI2\<3\>\/XI2\<0\>\/RR0_pos WLSEL\<945\> ) \
 R_1X_LL w=1e-07 l=1e-07   res=0.149966
XXI2\<3\>\/XI2\<2\>\/XI2\<3\>\/XI2\<0\>\/RI2 (  \
 N_SEL0\<0\>_XI2\<3\>\/XI2\<2\>\/XI2\<3\>\/XI2\<0\>\/RI2_pos WLSEL\<944\> ) \
 R_1X_LL w=1e-07 l=1e-07   res=0.149966
XXI2\<3\>\/XI2\<2\>\/XI2\<2\>\/XI2\<3\>\/RR2 (  \
 N_SEL3\<3\>_XI2\<3\>\/XI2\<2\>\/XI2\<2\>\/XI2\<3\>\/RR2_pos WLSEL\<943\> ) \
 R_1X_LL w=1e-07 l=1e-07   res=0.149966
XXI2\<3\>\/XI2\<2\>\/XI2\<2\>\/XI2\<3\>\/RR1 (  \
 N_SEL2\<2\>_XI2\<3\>\/XI2\<2\>\/XI2\<2\>\/XI2\<3\>\/RR1_pos WLSEL\<942\> ) \
 R_1X_LL w=1e-07 l=1e-07   res=0.149966
XXI2\<3\>\/XI2\<2\>\/XI2\<2\>\/XI2\<3\>\/RR0 (  \
 N_SEL1\<2\>_XI2\<3\>\/XI2\<2\>\/XI2\<2\>\/XI2\<3\>\/RR0_pos WLSEL\<941\> ) \
 R_1X_LL w=1e-07 l=1e-07   res=0.149966
XXI2\<3\>\/XI2\<2\>\/XI2\<2\>\/XI2\<3\>\/RI2 (  \
 N_SEL0\<3\>_XI2\<3\>\/XI2\<2\>\/XI2\<2\>\/XI2\<3\>\/RI2_pos WLSEL\<940\> ) \
 R_1X_LL w=1e-07 l=1e-07   res=0.149966
XXI2\<3\>\/XI2\<2\>\/XI2\<2\>\/XI2\<2\>\/RR2 (  \
 N_SEL3\<3\>_XI2\<3\>\/XI2\<2\>\/XI2\<2\>\/XI2\<2\>\/RR2_pos WLSEL\<939\> ) \
 R_1X_LL w=1e-07 l=1e-07   res=0.149966
XXI2\<3\>\/XI2\<2\>\/XI2\<2\>\/XI2\<2\>\/RR1 (  \
 N_SEL2\<2\>_XI2\<3\>\/XI2\<2\>\/XI2\<2\>\/XI2\<2\>\/RR1_pos WLSEL\<938\> ) \
 R_1X_LL w=1e-07 l=1e-07   res=0.149966
XXI2\<3\>\/XI2\<2\>\/XI2\<2\>\/XI2\<2\>\/RR0 (  \
 N_SEL1\<2\>_XI2\<3\>\/XI2\<2\>\/XI2\<2\>\/XI2\<2\>\/RR0_pos WLSEL\<937\> ) \
 R_1X_LL w=1e-07 l=1e-07   res=0.149966
XXI2\<3\>\/XI2\<2\>\/XI2\<2\>\/XI2\<2\>\/RI2 (  \
 N_SEL0\<2\>_XI2\<3\>\/XI2\<2\>\/XI2\<2\>\/XI2\<2\>\/RI2_pos WLSEL\<936\> ) \
 R_1X_LL w=1e-07 l=1e-07   res=0.149966
XXI2\<3\>\/XI2\<2\>\/XI2\<2\>\/XI2\<1\>\/RR2 (  \
 N_SEL3\<3\>_XI2\<3\>\/XI2\<2\>\/XI2\<2\>\/XI2\<1\>\/RR2_pos WLSEL\<935\> ) \
 R_1X_LL w=1e-07 l=1e-07   res=0.149966
XXI2\<3\>\/XI2\<2\>\/XI2\<2\>\/XI2\<1\>\/RR1 (  \
 N_SEL2\<2\>_XI2\<3\>\/XI2\<2\>\/XI2\<2\>\/XI2\<1\>\/RR1_pos WLSEL\<934\> ) \
 R_1X_LL w=1e-07 l=1e-07   res=0.149966
XXI2\<3\>\/XI2\<2\>\/XI2\<2\>\/XI2\<1\>\/RR0 (  \
 N_SEL1\<2\>_XI2\<3\>\/XI2\<2\>\/XI2\<2\>\/XI2\<1\>\/RR0_pos WLSEL\<933\> ) \
 R_1X_LL w=1e-07 l=1e-07   res=0.149966
XXI2\<3\>\/XI2\<2\>\/XI2\<2\>\/XI2\<1\>\/RI2 (  \
 N_SEL0\<1\>_XI2\<3\>\/XI2\<2\>\/XI2\<2\>\/XI2\<1\>\/RI2_pos WLSEL\<932\> ) \
 R_1X_LL w=1e-07 l=1e-07   res=0.149966
XXI2\<3\>\/XI2\<2\>\/XI2\<2\>\/XI2\<0\>\/RR2 (  \
 N_SEL3\<3\>_XI2\<3\>\/XI2\<2\>\/XI2\<2\>\/XI2\<0\>\/RR2_pos WLSEL\<931\> ) \
 R_1X_LL w=1e-07 l=1e-07   res=0.149966
XXI2\<3\>\/XI2\<2\>\/XI2\<2\>\/XI2\<0\>\/RR1 (  \
 N_SEL2\<2\>_XI2\<3\>\/XI2\<2\>\/XI2\<2\>\/XI2\<0\>\/RR1_pos WLSEL\<930\> ) \
 R_1X_LL w=1e-07 l=1e-07   res=0.149966
XXI2\<3\>\/XI2\<2\>\/XI2\<2\>\/XI2\<0\>\/RR0 (  \
 N_SEL1\<2\>_XI2\<3\>\/XI2\<2\>\/XI2\<2\>\/XI2\<0\>\/RR0_pos WLSEL\<929\> ) \
 R_1X_LL w=1e-07 l=1e-07   res=0.149966
XXI2\<3\>\/XI2\<2\>\/XI2\<2\>\/XI2\<0\>\/RI2 (  \
 N_SEL0\<0\>_XI2\<3\>\/XI2\<2\>\/XI2\<2\>\/XI2\<0\>\/RI2_pos WLSEL\<928\> ) \
 R_1X_LL w=1e-07 l=1e-07   res=0.149966
XXI2\<3\>\/XI2\<2\>\/XI2\<1\>\/XI2\<3\>\/RR2 (  \
 N_SEL3\<3\>_XI2\<3\>\/XI2\<2\>\/XI2\<1\>\/XI2\<3\>\/RR2_pos WLSEL\<927\> ) \
 R_1X_LL w=1e-07 l=1e-07   res=0.149966
XXI2\<3\>\/XI2\<2\>\/XI2\<1\>\/XI2\<3\>\/RR1 (  \
 N_SEL2\<2\>_XI2\<3\>\/XI2\<2\>\/XI2\<1\>\/XI2\<3\>\/RR1_pos WLSEL\<926\> ) \
 R_1X_LL w=1e-07 l=1e-07   res=0.149966
XXI2\<3\>\/XI2\<2\>\/XI2\<1\>\/XI2\<3\>\/RR0 (  \
 N_SEL1\<1\>_XI2\<3\>\/XI2\<2\>\/XI2\<1\>\/XI2\<3\>\/RR0_pos WLSEL\<925\> ) \
 R_1X_LL w=1e-07 l=1e-07   res=0.149966
XXI2\<3\>\/XI2\<2\>\/XI2\<1\>\/XI2\<3\>\/RI2 (  \
 N_SEL0\<3\>_XI2\<3\>\/XI2\<2\>\/XI2\<1\>\/XI2\<3\>\/RI2_pos WLSEL\<924\> ) \
 R_1X_LL w=1e-07 l=1e-07   res=0.149966
XXI2\<3\>\/XI2\<2\>\/XI2\<1\>\/XI2\<2\>\/RR2 (  \
 N_SEL3\<3\>_XI2\<3\>\/XI2\<2\>\/XI2\<1\>\/XI2\<2\>\/RR2_pos WLSEL\<923\> ) \
 R_1X_LL w=1e-07 l=1e-07   res=0.149966
XXI2\<3\>\/XI2\<2\>\/XI2\<1\>\/XI2\<2\>\/RR1 (  \
 N_SEL2\<2\>_XI2\<3\>\/XI2\<2\>\/XI2\<1\>\/XI2\<2\>\/RR1_pos WLSEL\<922\> ) \
 R_1X_LL w=1e-07 l=1e-07   res=0.149966
XXI2\<3\>\/XI2\<2\>\/XI2\<1\>\/XI2\<2\>\/RR0 (  \
 N_SEL1\<1\>_XI2\<3\>\/XI2\<2\>\/XI2\<1\>\/XI2\<2\>\/RR0_pos WLSEL\<921\> ) \
 R_1X_LL w=1e-07 l=1e-07   res=0.149966
XXI2\<3\>\/XI2\<2\>\/XI2\<1\>\/XI2\<2\>\/RI2 (  \
 N_SEL0\<2\>_XI2\<3\>\/XI2\<2\>\/XI2\<1\>\/XI2\<2\>\/RI2_pos WLSEL\<920\> ) \
 R_1X_LL w=1e-07 l=1e-07   res=0.149966
XXI2\<3\>\/XI2\<2\>\/XI2\<1\>\/XI2\<1\>\/RR2 (  \
 N_SEL3\<3\>_XI2\<3\>\/XI2\<2\>\/XI2\<1\>\/XI2\<1\>\/RR2_pos WLSEL\<919\> ) \
 R_1X_LL w=1e-07 l=1e-07   res=0.149966
XXI2\<3\>\/XI2\<2\>\/XI2\<1\>\/XI2\<1\>\/RR1 (  \
 N_SEL2\<2\>_XI2\<3\>\/XI2\<2\>\/XI2\<1\>\/XI2\<1\>\/RR1_pos WLSEL\<918\> ) \
 R_1X_LL w=1e-07 l=1e-07   res=0.149966
XXI2\<3\>\/XI2\<2\>\/XI2\<1\>\/XI2\<1\>\/RR0 (  \
 N_SEL1\<1\>_XI2\<3\>\/XI2\<2\>\/XI2\<1\>\/XI2\<1\>\/RR0_pos WLSEL\<917\> ) \
 R_1X_LL w=1e-07 l=1e-07   res=0.149966
XXI2\<3\>\/XI2\<2\>\/XI2\<1\>\/XI2\<1\>\/RI2 (  \
 N_SEL0\<1\>_XI2\<3\>\/XI2\<2\>\/XI2\<1\>\/XI2\<1\>\/RI2_pos WLSEL\<916\> ) \
 R_1X_LL w=1e-07 l=1e-07   res=0.149966
XXI2\<3\>\/XI2\<2\>\/XI2\<1\>\/XI2\<0\>\/RR2 (  \
 N_SEL3\<3\>_XI2\<3\>\/XI2\<2\>\/XI2\<1\>\/XI2\<0\>\/RR2_pos WLSEL\<915\> ) \
 R_1X_LL w=1e-07 l=1e-07   res=0.149966
XXI2\<3\>\/XI2\<2\>\/XI2\<1\>\/XI2\<0\>\/RR1 (  \
 N_SEL2\<2\>_XI2\<3\>\/XI2\<2\>\/XI2\<1\>\/XI2\<0\>\/RR1_pos WLSEL\<914\> ) \
 R_1X_LL w=1e-07 l=1e-07   res=0.149966
XXI2\<3\>\/XI2\<2\>\/XI2\<1\>\/XI2\<0\>\/RR0 (  \
 N_SEL1\<1\>_XI2\<3\>\/XI2\<2\>\/XI2\<1\>\/XI2\<0\>\/RR0_pos WLSEL\<913\> ) \
 R_1X_LL w=1e-07 l=1e-07   res=0.149966
XXI2\<3\>\/XI2\<2\>\/XI2\<1\>\/XI2\<0\>\/RI2 (  \
 N_SEL0\<0\>_XI2\<3\>\/XI2\<2\>\/XI2\<1\>\/XI2\<0\>\/RI2_pos WLSEL\<912\> ) \
 R_1X_LL w=1e-07 l=1e-07   res=0.149966
XXI2\<3\>\/XI2\<2\>\/XI2\<0\>\/XI2\<3\>\/RR2 (  \
 N_SEL3\<3\>_XI2\<3\>\/XI2\<2\>\/XI2\<0\>\/XI2\<3\>\/RR2_pos WLSEL\<911\> ) \
 R_1X_LL w=1e-07 l=1e-07   res=0.149966
XXI2\<3\>\/XI2\<2\>\/XI2\<0\>\/XI2\<3\>\/RR1 (  \
 N_SEL2\<2\>_XI2\<3\>\/XI2\<2\>\/XI2\<0\>\/XI2\<3\>\/RR1_pos WLSEL\<910\> ) \
 R_1X_LL w=1e-07 l=1e-07   res=0.149966
XXI2\<3\>\/XI2\<2\>\/XI2\<0\>\/XI2\<3\>\/RR0 (  \
 N_SEL1\<0\>_XI2\<3\>\/XI2\<2\>\/XI2\<0\>\/XI2\<3\>\/RR0_pos WLSEL\<909\> ) \
 R_1X_LL w=1e-07 l=1e-07   res=0.149966
XXI2\<3\>\/XI2\<2\>\/XI2\<0\>\/XI2\<3\>\/RI2 (  \
 N_SEL0\<3\>_XI2\<3\>\/XI2\<2\>\/XI2\<0\>\/XI2\<3\>\/RI2_pos WLSEL\<908\> ) \
 R_1X_LL w=1e-07 l=1e-07   res=0.149966
XXI2\<3\>\/XI2\<2\>\/XI2\<0\>\/XI2\<2\>\/RR2 (  \
 N_SEL3\<3\>_XI2\<3\>\/XI2\<2\>\/XI2\<0\>\/XI2\<2\>\/RR2_pos WLSEL\<907\> ) \
 R_1X_LL w=1e-07 l=1e-07   res=0.149966
XXI2\<3\>\/XI2\<2\>\/XI2\<0\>\/XI2\<2\>\/RR1 (  \
 N_SEL2\<2\>_XI2\<3\>\/XI2\<2\>\/XI2\<0\>\/XI2\<2\>\/RR1_pos WLSEL\<906\> ) \
 R_1X_LL w=1e-07 l=1e-07   res=0.149966
XXI2\<3\>\/XI2\<2\>\/XI2\<0\>\/XI2\<2\>\/RR0 (  \
 N_SEL1\<0\>_XI2\<3\>\/XI2\<2\>\/XI2\<0\>\/XI2\<2\>\/RR0_pos WLSEL\<905\> ) \
 R_1X_LL w=1e-07 l=1e-07   res=0.149966
XXI2\<3\>\/XI2\<2\>\/XI2\<0\>\/XI2\<2\>\/RI2 (  \
 N_SEL0\<2\>_XI2\<3\>\/XI2\<2\>\/XI2\<0\>\/XI2\<2\>\/RI2_pos WLSEL\<904\> ) \
 R_1X_LL w=1e-07 l=1e-07   res=0.149966
XXI2\<3\>\/XI2\<2\>\/XI2\<0\>\/XI2\<1\>\/RR2 (  \
 N_SEL3\<3\>_XI2\<3\>\/XI2\<2\>\/XI2\<0\>\/XI2\<1\>\/RR2_pos WLSEL\<903\> ) \
 R_1X_LL w=1e-07 l=1e-07   res=0.149966
XXI2\<3\>\/XI2\<2\>\/XI2\<0\>\/XI2\<1\>\/RR1 (  \
 N_SEL2\<2\>_XI2\<3\>\/XI2\<2\>\/XI2\<0\>\/XI2\<1\>\/RR1_pos WLSEL\<902\> ) \
 R_1X_LL w=1e-07 l=1e-07   res=0.149966
XXI2\<3\>\/XI2\<2\>\/XI2\<0\>\/XI2\<1\>\/RR0 (  \
 N_SEL1\<0\>_XI2\<3\>\/XI2\<2\>\/XI2\<0\>\/XI2\<1\>\/RR0_pos WLSEL\<901\> ) \
 R_1X_LL w=1e-07 l=1e-07   res=0.149966
XXI2\<3\>\/XI2\<2\>\/XI2\<0\>\/XI2\<1\>\/RI2 (  \
 N_SEL0\<1\>_XI2\<3\>\/XI2\<2\>\/XI2\<0\>\/XI2\<1\>\/RI2_pos WLSEL\<900\> ) \
 R_1X_LL w=1e-07 l=1e-07   res=0.149966
XXI2\<3\>\/XI2\<2\>\/XI2\<0\>\/XI2\<0\>\/RR2 (  \
 N_SEL3\<3\>_XI2\<3\>\/XI2\<2\>\/XI2\<0\>\/XI2\<0\>\/RR2_pos WLSEL\<899\> ) \
 R_1X_LL w=1e-07 l=1e-07   res=0.149966
XXI2\<3\>\/XI2\<2\>\/XI2\<0\>\/XI2\<0\>\/RR1 (  \
 N_SEL2\<2\>_XI2\<3\>\/XI2\<2\>\/XI2\<0\>\/XI2\<0\>\/RR1_pos WLSEL\<898\> ) \
 R_1X_LL w=1e-07 l=1e-07   res=0.149966
XXI2\<3\>\/XI2\<2\>\/XI2\<0\>\/XI2\<0\>\/RR0 (  \
 N_SEL1\<0\>_XI2\<3\>\/XI2\<2\>\/XI2\<0\>\/XI2\<0\>\/RR0_pos WLSEL\<897\> ) \
 R_1X_LL w=1e-07 l=1e-07   res=0.149966
XXI2\<3\>\/XI2\<2\>\/XI2\<0\>\/XI2\<0\>\/RI2 (  \
 N_SEL0\<0\>_XI2\<3\>\/XI2\<2\>\/XI2\<0\>\/XI2\<0\>\/RI2_pos WLSEL\<896\> ) \
 R_1X_LL w=1e-07 l=1e-07   res=0.149966
XXI2\<3\>\/XI2\<1\>\/XI2\<3\>\/XI2\<3\>\/RR2 (  \
 N_SEL3\<3\>_XI2\<3\>\/XI2\<1\>\/XI2\<3\>\/XI2\<3\>\/RR2_pos WLSEL\<895\> ) \
 R_1X_LL w=1e-07 l=1e-07   res=0.149966
XXI2\<3\>\/XI2\<1\>\/XI2\<3\>\/XI2\<3\>\/RR1 (  \
 N_SEL2\<1\>_XI2\<3\>\/XI2\<1\>\/XI2\<3\>\/XI2\<3\>\/RR1_pos WLSEL\<894\> ) \
 R_1X_LL w=1e-07 l=1e-07   res=0.149966
XXI2\<3\>\/XI2\<1\>\/XI2\<3\>\/XI2\<3\>\/RR0 (  \
 N_SEL1\<3\>_XI2\<3\>\/XI2\<1\>\/XI2\<3\>\/XI2\<3\>\/RR0_pos WLSEL\<893\> ) \
 R_1X_LL w=1e-07 l=1e-07   res=0.149966
XXI2\<3\>\/XI2\<1\>\/XI2\<3\>\/XI2\<3\>\/RI2 (  \
 N_SEL0\<3\>_XI2\<3\>\/XI2\<1\>\/XI2\<3\>\/XI2\<3\>\/RI2_pos WLSEL\<892\> ) \
 R_1X_LL w=1e-07 l=1e-07   res=0.149966
XXI2\<3\>\/XI2\<1\>\/XI2\<3\>\/XI2\<2\>\/RR2 (  \
 N_SEL3\<3\>_XI2\<3\>\/XI2\<1\>\/XI2\<3\>\/XI2\<2\>\/RR2_pos WLSEL\<891\> ) \
 R_1X_LL w=1e-07 l=1e-07   res=0.149966
XXI2\<3\>\/XI2\<1\>\/XI2\<3\>\/XI2\<2\>\/RR1 (  \
 N_SEL2\<1\>_XI2\<3\>\/XI2\<1\>\/XI2\<3\>\/XI2\<2\>\/RR1_pos WLSEL\<890\> ) \
 R_1X_LL w=1e-07 l=1e-07   res=0.149966
XXI2\<3\>\/XI2\<1\>\/XI2\<3\>\/XI2\<2\>\/RR0 (  \
 N_SEL1\<3\>_XI2\<3\>\/XI2\<1\>\/XI2\<3\>\/XI2\<2\>\/RR0_pos WLSEL\<889\> ) \
 R_1X_LL w=1e-07 l=1e-07   res=0.149966
XXI2\<3\>\/XI2\<1\>\/XI2\<3\>\/XI2\<2\>\/RI2 (  \
 N_SEL0\<2\>_XI2\<3\>\/XI2\<1\>\/XI2\<3\>\/XI2\<2\>\/RI2_pos WLSEL\<888\> ) \
 R_1X_LL w=1e-07 l=1e-07   res=0.149966
XXI2\<3\>\/XI2\<1\>\/XI2\<3\>\/XI2\<1\>\/RR2 (  \
 N_SEL3\<3\>_XI2\<3\>\/XI2\<1\>\/XI2\<3\>\/XI2\<1\>\/RR2_pos WLSEL\<887\> ) \
 R_1X_LL w=1e-07 l=1e-07   res=0.149966
XXI2\<3\>\/XI2\<1\>\/XI2\<3\>\/XI2\<1\>\/RR1 (  \
 N_SEL2\<1\>_XI2\<3\>\/XI2\<1\>\/XI2\<3\>\/XI2\<1\>\/RR1_pos WLSEL\<886\> ) \
 R_1X_LL w=1e-07 l=1e-07   res=0.149966
XXI2\<3\>\/XI2\<1\>\/XI2\<3\>\/XI2\<1\>\/RR0 (  \
 N_SEL1\<3\>_XI2\<3\>\/XI2\<1\>\/XI2\<3\>\/XI2\<1\>\/RR0_pos WLSEL\<885\> ) \
 R_1X_LL w=1e-07 l=1e-07   res=0.149966
XXI2\<3\>\/XI2\<1\>\/XI2\<3\>\/XI2\<1\>\/RI2 (  \
 N_SEL0\<1\>_XI2\<3\>\/XI2\<1\>\/XI2\<3\>\/XI2\<1\>\/RI2_pos WLSEL\<884\> ) \
 R_1X_LL w=1e-07 l=1e-07   res=0.149966
XXI2\<3\>\/XI2\<1\>\/XI2\<3\>\/XI2\<0\>\/RR2 (  \
 N_SEL3\<3\>_XI2\<3\>\/XI2\<1\>\/XI2\<3\>\/XI2\<0\>\/RR2_pos WLSEL\<883\> ) \
 R_1X_LL w=1e-07 l=1e-07   res=0.149966
XXI2\<3\>\/XI2\<1\>\/XI2\<3\>\/XI2\<0\>\/RR1 (  \
 N_SEL2\<1\>_XI2\<3\>\/XI2\<1\>\/XI2\<3\>\/XI2\<0\>\/RR1_pos WLSEL\<882\> ) \
 R_1X_LL w=1e-07 l=1e-07   res=0.149966
XXI2\<3\>\/XI2\<1\>\/XI2\<3\>\/XI2\<0\>\/RR0 (  \
 N_SEL1\<3\>_XI2\<3\>\/XI2\<1\>\/XI2\<3\>\/XI2\<0\>\/RR0_pos WLSEL\<881\> ) \
 R_1X_LL w=1e-07 l=1e-07   res=0.149966
XXI2\<3\>\/XI2\<1\>\/XI2\<3\>\/XI2\<0\>\/RI2 (  \
 N_SEL0\<0\>_XI2\<3\>\/XI2\<1\>\/XI2\<3\>\/XI2\<0\>\/RI2_pos WLSEL\<880\> ) \
 R_1X_LL w=1e-07 l=1e-07   res=0.149966
XXI2\<3\>\/XI2\<1\>\/XI2\<2\>\/XI2\<3\>\/RR2 (  \
 N_SEL3\<3\>_XI2\<3\>\/XI2\<1\>\/XI2\<2\>\/XI2\<3\>\/RR2_pos WLSEL\<879\> ) \
 R_1X_LL w=1e-07 l=1e-07   res=0.149966
XXI2\<3\>\/XI2\<1\>\/XI2\<2\>\/XI2\<3\>\/RR1 (  \
 N_SEL2\<1\>_XI2\<3\>\/XI2\<1\>\/XI2\<2\>\/XI2\<3\>\/RR1_pos WLSEL\<878\> ) \
 R_1X_LL w=1e-07 l=1e-07   res=0.149966
XXI2\<3\>\/XI2\<1\>\/XI2\<2\>\/XI2\<3\>\/RR0 (  \
 N_SEL1\<2\>_XI2\<3\>\/XI2\<1\>\/XI2\<2\>\/XI2\<3\>\/RR0_pos WLSEL\<877\> ) \
 R_1X_LL w=1e-07 l=1e-07   res=0.149966
XXI2\<3\>\/XI2\<1\>\/XI2\<2\>\/XI2\<3\>\/RI2 (  \
 N_SEL0\<3\>_XI2\<3\>\/XI2\<1\>\/XI2\<2\>\/XI2\<3\>\/RI2_pos WLSEL\<876\> ) \
 R_1X_LL w=1e-07 l=1e-07   res=0.149966
XXI2\<3\>\/XI2\<1\>\/XI2\<2\>\/XI2\<2\>\/RR2 (  \
 N_SEL3\<3\>_XI2\<3\>\/XI2\<1\>\/XI2\<2\>\/XI2\<2\>\/RR2_pos WLSEL\<875\> ) \
 R_1X_LL w=1e-07 l=1e-07   res=0.149966
XXI2\<3\>\/XI2\<1\>\/XI2\<2\>\/XI2\<2\>\/RR1 (  \
 N_SEL2\<1\>_XI2\<3\>\/XI2\<1\>\/XI2\<2\>\/XI2\<2\>\/RR1_pos WLSEL\<874\> ) \
 R_1X_LL w=1e-07 l=1e-07   res=0.149966
XXI2\<3\>\/XI2\<1\>\/XI2\<2\>\/XI2\<2\>\/RR0 (  \
 N_SEL1\<2\>_XI2\<3\>\/XI2\<1\>\/XI2\<2\>\/XI2\<2\>\/RR0_pos WLSEL\<873\> ) \
 R_1X_LL w=1e-07 l=1e-07   res=0.149966
XXI2\<3\>\/XI2\<1\>\/XI2\<2\>\/XI2\<2\>\/RI2 (  \
 N_SEL0\<2\>_XI2\<3\>\/XI2\<1\>\/XI2\<2\>\/XI2\<2\>\/RI2_pos WLSEL\<872\> ) \
 R_1X_LL w=1e-07 l=1e-07   res=0.149966
XXI2\<3\>\/XI2\<1\>\/XI2\<2\>\/XI2\<1\>\/RR2 (  \
 N_SEL3\<3\>_XI2\<3\>\/XI2\<1\>\/XI2\<2\>\/XI2\<1\>\/RR2_pos WLSEL\<871\> ) \
 R_1X_LL w=1e-07 l=1e-07   res=0.149966
XXI2\<3\>\/XI2\<1\>\/XI2\<2\>\/XI2\<1\>\/RR1 (  \
 N_SEL2\<1\>_XI2\<3\>\/XI2\<1\>\/XI2\<2\>\/XI2\<1\>\/RR1_pos WLSEL\<870\> ) \
 R_1X_LL w=1e-07 l=1e-07   res=0.149966
XXI2\<3\>\/XI2\<1\>\/XI2\<2\>\/XI2\<1\>\/RR0 (  \
 N_SEL1\<2\>_XI2\<3\>\/XI2\<1\>\/XI2\<2\>\/XI2\<1\>\/RR0_pos WLSEL\<869\> ) \
 R_1X_LL w=1e-07 l=1e-07   res=0.149966
XXI2\<3\>\/XI2\<1\>\/XI2\<2\>\/XI2\<1\>\/RI2 (  \
 N_SEL0\<1\>_XI2\<3\>\/XI2\<1\>\/XI2\<2\>\/XI2\<1\>\/RI2_pos WLSEL\<868\> ) \
 R_1X_LL w=1e-07 l=1e-07   res=0.149966
XXI2\<3\>\/XI2\<1\>\/XI2\<2\>\/XI2\<0\>\/RR2 (  \
 N_SEL3\<3\>_XI2\<3\>\/XI2\<1\>\/XI2\<2\>\/XI2\<0\>\/RR2_pos WLSEL\<867\> ) \
 R_1X_LL w=1e-07 l=1e-07   res=0.149966
XXI2\<3\>\/XI2\<1\>\/XI2\<2\>\/XI2\<0\>\/RR1 (  \
 N_SEL2\<1\>_XI2\<3\>\/XI2\<1\>\/XI2\<2\>\/XI2\<0\>\/RR1_pos WLSEL\<866\> ) \
 R_1X_LL w=1e-07 l=1e-07   res=0.149966
XXI2\<3\>\/XI2\<1\>\/XI2\<2\>\/XI2\<0\>\/RR0 (  \
 N_SEL1\<2\>_XI2\<3\>\/XI2\<1\>\/XI2\<2\>\/XI2\<0\>\/RR0_pos WLSEL\<865\> ) \
 R_1X_LL w=1e-07 l=1e-07   res=0.149966
XXI2\<3\>\/XI2\<1\>\/XI2\<2\>\/XI2\<0\>\/RI2 (  \
 N_SEL0\<0\>_XI2\<3\>\/XI2\<1\>\/XI2\<2\>\/XI2\<0\>\/RI2_pos WLSEL\<864\> ) \
 R_1X_LL w=1e-07 l=1e-07   res=0.149966
XXI2\<3\>\/XI2\<1\>\/XI2\<1\>\/XI2\<3\>\/RR2 (  \
 N_SEL3\<3\>_XI2\<3\>\/XI2\<1\>\/XI2\<1\>\/XI2\<3\>\/RR2_pos WLSEL\<863\> ) \
 R_1X_LL w=1e-07 l=1e-07   res=0.149966
XXI2\<3\>\/XI2\<1\>\/XI2\<1\>\/XI2\<3\>\/RR1 (  \
 N_SEL2\<1\>_XI2\<3\>\/XI2\<1\>\/XI2\<1\>\/XI2\<3\>\/RR1_pos WLSEL\<862\> ) \
 R_1X_LL w=1e-07 l=1e-07   res=0.149966
XXI2\<3\>\/XI2\<1\>\/XI2\<1\>\/XI2\<3\>\/RR0 (  \
 N_SEL1\<1\>_XI2\<3\>\/XI2\<1\>\/XI2\<1\>\/XI2\<3\>\/RR0_pos WLSEL\<861\> ) \
 R_1X_LL w=1e-07 l=1e-07   res=0.149966
XXI2\<3\>\/XI2\<1\>\/XI2\<1\>\/XI2\<3\>\/RI2 (  \
 N_SEL0\<3\>_XI2\<3\>\/XI2\<1\>\/XI2\<1\>\/XI2\<3\>\/RI2_pos WLSEL\<860\> ) \
 R_1X_LL w=1e-07 l=1e-07   res=0.149966
XXI2\<3\>\/XI2\<1\>\/XI2\<1\>\/XI2\<2\>\/RR2 (  \
 N_SEL3\<3\>_XI2\<3\>\/XI2\<1\>\/XI2\<1\>\/XI2\<2\>\/RR2_pos WLSEL\<859\> ) \
 R_1X_LL w=1e-07 l=1e-07   res=0.149966
XXI2\<3\>\/XI2\<1\>\/XI2\<1\>\/XI2\<2\>\/RR1 (  \
 N_SEL2\<1\>_XI2\<3\>\/XI2\<1\>\/XI2\<1\>\/XI2\<2\>\/RR1_pos WLSEL\<858\> ) \
 R_1X_LL w=1e-07 l=1e-07   res=0.149966
XXI2\<3\>\/XI2\<1\>\/XI2\<1\>\/XI2\<2\>\/RR0 (  \
 N_SEL1\<1\>_XI2\<3\>\/XI2\<1\>\/XI2\<1\>\/XI2\<2\>\/RR0_pos WLSEL\<857\> ) \
 R_1X_LL w=1e-07 l=1e-07   res=0.149966
XXI2\<3\>\/XI2\<1\>\/XI2\<1\>\/XI2\<2\>\/RI2 (  \
 N_SEL0\<2\>_XI2\<3\>\/XI2\<1\>\/XI2\<1\>\/XI2\<2\>\/RI2_pos WLSEL\<856\> ) \
 R_1X_LL w=1e-07 l=1e-07   res=0.149966
XXI2\<3\>\/XI2\<1\>\/XI2\<1\>\/XI2\<1\>\/RR2 (  \
 N_SEL3\<3\>_XI2\<3\>\/XI2\<1\>\/XI2\<1\>\/XI2\<1\>\/RR2_pos WLSEL\<855\> ) \
 R_1X_LL w=1e-07 l=1e-07   res=0.149966
XXI2\<3\>\/XI2\<1\>\/XI2\<1\>\/XI2\<1\>\/RR1 (  \
 N_SEL2\<1\>_XI2\<3\>\/XI2\<1\>\/XI2\<1\>\/XI2\<1\>\/RR1_pos WLSEL\<854\> ) \
 R_1X_LL w=1e-07 l=1e-07   res=0.149966
XXI2\<3\>\/XI2\<1\>\/XI2\<1\>\/XI2\<1\>\/RR0 (  \
 N_SEL1\<1\>_XI2\<3\>\/XI2\<1\>\/XI2\<1\>\/XI2\<1\>\/RR0_pos WLSEL\<853\> ) \
 R_1X_LL w=1e-07 l=1e-07   res=0.149966
XXI2\<3\>\/XI2\<1\>\/XI2\<1\>\/XI2\<1\>\/RI2 (  \
 N_SEL0\<1\>_XI2\<3\>\/XI2\<1\>\/XI2\<1\>\/XI2\<1\>\/RI2_pos WLSEL\<852\> ) \
 R_1X_LL w=1e-07 l=1e-07   res=0.149966
XXI2\<3\>\/XI2\<1\>\/XI2\<1\>\/XI2\<0\>\/RR2 (  \
 N_SEL3\<3\>_XI2\<3\>\/XI2\<1\>\/XI2\<1\>\/XI2\<0\>\/RR2_pos WLSEL\<851\> ) \
 R_1X_LL w=1e-07 l=1e-07   res=0.149966
XXI2\<3\>\/XI2\<1\>\/XI2\<1\>\/XI2\<0\>\/RR1 (  \
 N_SEL2\<1\>_XI2\<3\>\/XI2\<1\>\/XI2\<1\>\/XI2\<0\>\/RR1_pos WLSEL\<850\> ) \
 R_1X_LL w=1e-07 l=1e-07   res=0.149966
XXI2\<3\>\/XI2\<1\>\/XI2\<1\>\/XI2\<0\>\/RR0 (  \
 N_SEL1\<1\>_XI2\<3\>\/XI2\<1\>\/XI2\<1\>\/XI2\<0\>\/RR0_pos WLSEL\<849\> ) \
 R_1X_LL w=1e-07 l=1e-07   res=0.149966
XXI2\<3\>\/XI2\<1\>\/XI2\<1\>\/XI2\<0\>\/RI2 (  \
 N_SEL0\<0\>_XI2\<3\>\/XI2\<1\>\/XI2\<1\>\/XI2\<0\>\/RI2_pos WLSEL\<848\> ) \
 R_1X_LL w=1e-07 l=1e-07   res=0.149966
XXI2\<3\>\/XI2\<1\>\/XI2\<0\>\/XI2\<3\>\/RR2 (  \
 N_SEL3\<3\>_XI2\<3\>\/XI2\<1\>\/XI2\<0\>\/XI2\<3\>\/RR2_pos WLSEL\<847\> ) \
 R_1X_LL w=1e-07 l=1e-07   res=0.149966
XXI2\<3\>\/XI2\<1\>\/XI2\<0\>\/XI2\<3\>\/RR1 (  \
 N_SEL2\<1\>_XI2\<3\>\/XI2\<1\>\/XI2\<0\>\/XI2\<3\>\/RR1_pos WLSEL\<846\> ) \
 R_1X_LL w=1e-07 l=1e-07   res=0.149966
XXI2\<3\>\/XI2\<1\>\/XI2\<0\>\/XI2\<3\>\/RR0 (  \
 N_SEL1\<0\>_XI2\<3\>\/XI2\<1\>\/XI2\<0\>\/XI2\<3\>\/RR0_pos WLSEL\<845\> ) \
 R_1X_LL w=1e-07 l=1e-07   res=0.149966
XXI2\<3\>\/XI2\<1\>\/XI2\<0\>\/XI2\<3\>\/RI2 (  \
 N_SEL0\<3\>_XI2\<3\>\/XI2\<1\>\/XI2\<0\>\/XI2\<3\>\/RI2_pos WLSEL\<844\> ) \
 R_1X_LL w=1e-07 l=1e-07   res=0.149966
XXI2\<3\>\/XI2\<1\>\/XI2\<0\>\/XI2\<2\>\/RR2 (  \
 N_SEL3\<3\>_XI2\<3\>\/XI2\<1\>\/XI2\<0\>\/XI2\<2\>\/RR2_pos WLSEL\<843\> ) \
 R_1X_LL w=1e-07 l=1e-07   res=0.149966
XXI2\<3\>\/XI2\<1\>\/XI2\<0\>\/XI2\<2\>\/RR1 (  \
 N_SEL2\<1\>_XI2\<3\>\/XI2\<1\>\/XI2\<0\>\/XI2\<2\>\/RR1_pos WLSEL\<842\> ) \
 R_1X_LL w=1e-07 l=1e-07   res=0.149966
XXI2\<3\>\/XI2\<1\>\/XI2\<0\>\/XI2\<2\>\/RR0 (  \
 N_SEL1\<0\>_XI2\<3\>\/XI2\<1\>\/XI2\<0\>\/XI2\<2\>\/RR0_pos WLSEL\<841\> ) \
 R_1X_LL w=1e-07 l=1e-07   res=0.149966
XXI2\<3\>\/XI2\<1\>\/XI2\<0\>\/XI2\<2\>\/RI2 (  \
 N_SEL0\<2\>_XI2\<3\>\/XI2\<1\>\/XI2\<0\>\/XI2\<2\>\/RI2_pos WLSEL\<840\> ) \
 R_1X_LL w=1e-07 l=1e-07   res=0.149966
XXI2\<3\>\/XI2\<1\>\/XI2\<0\>\/XI2\<1\>\/RR2 (  \
 N_SEL3\<3\>_XI2\<3\>\/XI2\<1\>\/XI2\<0\>\/XI2\<1\>\/RR2_pos WLSEL\<839\> ) \
 R_1X_LL w=1e-07 l=1e-07   res=0.149966
XXI2\<3\>\/XI2\<1\>\/XI2\<0\>\/XI2\<1\>\/RR1 (  \
 N_SEL2\<1\>_XI2\<3\>\/XI2\<1\>\/XI2\<0\>\/XI2\<1\>\/RR1_pos WLSEL\<838\> ) \
 R_1X_LL w=1e-07 l=1e-07   res=0.149966
XXI2\<3\>\/XI2\<1\>\/XI2\<0\>\/XI2\<1\>\/RR0 (  \
 N_SEL1\<0\>_XI2\<3\>\/XI2\<1\>\/XI2\<0\>\/XI2\<1\>\/RR0_pos WLSEL\<837\> ) \
 R_1X_LL w=1e-07 l=1e-07   res=0.149966
XXI2\<3\>\/XI2\<1\>\/XI2\<0\>\/XI2\<1\>\/RI2 (  \
 N_SEL0\<1\>_XI2\<3\>\/XI2\<1\>\/XI2\<0\>\/XI2\<1\>\/RI2_pos WLSEL\<836\> ) \
 R_1X_LL w=1e-07 l=1e-07   res=0.149966
XXI2\<3\>\/XI2\<1\>\/XI2\<0\>\/XI2\<0\>\/RR2 (  \
 N_SEL3\<3\>_XI2\<3\>\/XI2\<1\>\/XI2\<0\>\/XI2\<0\>\/RR2_pos WLSEL\<835\> ) \
 R_1X_LL w=1e-07 l=1e-07   res=0.149966
XXI2\<3\>\/XI2\<1\>\/XI2\<0\>\/XI2\<0\>\/RR1 (  \
 N_SEL2\<1\>_XI2\<3\>\/XI2\<1\>\/XI2\<0\>\/XI2\<0\>\/RR1_pos WLSEL\<834\> ) \
 R_1X_LL w=1e-07 l=1e-07   res=0.149966
XXI2\<3\>\/XI2\<1\>\/XI2\<0\>\/XI2\<0\>\/RR0 (  \
 N_SEL1\<0\>_XI2\<3\>\/XI2\<1\>\/XI2\<0\>\/XI2\<0\>\/RR0_pos WLSEL\<833\> ) \
 R_1X_LL w=1e-07 l=1e-07   res=0.149966
XXI2\<3\>\/XI2\<1\>\/XI2\<0\>\/XI2\<0\>\/RI2 (  \
 N_SEL0\<0\>_XI2\<3\>\/XI2\<1\>\/XI2\<0\>\/XI2\<0\>\/RI2_pos WLSEL\<832\> ) \
 R_1X_LL w=1e-07 l=1e-07   res=0.149966
XXI2\<3\>\/XI2\<0\>\/XI2\<3\>\/XI2\<3\>\/RR2 (  \
 N_SEL3\<3\>_XI2\<3\>\/XI2\<0\>\/XI2\<3\>\/XI2\<3\>\/RR2_pos WLSEL\<831\> ) \
 R_1X_LL w=1e-07 l=1e-07   res=0.149966
XXI2\<3\>\/XI2\<0\>\/XI2\<3\>\/XI2\<3\>\/RR1 (  \
 N_SEL2\<0\>_XI2\<3\>\/XI2\<0\>\/XI2\<3\>\/XI2\<3\>\/RR1_pos WLSEL\<830\> ) \
 R_1X_LL w=1e-07 l=1e-07   res=0.149966
XXI2\<3\>\/XI2\<0\>\/XI2\<3\>\/XI2\<3\>\/RR0 (  \
 N_SEL1\<3\>_XI2\<3\>\/XI2\<0\>\/XI2\<3\>\/XI2\<3\>\/RR0_pos WLSEL\<829\> ) \
 R_1X_LL w=1e-07 l=1e-07   res=0.149966
XXI2\<3\>\/XI2\<0\>\/XI2\<3\>\/XI2\<3\>\/RI2 (  \
 N_SEL0\<3\>_XI2\<3\>\/XI2\<0\>\/XI2\<3\>\/XI2\<3\>\/RI2_pos WLSEL\<828\> ) \
 R_1X_LL w=1e-07 l=1e-07   res=0.149966
XXI2\<3\>\/XI2\<0\>\/XI2\<3\>\/XI2\<2\>\/RR2 (  \
 N_SEL3\<3\>_XI2\<3\>\/XI2\<0\>\/XI2\<3\>\/XI2\<2\>\/RR2_pos WLSEL\<827\> ) \
 R_1X_LL w=1e-07 l=1e-07   res=0.149966
XXI2\<3\>\/XI2\<0\>\/XI2\<3\>\/XI2\<2\>\/RR1 (  \
 N_SEL2\<0\>_XI2\<3\>\/XI2\<0\>\/XI2\<3\>\/XI2\<2\>\/RR1_pos WLSEL\<826\> ) \
 R_1X_LL w=1e-07 l=1e-07   res=0.149966
XXI2\<3\>\/XI2\<0\>\/XI2\<3\>\/XI2\<2\>\/RR0 (  \
 N_SEL1\<3\>_XI2\<3\>\/XI2\<0\>\/XI2\<3\>\/XI2\<2\>\/RR0_pos WLSEL\<825\> ) \
 R_1X_LL w=1e-07 l=1e-07   res=0.149966
XXI2\<3\>\/XI2\<0\>\/XI2\<3\>\/XI2\<2\>\/RI2 (  \
 N_SEL0\<2\>_XI2\<3\>\/XI2\<0\>\/XI2\<3\>\/XI2\<2\>\/RI2_pos WLSEL\<824\> ) \
 R_1X_LL w=1e-07 l=1e-07   res=0.149966
XXI2\<3\>\/XI2\<0\>\/XI2\<3\>\/XI2\<1\>\/RR2 (  \
 N_SEL3\<3\>_XI2\<3\>\/XI2\<0\>\/XI2\<3\>\/XI2\<1\>\/RR2_pos WLSEL\<823\> ) \
 R_1X_LL w=1e-07 l=1e-07   res=0.149966
XXI2\<3\>\/XI2\<0\>\/XI2\<3\>\/XI2\<1\>\/RR1 (  \
 N_SEL2\<0\>_XI2\<3\>\/XI2\<0\>\/XI2\<3\>\/XI2\<1\>\/RR1_pos WLSEL\<822\> ) \
 R_1X_LL w=1e-07 l=1e-07   res=0.149966
XXI2\<3\>\/XI2\<0\>\/XI2\<3\>\/XI2\<1\>\/RR0 (  \
 N_SEL1\<3\>_XI2\<3\>\/XI2\<0\>\/XI2\<3\>\/XI2\<1\>\/RR0_pos WLSEL\<821\> ) \
 R_1X_LL w=1e-07 l=1e-07   res=0.149966
XXI2\<3\>\/XI2\<0\>\/XI2\<3\>\/XI2\<1\>\/RI2 (  \
 N_SEL0\<1\>_XI2\<3\>\/XI2\<0\>\/XI2\<3\>\/XI2\<1\>\/RI2_pos WLSEL\<820\> ) \
 R_1X_LL w=1e-07 l=1e-07   res=0.149966
XXI2\<3\>\/XI2\<0\>\/XI2\<3\>\/XI2\<0\>\/RR2 (  \
 N_SEL3\<3\>_XI2\<3\>\/XI2\<0\>\/XI2\<3\>\/XI2\<0\>\/RR2_pos WLSEL\<819\> ) \
 R_1X_LL w=1e-07 l=1e-07   res=0.149966
XXI2\<3\>\/XI2\<0\>\/XI2\<3\>\/XI2\<0\>\/RR1 (  \
 N_SEL2\<0\>_XI2\<3\>\/XI2\<0\>\/XI2\<3\>\/XI2\<0\>\/RR1_pos WLSEL\<818\> ) \
 R_1X_LL w=1e-07 l=1e-07   res=0.149966
XXI2\<3\>\/XI2\<0\>\/XI2\<3\>\/XI2\<0\>\/RR0 (  \
 N_SEL1\<3\>_XI2\<3\>\/XI2\<0\>\/XI2\<3\>\/XI2\<0\>\/RR0_pos WLSEL\<817\> ) \
 R_1X_LL w=1e-07 l=1e-07   res=0.149966
XXI2\<3\>\/XI2\<0\>\/XI2\<3\>\/XI2\<0\>\/RI2 (  \
 N_SEL0\<0\>_XI2\<3\>\/XI2\<0\>\/XI2\<3\>\/XI2\<0\>\/RI2_pos WLSEL\<816\> ) \
 R_1X_LL w=1e-07 l=1e-07   res=0.149966
XXI2\<3\>\/XI2\<0\>\/XI2\<2\>\/XI2\<3\>\/RR2 (  \
 N_SEL3\<3\>_XI2\<3\>\/XI2\<0\>\/XI2\<2\>\/XI2\<3\>\/RR2_pos WLSEL\<815\> ) \
 R_1X_LL w=1e-07 l=1e-07   res=0.149966
XXI2\<3\>\/XI2\<0\>\/XI2\<2\>\/XI2\<3\>\/RR1 (  \
 N_SEL2\<0\>_XI2\<3\>\/XI2\<0\>\/XI2\<2\>\/XI2\<3\>\/RR1_pos WLSEL\<814\> ) \
 R_1X_LL w=1e-07 l=1e-07   res=0.149966
XXI2\<3\>\/XI2\<0\>\/XI2\<2\>\/XI2\<3\>\/RR0 (  \
 N_SEL1\<2\>_XI2\<3\>\/XI2\<0\>\/XI2\<2\>\/XI2\<3\>\/RR0_pos WLSEL\<813\> ) \
 R_1X_LL w=1e-07 l=1e-07   res=0.149966
XXI2\<3\>\/XI2\<0\>\/XI2\<2\>\/XI2\<3\>\/RI2 (  \
 N_SEL0\<3\>_XI2\<3\>\/XI2\<0\>\/XI2\<2\>\/XI2\<3\>\/RI2_pos WLSEL\<812\> ) \
 R_1X_LL w=1e-07 l=1e-07   res=0.149966
XXI2\<3\>\/XI2\<0\>\/XI2\<2\>\/XI2\<2\>\/RR2 (  \
 N_SEL3\<3\>_XI2\<3\>\/XI2\<0\>\/XI2\<2\>\/XI2\<2\>\/RR2_pos WLSEL\<811\> ) \
 R_1X_LL w=1e-07 l=1e-07   res=0.149966
XXI2\<3\>\/XI2\<0\>\/XI2\<2\>\/XI2\<2\>\/RR1 (  \
 N_SEL2\<0\>_XI2\<3\>\/XI2\<0\>\/XI2\<2\>\/XI2\<2\>\/RR1_pos WLSEL\<810\> ) \
 R_1X_LL w=1e-07 l=1e-07   res=0.149966
XXI2\<3\>\/XI2\<0\>\/XI2\<2\>\/XI2\<2\>\/RR0 (  \
 N_SEL1\<2\>_XI2\<3\>\/XI2\<0\>\/XI2\<2\>\/XI2\<2\>\/RR0_pos WLSEL\<809\> ) \
 R_1X_LL w=1e-07 l=1e-07   res=0.149966
XXI2\<3\>\/XI2\<0\>\/XI2\<2\>\/XI2\<2\>\/RI2 (  \
 N_SEL0\<2\>_XI2\<3\>\/XI2\<0\>\/XI2\<2\>\/XI2\<2\>\/RI2_pos WLSEL\<808\> ) \
 R_1X_LL w=1e-07 l=1e-07   res=0.149966
XXI2\<3\>\/XI2\<0\>\/XI2\<2\>\/XI2\<1\>\/RR2 (  \
 N_SEL3\<3\>_XI2\<3\>\/XI2\<0\>\/XI2\<2\>\/XI2\<1\>\/RR2_pos WLSEL\<807\> ) \
 R_1X_LL w=1e-07 l=1e-07   res=0.149966
XXI2\<3\>\/XI2\<0\>\/XI2\<2\>\/XI2\<1\>\/RR1 (  \
 N_SEL2\<0\>_XI2\<3\>\/XI2\<0\>\/XI2\<2\>\/XI2\<1\>\/RR1_pos WLSEL\<806\> ) \
 R_1X_LL w=1e-07 l=1e-07   res=0.149966
XXI2\<3\>\/XI2\<0\>\/XI2\<2\>\/XI2\<1\>\/RR0 (  \
 N_SEL1\<2\>_XI2\<3\>\/XI2\<0\>\/XI2\<2\>\/XI2\<1\>\/RR0_pos WLSEL\<805\> ) \
 R_1X_LL w=1e-07 l=1e-07   res=0.149966
XXI2\<3\>\/XI2\<0\>\/XI2\<2\>\/XI2\<1\>\/RI2 (  \
 N_SEL0\<1\>_XI2\<3\>\/XI2\<0\>\/XI2\<2\>\/XI2\<1\>\/RI2_pos WLSEL\<804\> ) \
 R_1X_LL w=1e-07 l=1e-07   res=0.149966
XXI2\<3\>\/XI2\<0\>\/XI2\<2\>\/XI2\<0\>\/RR2 (  \
 N_SEL3\<3\>_XI2\<3\>\/XI2\<0\>\/XI2\<2\>\/XI2\<0\>\/RR2_pos WLSEL\<803\> ) \
 R_1X_LL w=1e-07 l=1e-07   res=0.149966
XXI2\<3\>\/XI2\<0\>\/XI2\<2\>\/XI2\<0\>\/RR1 (  \
 N_SEL2\<0\>_XI2\<3\>\/XI2\<0\>\/XI2\<2\>\/XI2\<0\>\/RR1_pos WLSEL\<802\> ) \
 R_1X_LL w=1e-07 l=1e-07   res=0.149966
XXI2\<3\>\/XI2\<0\>\/XI2\<2\>\/XI2\<0\>\/RR0 (  \
 N_SEL1\<2\>_XI2\<3\>\/XI2\<0\>\/XI2\<2\>\/XI2\<0\>\/RR0_pos WLSEL\<801\> ) \
 R_1X_LL w=1e-07 l=1e-07   res=0.149966
XXI2\<3\>\/XI2\<0\>\/XI2\<2\>\/XI2\<0\>\/RI2 (  \
 N_SEL0\<0\>_XI2\<3\>\/XI2\<0\>\/XI2\<2\>\/XI2\<0\>\/RI2_pos WLSEL\<800\> ) \
 R_1X_LL w=1e-07 l=1e-07   res=0.149966
XXI2\<3\>\/XI2\<0\>\/XI2\<1\>\/XI2\<3\>\/RR2 (  \
 N_SEL3\<3\>_XI2\<3\>\/XI2\<0\>\/XI2\<1\>\/XI2\<3\>\/RR2_pos WLSEL\<799\> ) \
 R_1X_LL w=1e-07 l=1e-07   res=0.149966
XXI2\<3\>\/XI2\<0\>\/XI2\<1\>\/XI2\<3\>\/RR1 (  \
 N_SEL2\<0\>_XI2\<3\>\/XI2\<0\>\/XI2\<1\>\/XI2\<3\>\/RR1_pos WLSEL\<798\> ) \
 R_1X_LL w=1e-07 l=1e-07   res=0.149966
XXI2\<3\>\/XI2\<0\>\/XI2\<1\>\/XI2\<3\>\/RR0 (  \
 N_SEL1\<1\>_XI2\<3\>\/XI2\<0\>\/XI2\<1\>\/XI2\<3\>\/RR0_pos WLSEL\<797\> ) \
 R_1X_LL w=1e-07 l=1e-07   res=0.149966
XXI2\<3\>\/XI2\<0\>\/XI2\<1\>\/XI2\<3\>\/RI2 (  \
 N_SEL0\<3\>_XI2\<3\>\/XI2\<0\>\/XI2\<1\>\/XI2\<3\>\/RI2_pos WLSEL\<796\> ) \
 R_1X_LL w=1e-07 l=1e-07   res=0.149966
XXI2\<3\>\/XI2\<0\>\/XI2\<1\>\/XI2\<2\>\/RR2 (  \
 N_SEL3\<3\>_XI2\<3\>\/XI2\<0\>\/XI2\<1\>\/XI2\<2\>\/RR2_pos WLSEL\<795\> ) \
 R_1X_LL w=1e-07 l=1e-07   res=0.149966
XXI2\<3\>\/XI2\<0\>\/XI2\<1\>\/XI2\<2\>\/RR1 (  \
 N_SEL2\<0\>_XI2\<3\>\/XI2\<0\>\/XI2\<1\>\/XI2\<2\>\/RR1_pos WLSEL\<794\> ) \
 R_1X_LL w=1e-07 l=1e-07   res=0.149966
XXI2\<3\>\/XI2\<0\>\/XI2\<1\>\/XI2\<2\>\/RR0 (  \
 N_SEL1\<1\>_XI2\<3\>\/XI2\<0\>\/XI2\<1\>\/XI2\<2\>\/RR0_pos WLSEL\<793\> ) \
 R_1X_LL w=1e-07 l=1e-07   res=0.149966
XXI2\<3\>\/XI2\<0\>\/XI2\<1\>\/XI2\<2\>\/RI2 (  \
 N_SEL0\<2\>_XI2\<3\>\/XI2\<0\>\/XI2\<1\>\/XI2\<2\>\/RI2_pos WLSEL\<792\> ) \
 R_1X_LL w=1e-07 l=1e-07   res=0.149966
XXI2\<3\>\/XI2\<0\>\/XI2\<1\>\/XI2\<1\>\/RR2 (  \
 N_SEL3\<3\>_XI2\<3\>\/XI2\<0\>\/XI2\<1\>\/XI2\<1\>\/RR2_pos WLSEL\<791\> ) \
 R_1X_LL w=1e-07 l=1e-07   res=0.149966
XXI2\<3\>\/XI2\<0\>\/XI2\<1\>\/XI2\<1\>\/RR1 (  \
 N_SEL2\<0\>_XI2\<3\>\/XI2\<0\>\/XI2\<1\>\/XI2\<1\>\/RR1_pos WLSEL\<790\> ) \
 R_1X_LL w=1e-07 l=1e-07   res=0.149966
XXI2\<3\>\/XI2\<0\>\/XI2\<1\>\/XI2\<1\>\/RR0 (  \
 N_SEL1\<1\>_XI2\<3\>\/XI2\<0\>\/XI2\<1\>\/XI2\<1\>\/RR0_pos WLSEL\<789\> ) \
 R_1X_LL w=1e-07 l=1e-07   res=0.149966
XXI2\<3\>\/XI2\<0\>\/XI2\<1\>\/XI2\<1\>\/RI2 (  \
 N_SEL0\<1\>_XI2\<3\>\/XI2\<0\>\/XI2\<1\>\/XI2\<1\>\/RI2_pos WLSEL\<788\> ) \
 R_1X_LL w=1e-07 l=1e-07   res=0.149966
XXI2\<3\>\/XI2\<0\>\/XI2\<1\>\/XI2\<0\>\/RR2 (  \
 N_SEL3\<3\>_XI2\<3\>\/XI2\<0\>\/XI2\<1\>\/XI2\<0\>\/RR2_pos WLSEL\<787\> ) \
 R_1X_LL w=1e-07 l=1e-07   res=0.149966
XXI2\<3\>\/XI2\<0\>\/XI2\<1\>\/XI2\<0\>\/RR1 (  \
 N_SEL2\<0\>_XI2\<3\>\/XI2\<0\>\/XI2\<1\>\/XI2\<0\>\/RR1_pos WLSEL\<786\> ) \
 R_1X_LL w=1e-07 l=1e-07   res=0.149966
XXI2\<3\>\/XI2\<0\>\/XI2\<1\>\/XI2\<0\>\/RR0 (  \
 N_SEL1\<1\>_XI2\<3\>\/XI2\<0\>\/XI2\<1\>\/XI2\<0\>\/RR0_pos WLSEL\<785\> ) \
 R_1X_LL w=1e-07 l=1e-07   res=0.149966
XXI2\<3\>\/XI2\<0\>\/XI2\<1\>\/XI2\<0\>\/RI2 (  \
 N_SEL0\<0\>_XI2\<3\>\/XI2\<0\>\/XI2\<1\>\/XI2\<0\>\/RI2_pos WLSEL\<784\> ) \
 R_1X_LL w=1e-07 l=1e-07   res=0.149966
XXI2\<3\>\/XI2\<0\>\/XI2\<0\>\/XI2\<3\>\/RR2 (  \
 N_SEL3\<3\>_XI2\<3\>\/XI2\<0\>\/XI2\<0\>\/XI2\<3\>\/RR2_pos WLSEL\<783\> ) \
 R_1X_LL w=1e-07 l=1e-07   res=0.149966
XXI2\<3\>\/XI2\<0\>\/XI2\<0\>\/XI2\<3\>\/RR1 (  \
 N_SEL2\<0\>_XI2\<3\>\/XI2\<0\>\/XI2\<0\>\/XI2\<3\>\/RR1_pos WLSEL\<782\> ) \
 R_1X_LL w=1e-07 l=1e-07   res=0.149966
XXI2\<3\>\/XI2\<0\>\/XI2\<0\>\/XI2\<3\>\/RR0 (  \
 N_SEL1\<0\>_XI2\<3\>\/XI2\<0\>\/XI2\<0\>\/XI2\<3\>\/RR0_pos WLSEL\<781\> ) \
 R_1X_LL w=1e-07 l=1e-07   res=0.149966
XXI2\<3\>\/XI2\<0\>\/XI2\<0\>\/XI2\<3\>\/RI2 (  \
 N_SEL0\<3\>_XI2\<3\>\/XI2\<0\>\/XI2\<0\>\/XI2\<3\>\/RI2_pos WLSEL\<780\> ) \
 R_1X_LL w=1e-07 l=1e-07   res=0.149966
XXI2\<3\>\/XI2\<0\>\/XI2\<0\>\/XI2\<2\>\/RR2 (  \
 N_SEL3\<3\>_XI2\<3\>\/XI2\<0\>\/XI2\<0\>\/XI2\<2\>\/RR2_pos WLSEL\<779\> ) \
 R_1X_LL w=1e-07 l=1e-07   res=0.149966
XXI2\<3\>\/XI2\<0\>\/XI2\<0\>\/XI2\<2\>\/RR1 (  \
 N_SEL2\<0\>_XI2\<3\>\/XI2\<0\>\/XI2\<0\>\/XI2\<2\>\/RR1_pos WLSEL\<778\> ) \
 R_1X_LL w=1e-07 l=1e-07   res=0.149966
XXI2\<3\>\/XI2\<0\>\/XI2\<0\>\/XI2\<2\>\/RR0 (  \
 N_SEL1\<0\>_XI2\<3\>\/XI2\<0\>\/XI2\<0\>\/XI2\<2\>\/RR0_pos WLSEL\<777\> ) \
 R_1X_LL w=1e-07 l=1e-07   res=0.149966
XXI2\<3\>\/XI2\<0\>\/XI2\<0\>\/XI2\<2\>\/RI2 (  \
 N_SEL0\<2\>_XI2\<3\>\/XI2\<0\>\/XI2\<0\>\/XI2\<2\>\/RI2_pos WLSEL\<776\> ) \
 R_1X_LL w=1e-07 l=1e-07   res=0.149966
XXI2\<3\>\/XI2\<0\>\/XI2\<0\>\/XI2\<1\>\/RR2 (  \
 N_SEL3\<3\>_XI2\<3\>\/XI2\<0\>\/XI2\<0\>\/XI2\<1\>\/RR2_pos WLSEL\<775\> ) \
 R_1X_LL w=1e-07 l=1e-07   res=0.149966
XXI2\<3\>\/XI2\<0\>\/XI2\<0\>\/XI2\<1\>\/RR1 (  \
 N_SEL2\<0\>_XI2\<3\>\/XI2\<0\>\/XI2\<0\>\/XI2\<1\>\/RR1_pos WLSEL\<774\> ) \
 R_1X_LL w=1e-07 l=1e-07   res=0.149966
XXI2\<3\>\/XI2\<0\>\/XI2\<0\>\/XI2\<1\>\/RR0 (  \
 N_SEL1\<0\>_XI2\<3\>\/XI2\<0\>\/XI2\<0\>\/XI2\<1\>\/RR0_pos WLSEL\<773\> ) \
 R_1X_LL w=1e-07 l=1e-07   res=0.149966
XXI2\<3\>\/XI2\<0\>\/XI2\<0\>\/XI2\<1\>\/RI2 (  \
 N_SEL0\<1\>_XI2\<3\>\/XI2\<0\>\/XI2\<0\>\/XI2\<1\>\/RI2_pos WLSEL\<772\> ) \
 R_1X_LL w=1e-07 l=1e-07   res=0.149966
XXI2\<3\>\/XI2\<0\>\/XI2\<0\>\/XI2\<0\>\/RR2 (  \
 N_SEL3\<3\>_XI2\<3\>\/XI2\<0\>\/XI2\<0\>\/XI2\<0\>\/RR2_pos WLSEL\<771\> ) \
 R_1X_LL w=1e-07 l=1e-07   res=0.149966
XXI2\<3\>\/XI2\<0\>\/XI2\<0\>\/XI2\<0\>\/RR1 (  \
 N_SEL2\<0\>_XI2\<3\>\/XI2\<0\>\/XI2\<0\>\/XI2\<0\>\/RR1_pos WLSEL\<770\> ) \
 R_1X_LL w=1e-07 l=1e-07   res=0.149966
XXI2\<3\>\/XI2\<0\>\/XI2\<0\>\/XI2\<0\>\/RR0 (  \
 N_SEL1\<0\>_XI2\<3\>\/XI2\<0\>\/XI2\<0\>\/XI2\<0\>\/RR0_pos WLSEL\<769\> ) \
 R_1X_LL w=1e-07 l=1e-07   res=0.149966
XXI2\<3\>\/XI2\<0\>\/XI2\<0\>\/XI2\<0\>\/RI2 (  \
 N_SEL0\<0\>_XI2\<3\>\/XI2\<0\>\/XI2\<0\>\/XI2\<0\>\/RI2_pos WLSEL\<768\> ) \
 R_1X_LL w=1e-07 l=1e-07   res=0.149966
XXI2\<2\>\/XI2\<3\>\/XI2\<3\>\/XI2\<3\>\/RR2 (  \
 N_SEL3\<2\>_XI2\<2\>\/XI2\<3\>\/XI2\<3\>\/XI2\<3\>\/RR2_pos WLSEL\<767\> ) \
 R_1X_LL w=1e-07 l=1e-07   res=0.149966
XXI2\<2\>\/XI2\<3\>\/XI2\<3\>\/XI2\<3\>\/RR1 (  \
 N_SEL2\<3\>_XI2\<2\>\/XI2\<3\>\/XI2\<3\>\/XI2\<3\>\/RR1_pos WLSEL\<766\> ) \
 R_1X_LL w=1e-07 l=1e-07   res=0.149966
XXI2\<2\>\/XI2\<3\>\/XI2\<3\>\/XI2\<3\>\/RR0 (  \
 N_SEL1\<3\>_XI2\<2\>\/XI2\<3\>\/XI2\<3\>\/XI2\<3\>\/RR0_pos WLSEL\<765\> ) \
 R_1X_LL w=1e-07 l=1e-07   res=0.149966
XXI2\<2\>\/XI2\<3\>\/XI2\<3\>\/XI2\<3\>\/RI2 (  \
 N_SEL0\<3\>_XI2\<2\>\/XI2\<3\>\/XI2\<3\>\/XI2\<3\>\/RI2_pos WLSEL\<764\> ) \
 R_1X_LL w=1e-07 l=1e-07   res=0.149966
XXI2\<2\>\/XI2\<3\>\/XI2\<3\>\/XI2\<2\>\/RR2 (  \
 N_SEL3\<2\>_XI2\<2\>\/XI2\<3\>\/XI2\<3\>\/XI2\<2\>\/RR2_pos WLSEL\<763\> ) \
 R_1X_LL w=1e-07 l=1e-07   res=0.149966
XXI2\<2\>\/XI2\<3\>\/XI2\<3\>\/XI2\<2\>\/RR1 (  \
 N_SEL2\<3\>_XI2\<2\>\/XI2\<3\>\/XI2\<3\>\/XI2\<2\>\/RR1_pos WLSEL\<762\> ) \
 R_1X_LL w=1e-07 l=1e-07   res=0.149966
XXI2\<2\>\/XI2\<3\>\/XI2\<3\>\/XI2\<2\>\/RR0 (  \
 N_SEL1\<3\>_XI2\<2\>\/XI2\<3\>\/XI2\<3\>\/XI2\<2\>\/RR0_pos WLSEL\<761\> ) \
 R_1X_LL w=1e-07 l=1e-07   res=0.149966
XXI2\<2\>\/XI2\<3\>\/XI2\<3\>\/XI2\<2\>\/RI2 (  \
 N_SEL0\<2\>_XI2\<2\>\/XI2\<3\>\/XI2\<3\>\/XI2\<2\>\/RI2_pos WLSEL\<760\> ) \
 R_1X_LL w=1e-07 l=1e-07   res=0.149966
XXI2\<2\>\/XI2\<3\>\/XI2\<3\>\/XI2\<1\>\/RR2 (  \
 N_SEL3\<2\>_XI2\<2\>\/XI2\<3\>\/XI2\<3\>\/XI2\<1\>\/RR2_pos WLSEL\<759\> ) \
 R_1X_LL w=1e-07 l=1e-07   res=0.149966
XXI2\<2\>\/XI2\<3\>\/XI2\<3\>\/XI2\<1\>\/RR1 (  \
 N_SEL2\<3\>_XI2\<2\>\/XI2\<3\>\/XI2\<3\>\/XI2\<1\>\/RR1_pos WLSEL\<758\> ) \
 R_1X_LL w=1e-07 l=1e-07   res=0.149966
XXI2\<2\>\/XI2\<3\>\/XI2\<3\>\/XI2\<1\>\/RR0 (  \
 N_SEL1\<3\>_XI2\<2\>\/XI2\<3\>\/XI2\<3\>\/XI2\<1\>\/RR0_pos WLSEL\<757\> ) \
 R_1X_LL w=1e-07 l=1e-07   res=0.149966
XXI2\<2\>\/XI2\<3\>\/XI2\<3\>\/XI2\<1\>\/RI2 (  \
 N_SEL0\<1\>_XI2\<2\>\/XI2\<3\>\/XI2\<3\>\/XI2\<1\>\/RI2_pos WLSEL\<756\> ) \
 R_1X_LL w=1e-07 l=1e-07   res=0.149966
XXI2\<2\>\/XI2\<3\>\/XI2\<3\>\/XI2\<0\>\/RR2 (  \
 N_SEL3\<2\>_XI2\<2\>\/XI2\<3\>\/XI2\<3\>\/XI2\<0\>\/RR2_pos WLSEL\<755\> ) \
 R_1X_LL w=1e-07 l=1e-07   res=0.149966
XXI2\<2\>\/XI2\<3\>\/XI2\<3\>\/XI2\<0\>\/RR1 (  \
 N_SEL2\<3\>_XI2\<2\>\/XI2\<3\>\/XI2\<3\>\/XI2\<0\>\/RR1_pos WLSEL\<754\> ) \
 R_1X_LL w=1e-07 l=1e-07   res=0.149966
XXI2\<2\>\/XI2\<3\>\/XI2\<3\>\/XI2\<0\>\/RR0 (  \
 N_SEL1\<3\>_XI2\<2\>\/XI2\<3\>\/XI2\<3\>\/XI2\<0\>\/RR0_pos WLSEL\<753\> ) \
 R_1X_LL w=1e-07 l=1e-07   res=0.149966
XXI2\<2\>\/XI2\<3\>\/XI2\<3\>\/XI2\<0\>\/RI2 (  \
 N_SEL0\<0\>_XI2\<2\>\/XI2\<3\>\/XI2\<3\>\/XI2\<0\>\/RI2_pos WLSEL\<752\> ) \
 R_1X_LL w=1e-07 l=1e-07   res=0.149966
XXI2\<2\>\/XI2\<3\>\/XI2\<2\>\/XI2\<3\>\/RR2 (  \
 N_SEL3\<2\>_XI2\<2\>\/XI2\<3\>\/XI2\<2\>\/XI2\<3\>\/RR2_pos WLSEL\<751\> ) \
 R_1X_LL w=1e-07 l=1e-07   res=0.149966
XXI2\<2\>\/XI2\<3\>\/XI2\<2\>\/XI2\<3\>\/RR1 (  \
 N_SEL2\<3\>_XI2\<2\>\/XI2\<3\>\/XI2\<2\>\/XI2\<3\>\/RR1_pos WLSEL\<750\> ) \
 R_1X_LL w=1e-07 l=1e-07   res=0.149966
XXI2\<2\>\/XI2\<3\>\/XI2\<2\>\/XI2\<3\>\/RR0 (  \
 N_SEL1\<2\>_XI2\<2\>\/XI2\<3\>\/XI2\<2\>\/XI2\<3\>\/RR0_pos WLSEL\<749\> ) \
 R_1X_LL w=1e-07 l=1e-07   res=0.149966
XXI2\<2\>\/XI2\<3\>\/XI2\<2\>\/XI2\<3\>\/RI2 (  \
 N_SEL0\<3\>_XI2\<2\>\/XI2\<3\>\/XI2\<2\>\/XI2\<3\>\/RI2_pos WLSEL\<748\> ) \
 R_1X_LL w=1e-07 l=1e-07   res=0.149966
XXI2\<2\>\/XI2\<3\>\/XI2\<2\>\/XI2\<2\>\/RR2 (  \
 N_SEL3\<2\>_XI2\<2\>\/XI2\<3\>\/XI2\<2\>\/XI2\<2\>\/RR2_pos WLSEL\<747\> ) \
 R_1X_LL w=1e-07 l=1e-07   res=0.149966
XXI2\<2\>\/XI2\<3\>\/XI2\<2\>\/XI2\<2\>\/RR1 (  \
 N_SEL2\<3\>_XI2\<2\>\/XI2\<3\>\/XI2\<2\>\/XI2\<2\>\/RR1_pos WLSEL\<746\> ) \
 R_1X_LL w=1e-07 l=1e-07   res=0.149966
XXI2\<2\>\/XI2\<3\>\/XI2\<2\>\/XI2\<2\>\/RR0 (  \
 N_SEL1\<2\>_XI2\<2\>\/XI2\<3\>\/XI2\<2\>\/XI2\<2\>\/RR0_pos WLSEL\<745\> ) \
 R_1X_LL w=1e-07 l=1e-07   res=0.149966
XXI2\<2\>\/XI2\<3\>\/XI2\<2\>\/XI2\<2\>\/RI2 (  \
 N_SEL0\<2\>_XI2\<2\>\/XI2\<3\>\/XI2\<2\>\/XI2\<2\>\/RI2_pos WLSEL\<744\> ) \
 R_1X_LL w=1e-07 l=1e-07   res=0.149966
XXI2\<2\>\/XI2\<3\>\/XI2\<2\>\/XI2\<1\>\/RR2 (  \
 N_SEL3\<2\>_XI2\<2\>\/XI2\<3\>\/XI2\<2\>\/XI2\<1\>\/RR2_pos WLSEL\<743\> ) \
 R_1X_LL w=1e-07 l=1e-07   res=0.149966
XXI2\<2\>\/XI2\<3\>\/XI2\<2\>\/XI2\<1\>\/RR1 (  \
 N_SEL2\<3\>_XI2\<2\>\/XI2\<3\>\/XI2\<2\>\/XI2\<1\>\/RR1_pos WLSEL\<742\> ) \
 R_1X_LL w=1e-07 l=1e-07   res=0.149966
XXI2\<2\>\/XI2\<3\>\/XI2\<2\>\/XI2\<1\>\/RR0 (  \
 N_SEL1\<2\>_XI2\<2\>\/XI2\<3\>\/XI2\<2\>\/XI2\<1\>\/RR0_pos WLSEL\<741\> ) \
 R_1X_LL w=1e-07 l=1e-07   res=0.149966
XXI2\<2\>\/XI2\<3\>\/XI2\<2\>\/XI2\<1\>\/RI2 (  \
 N_SEL0\<1\>_XI2\<2\>\/XI2\<3\>\/XI2\<2\>\/XI2\<1\>\/RI2_pos WLSEL\<740\> ) \
 R_1X_LL w=1e-07 l=1e-07   res=0.149966
XXI2\<2\>\/XI2\<3\>\/XI2\<2\>\/XI2\<0\>\/RR2 (  \
 N_SEL3\<2\>_XI2\<2\>\/XI2\<3\>\/XI2\<2\>\/XI2\<0\>\/RR2_pos WLSEL\<739\> ) \
 R_1X_LL w=1e-07 l=1e-07   res=0.149966
XXI2\<2\>\/XI2\<3\>\/XI2\<2\>\/XI2\<0\>\/RR1 (  \
 N_SEL2\<3\>_XI2\<2\>\/XI2\<3\>\/XI2\<2\>\/XI2\<0\>\/RR1_pos WLSEL\<738\> ) \
 R_1X_LL w=1e-07 l=1e-07   res=0.149966
XXI2\<2\>\/XI2\<3\>\/XI2\<2\>\/XI2\<0\>\/RR0 (  \
 N_SEL1\<2\>_XI2\<2\>\/XI2\<3\>\/XI2\<2\>\/XI2\<0\>\/RR0_pos WLSEL\<737\> ) \
 R_1X_LL w=1e-07 l=1e-07   res=0.149966
XXI2\<2\>\/XI2\<3\>\/XI2\<2\>\/XI2\<0\>\/RI2 (  \
 N_SEL0\<0\>_XI2\<2\>\/XI2\<3\>\/XI2\<2\>\/XI2\<0\>\/RI2_pos WLSEL\<736\> ) \
 R_1X_LL w=1e-07 l=1e-07   res=0.149966
XXI2\<2\>\/XI2\<3\>\/XI2\<1\>\/XI2\<3\>\/RR2 (  \
 N_SEL3\<2\>_XI2\<2\>\/XI2\<3\>\/XI2\<1\>\/XI2\<3\>\/RR2_pos WLSEL\<735\> ) \
 R_1X_LL w=1e-07 l=1e-07   res=0.149966
XXI2\<2\>\/XI2\<3\>\/XI2\<1\>\/XI2\<3\>\/RR1 (  \
 N_SEL2\<3\>_XI2\<2\>\/XI2\<3\>\/XI2\<1\>\/XI2\<3\>\/RR1_pos WLSEL\<734\> ) \
 R_1X_LL w=1e-07 l=1e-07   res=0.149966
XXI2\<2\>\/XI2\<3\>\/XI2\<1\>\/XI2\<3\>\/RR0 (  \
 N_SEL1\<1\>_XI2\<2\>\/XI2\<3\>\/XI2\<1\>\/XI2\<3\>\/RR0_pos WLSEL\<733\> ) \
 R_1X_LL w=1e-07 l=1e-07   res=0.149966
XXI2\<2\>\/XI2\<3\>\/XI2\<1\>\/XI2\<3\>\/RI2 (  \
 N_SEL0\<3\>_XI2\<2\>\/XI2\<3\>\/XI2\<1\>\/XI2\<3\>\/RI2_pos WLSEL\<732\> ) \
 R_1X_LL w=1e-07 l=1e-07   res=0.149966
XXI2\<2\>\/XI2\<3\>\/XI2\<1\>\/XI2\<2\>\/RR2 (  \
 N_SEL3\<2\>_XI2\<2\>\/XI2\<3\>\/XI2\<1\>\/XI2\<2\>\/RR2_pos WLSEL\<731\> ) \
 R_1X_LL w=1e-07 l=1e-07   res=0.149966
XXI2\<2\>\/XI2\<3\>\/XI2\<1\>\/XI2\<2\>\/RR1 (  \
 N_SEL2\<3\>_XI2\<2\>\/XI2\<3\>\/XI2\<1\>\/XI2\<2\>\/RR1_pos WLSEL\<730\> ) \
 R_1X_LL w=1e-07 l=1e-07   res=0.149966
XXI2\<2\>\/XI2\<3\>\/XI2\<1\>\/XI2\<2\>\/RR0 (  \
 N_SEL1\<1\>_XI2\<2\>\/XI2\<3\>\/XI2\<1\>\/XI2\<2\>\/RR0_pos WLSEL\<729\> ) \
 R_1X_LL w=1e-07 l=1e-07   res=0.149966
XXI2\<2\>\/XI2\<3\>\/XI2\<1\>\/XI2\<2\>\/RI2 (  \
 N_SEL0\<2\>_XI2\<2\>\/XI2\<3\>\/XI2\<1\>\/XI2\<2\>\/RI2_pos WLSEL\<728\> ) \
 R_1X_LL w=1e-07 l=1e-07   res=0.149966
XXI2\<2\>\/XI2\<3\>\/XI2\<1\>\/XI2\<1\>\/RR2 (  \
 N_SEL3\<2\>_XI2\<2\>\/XI2\<3\>\/XI2\<1\>\/XI2\<1\>\/RR2_pos WLSEL\<727\> ) \
 R_1X_LL w=1e-07 l=1e-07   res=0.149966
XXI2\<2\>\/XI2\<3\>\/XI2\<1\>\/XI2\<1\>\/RR1 (  \
 N_SEL2\<3\>_XI2\<2\>\/XI2\<3\>\/XI2\<1\>\/XI2\<1\>\/RR1_pos WLSEL\<726\> ) \
 R_1X_LL w=1e-07 l=1e-07   res=0.149966
XXI2\<2\>\/XI2\<3\>\/XI2\<1\>\/XI2\<1\>\/RR0 (  \
 N_SEL1\<1\>_XI2\<2\>\/XI2\<3\>\/XI2\<1\>\/XI2\<1\>\/RR0_pos WLSEL\<725\> ) \
 R_1X_LL w=1e-07 l=1e-07   res=0.149966
XXI2\<2\>\/XI2\<3\>\/XI2\<1\>\/XI2\<1\>\/RI2 (  \
 N_SEL0\<1\>_XI2\<2\>\/XI2\<3\>\/XI2\<1\>\/XI2\<1\>\/RI2_pos WLSEL\<724\> ) \
 R_1X_LL w=1e-07 l=1e-07   res=0.149966
XXI2\<2\>\/XI2\<3\>\/XI2\<1\>\/XI2\<0\>\/RR2 (  \
 N_SEL3\<2\>_XI2\<2\>\/XI2\<3\>\/XI2\<1\>\/XI2\<0\>\/RR2_pos WLSEL\<723\> ) \
 R_1X_LL w=1e-07 l=1e-07   res=0.149966
XXI2\<2\>\/XI2\<3\>\/XI2\<1\>\/XI2\<0\>\/RR1 (  \
 N_SEL2\<3\>_XI2\<2\>\/XI2\<3\>\/XI2\<1\>\/XI2\<0\>\/RR1_pos WLSEL\<722\> ) \
 R_1X_LL w=1e-07 l=1e-07   res=0.149966
XXI2\<2\>\/XI2\<3\>\/XI2\<1\>\/XI2\<0\>\/RR0 (  \
 N_SEL1\<1\>_XI2\<2\>\/XI2\<3\>\/XI2\<1\>\/XI2\<0\>\/RR0_pos WLSEL\<721\> ) \
 R_1X_LL w=1e-07 l=1e-07   res=0.149966
XXI2\<2\>\/XI2\<3\>\/XI2\<1\>\/XI2\<0\>\/RI2 (  \
 N_SEL0\<0\>_XI2\<2\>\/XI2\<3\>\/XI2\<1\>\/XI2\<0\>\/RI2_pos WLSEL\<720\> ) \
 R_1X_LL w=1e-07 l=1e-07   res=0.149966
XXI2\<2\>\/XI2\<3\>\/XI2\<0\>\/XI2\<3\>\/RR2 (  \
 N_SEL3\<2\>_XI2\<2\>\/XI2\<3\>\/XI2\<0\>\/XI2\<3\>\/RR2_pos WLSEL\<719\> ) \
 R_1X_LL w=1e-07 l=1e-07   res=0.149966
XXI2\<2\>\/XI2\<3\>\/XI2\<0\>\/XI2\<3\>\/RR1 (  \
 N_SEL2\<3\>_XI2\<2\>\/XI2\<3\>\/XI2\<0\>\/XI2\<3\>\/RR1_pos WLSEL\<718\> ) \
 R_1X_LL w=1e-07 l=1e-07   res=0.149966
XXI2\<2\>\/XI2\<3\>\/XI2\<0\>\/XI2\<3\>\/RR0 (  \
 N_SEL1\<0\>_XI2\<2\>\/XI2\<3\>\/XI2\<0\>\/XI2\<3\>\/RR0_pos WLSEL\<717\> ) \
 R_1X_LL w=1e-07 l=1e-07   res=0.149966
XXI2\<2\>\/XI2\<3\>\/XI2\<0\>\/XI2\<3\>\/RI2 (  \
 N_SEL0\<3\>_XI2\<2\>\/XI2\<3\>\/XI2\<0\>\/XI2\<3\>\/RI2_pos WLSEL\<716\> ) \
 R_1X_LL w=1e-07 l=1e-07   res=0.149966
XXI2\<2\>\/XI2\<3\>\/XI2\<0\>\/XI2\<2\>\/RR2 (  \
 N_SEL3\<2\>_XI2\<2\>\/XI2\<3\>\/XI2\<0\>\/XI2\<2\>\/RR2_pos WLSEL\<715\> ) \
 R_1X_LL w=1e-07 l=1e-07   res=0.149966
XXI2\<2\>\/XI2\<3\>\/XI2\<0\>\/XI2\<2\>\/RR1 (  \
 N_SEL2\<3\>_XI2\<2\>\/XI2\<3\>\/XI2\<0\>\/XI2\<2\>\/RR1_pos WLSEL\<714\> ) \
 R_1X_LL w=1e-07 l=1e-07   res=0.149966
XXI2\<2\>\/XI2\<3\>\/XI2\<0\>\/XI2\<2\>\/RR0 (  \
 N_SEL1\<0\>_XI2\<2\>\/XI2\<3\>\/XI2\<0\>\/XI2\<2\>\/RR0_pos WLSEL\<713\> ) \
 R_1X_LL w=1e-07 l=1e-07   res=0.149966
XXI2\<2\>\/XI2\<3\>\/XI2\<0\>\/XI2\<2\>\/RI2 (  \
 N_SEL0\<2\>_XI2\<2\>\/XI2\<3\>\/XI2\<0\>\/XI2\<2\>\/RI2_pos WLSEL\<712\> ) \
 R_1X_LL w=1e-07 l=1e-07   res=0.149966
XXI2\<2\>\/XI2\<3\>\/XI2\<0\>\/XI2\<1\>\/RR2 (  \
 N_SEL3\<2\>_XI2\<2\>\/XI2\<3\>\/XI2\<0\>\/XI2\<1\>\/RR2_pos WLSEL\<711\> ) \
 R_1X_LL w=1e-07 l=1e-07   res=0.149966
XXI2\<2\>\/XI2\<3\>\/XI2\<0\>\/XI2\<1\>\/RR1 (  \
 N_SEL2\<3\>_XI2\<2\>\/XI2\<3\>\/XI2\<0\>\/XI2\<1\>\/RR1_pos WLSEL\<710\> ) \
 R_1X_LL w=1e-07 l=1e-07   res=0.149966
XXI2\<2\>\/XI2\<3\>\/XI2\<0\>\/XI2\<1\>\/RR0 (  \
 N_SEL1\<0\>_XI2\<2\>\/XI2\<3\>\/XI2\<0\>\/XI2\<1\>\/RR0_pos WLSEL\<709\> ) \
 R_1X_LL w=1e-07 l=1e-07   res=0.149966
XXI2\<2\>\/XI2\<3\>\/XI2\<0\>\/XI2\<1\>\/RI2 (  \
 N_SEL0\<1\>_XI2\<2\>\/XI2\<3\>\/XI2\<0\>\/XI2\<1\>\/RI2_pos WLSEL\<708\> ) \
 R_1X_LL w=1e-07 l=1e-07   res=0.149966
XXI2\<2\>\/XI2\<3\>\/XI2\<0\>\/XI2\<0\>\/RR2 (  \
 N_SEL3\<2\>_XI2\<2\>\/XI2\<3\>\/XI2\<0\>\/XI2\<0\>\/RR2_pos WLSEL\<707\> ) \
 R_1X_LL w=1e-07 l=1e-07   res=0.149966
XXI2\<2\>\/XI2\<3\>\/XI2\<0\>\/XI2\<0\>\/RR1 (  \
 N_SEL2\<3\>_XI2\<2\>\/XI2\<3\>\/XI2\<0\>\/XI2\<0\>\/RR1_pos WLSEL\<706\> ) \
 R_1X_LL w=1e-07 l=1e-07   res=0.149966
XXI2\<2\>\/XI2\<3\>\/XI2\<0\>\/XI2\<0\>\/RR0 (  \
 N_SEL1\<0\>_XI2\<2\>\/XI2\<3\>\/XI2\<0\>\/XI2\<0\>\/RR0_pos WLSEL\<705\> ) \
 R_1X_LL w=1e-07 l=1e-07   res=0.149966
XXI2\<2\>\/XI2\<3\>\/XI2\<0\>\/XI2\<0\>\/RI2 (  \
 N_SEL0\<0\>_XI2\<2\>\/XI2\<3\>\/XI2\<0\>\/XI2\<0\>\/RI2_pos WLSEL\<704\> ) \
 R_1X_LL w=1e-07 l=1e-07   res=0.149966
XXI2\<2\>\/XI2\<2\>\/XI2\<3\>\/XI2\<3\>\/RR2 (  \
 N_SEL3\<2\>_XI2\<2\>\/XI2\<2\>\/XI2\<3\>\/XI2\<3\>\/RR2_pos WLSEL\<703\> ) \
 R_1X_LL w=1e-07 l=1e-07   res=0.149966
XXI2\<2\>\/XI2\<2\>\/XI2\<3\>\/XI2\<3\>\/RR1 (  \
 N_SEL2\<2\>_XI2\<2\>\/XI2\<2\>\/XI2\<3\>\/XI2\<3\>\/RR1_pos WLSEL\<702\> ) \
 R_1X_LL w=1e-07 l=1e-07   res=0.149966
XXI2\<2\>\/XI2\<2\>\/XI2\<3\>\/XI2\<3\>\/RR0 (  \
 N_SEL1\<3\>_XI2\<2\>\/XI2\<2\>\/XI2\<3\>\/XI2\<3\>\/RR0_pos WLSEL\<701\> ) \
 R_1X_LL w=1e-07 l=1e-07   res=0.149966
XXI2\<2\>\/XI2\<2\>\/XI2\<3\>\/XI2\<3\>\/RI2 (  \
 N_SEL0\<3\>_XI2\<2\>\/XI2\<2\>\/XI2\<3\>\/XI2\<3\>\/RI2_pos WLSEL\<700\> ) \
 R_1X_LL w=1e-07 l=1e-07   res=0.149966
XXI2\<2\>\/XI2\<2\>\/XI2\<3\>\/XI2\<2\>\/RR2 (  \
 N_SEL3\<2\>_XI2\<2\>\/XI2\<2\>\/XI2\<3\>\/XI2\<2\>\/RR2_pos WLSEL\<699\> ) \
 R_1X_LL w=1e-07 l=1e-07   res=0.149966
XXI2\<2\>\/XI2\<2\>\/XI2\<3\>\/XI2\<2\>\/RR1 (  \
 N_SEL2\<2\>_XI2\<2\>\/XI2\<2\>\/XI2\<3\>\/XI2\<2\>\/RR1_pos WLSEL\<698\> ) \
 R_1X_LL w=1e-07 l=1e-07   res=0.149966
XXI2\<2\>\/XI2\<2\>\/XI2\<3\>\/XI2\<2\>\/RR0 (  \
 N_SEL1\<3\>_XI2\<2\>\/XI2\<2\>\/XI2\<3\>\/XI2\<2\>\/RR0_pos WLSEL\<697\> ) \
 R_1X_LL w=1e-07 l=1e-07   res=0.149966
XXI2\<2\>\/XI2\<2\>\/XI2\<3\>\/XI2\<2\>\/RI2 (  \
 N_SEL0\<2\>_XI2\<2\>\/XI2\<2\>\/XI2\<3\>\/XI2\<2\>\/RI2_pos WLSEL\<696\> ) \
 R_1X_LL w=1e-07 l=1e-07   res=0.149966
XXI2\<2\>\/XI2\<2\>\/XI2\<3\>\/XI2\<1\>\/RR2 (  \
 N_SEL3\<2\>_XI2\<2\>\/XI2\<2\>\/XI2\<3\>\/XI2\<1\>\/RR2_pos WLSEL\<695\> ) \
 R_1X_LL w=1e-07 l=1e-07   res=0.149966
XXI2\<2\>\/XI2\<2\>\/XI2\<3\>\/XI2\<1\>\/RR1 (  \
 N_SEL2\<2\>_XI2\<2\>\/XI2\<2\>\/XI2\<3\>\/XI2\<1\>\/RR1_pos WLSEL\<694\> ) \
 R_1X_LL w=1e-07 l=1e-07   res=0.149966
XXI2\<2\>\/XI2\<2\>\/XI2\<3\>\/XI2\<1\>\/RR0 (  \
 N_SEL1\<3\>_XI2\<2\>\/XI2\<2\>\/XI2\<3\>\/XI2\<1\>\/RR0_pos WLSEL\<693\> ) \
 R_1X_LL w=1e-07 l=1e-07   res=0.149966
XXI2\<2\>\/XI2\<2\>\/XI2\<3\>\/XI2\<1\>\/RI2 (  \
 N_SEL0\<1\>_XI2\<2\>\/XI2\<2\>\/XI2\<3\>\/XI2\<1\>\/RI2_pos WLSEL\<692\> ) \
 R_1X_LL w=1e-07 l=1e-07   res=0.149966
XXI2\<2\>\/XI2\<2\>\/XI2\<3\>\/XI2\<0\>\/RR2 (  \
 N_SEL3\<2\>_XI2\<2\>\/XI2\<2\>\/XI2\<3\>\/XI2\<0\>\/RR2_pos WLSEL\<691\> ) \
 R_1X_LL w=1e-07 l=1e-07   res=0.149966
XXI2\<2\>\/XI2\<2\>\/XI2\<3\>\/XI2\<0\>\/RR1 (  \
 N_SEL2\<2\>_XI2\<2\>\/XI2\<2\>\/XI2\<3\>\/XI2\<0\>\/RR1_pos WLSEL\<690\> ) \
 R_1X_LL w=1e-07 l=1e-07   res=0.149966
XXI2\<2\>\/XI2\<2\>\/XI2\<3\>\/XI2\<0\>\/RR0 (  \
 N_SEL1\<3\>_XI2\<2\>\/XI2\<2\>\/XI2\<3\>\/XI2\<0\>\/RR0_pos WLSEL\<689\> ) \
 R_1X_LL w=1e-07 l=1e-07   res=0.149966
XXI2\<2\>\/XI2\<2\>\/XI2\<3\>\/XI2\<0\>\/RI2 (  \
 N_SEL0\<0\>_XI2\<2\>\/XI2\<2\>\/XI2\<3\>\/XI2\<0\>\/RI2_pos WLSEL\<688\> ) \
 R_1X_LL w=1e-07 l=1e-07   res=0.149966
XXI2\<2\>\/XI2\<2\>\/XI2\<2\>\/XI2\<3\>\/RR2 (  \
 N_SEL3\<2\>_XI2\<2\>\/XI2\<2\>\/XI2\<2\>\/XI2\<3\>\/RR2_pos WLSEL\<687\> ) \
 R_1X_LL w=1e-07 l=1e-07   res=0.149966
XXI2\<2\>\/XI2\<2\>\/XI2\<2\>\/XI2\<3\>\/RR1 (  \
 N_SEL2\<2\>_XI2\<2\>\/XI2\<2\>\/XI2\<2\>\/XI2\<3\>\/RR1_pos WLSEL\<686\> ) \
 R_1X_LL w=1e-07 l=1e-07   res=0.149966
XXI2\<2\>\/XI2\<2\>\/XI2\<2\>\/XI2\<3\>\/RR0 (  \
 N_SEL1\<2\>_XI2\<2\>\/XI2\<2\>\/XI2\<2\>\/XI2\<3\>\/RR0_pos WLSEL\<685\> ) \
 R_1X_LL w=1e-07 l=1e-07   res=0.149966
XXI2\<2\>\/XI2\<2\>\/XI2\<2\>\/XI2\<3\>\/RI2 (  \
 N_SEL0\<3\>_XI2\<2\>\/XI2\<2\>\/XI2\<2\>\/XI2\<3\>\/RI2_pos WLSEL\<684\> ) \
 R_1X_LL w=1e-07 l=1e-07   res=0.149966
XXI2\<2\>\/XI2\<2\>\/XI2\<2\>\/XI2\<2\>\/RR2 (  \
 N_SEL3\<2\>_XI2\<2\>\/XI2\<2\>\/XI2\<2\>\/XI2\<2\>\/RR2_pos WLSEL\<683\> ) \
 R_1X_LL w=1e-07 l=1e-07   res=0.149966
XXI2\<2\>\/XI2\<2\>\/XI2\<2\>\/XI2\<2\>\/RR1 (  \
 N_SEL2\<2\>_XI2\<2\>\/XI2\<2\>\/XI2\<2\>\/XI2\<2\>\/RR1_pos WLSEL\<682\> ) \
 R_1X_LL w=1e-07 l=1e-07   res=0.149966
XXI2\<2\>\/XI2\<2\>\/XI2\<2\>\/XI2\<2\>\/RR0 (  \
 N_SEL1\<2\>_XI2\<2\>\/XI2\<2\>\/XI2\<2\>\/XI2\<2\>\/RR0_pos WLSEL\<681\> ) \
 R_1X_LL w=1e-07 l=1e-07   res=0.149966
XXI2\<2\>\/XI2\<2\>\/XI2\<2\>\/XI2\<2\>\/RI2 (  \
 N_SEL0\<2\>_XI2\<2\>\/XI2\<2\>\/XI2\<2\>\/XI2\<2\>\/RI2_pos WLSEL\<680\> ) \
 R_1X_LL w=1e-07 l=1e-07   res=0.149966
XXI2\<2\>\/XI2\<2\>\/XI2\<2\>\/XI2\<1\>\/RR2 (  \
 N_SEL3\<2\>_XI2\<2\>\/XI2\<2\>\/XI2\<2\>\/XI2\<1\>\/RR2_pos WLSEL\<679\> ) \
 R_1X_LL w=1e-07 l=1e-07   res=0.149966
XXI2\<2\>\/XI2\<2\>\/XI2\<2\>\/XI2\<1\>\/RR1 (  \
 N_SEL2\<2\>_XI2\<2\>\/XI2\<2\>\/XI2\<2\>\/XI2\<1\>\/RR1_pos WLSEL\<678\> ) \
 R_1X_LL w=1e-07 l=1e-07   res=0.149966
XXI2\<2\>\/XI2\<2\>\/XI2\<2\>\/XI2\<1\>\/RR0 (  \
 N_SEL1\<2\>_XI2\<2\>\/XI2\<2\>\/XI2\<2\>\/XI2\<1\>\/RR0_pos WLSEL\<677\> ) \
 R_1X_LL w=1e-07 l=1e-07   res=0.149966
XXI2\<2\>\/XI2\<2\>\/XI2\<2\>\/XI2\<1\>\/RI2 (  \
 N_SEL0\<1\>_XI2\<2\>\/XI2\<2\>\/XI2\<2\>\/XI2\<1\>\/RI2_pos WLSEL\<676\> ) \
 R_1X_LL w=1e-07 l=1e-07   res=0.149966
XXI2\<2\>\/XI2\<2\>\/XI2\<2\>\/XI2\<0\>\/RR2 (  \
 N_SEL3\<2\>_XI2\<2\>\/XI2\<2\>\/XI2\<2\>\/XI2\<0\>\/RR2_pos WLSEL\<675\> ) \
 R_1X_LL w=1e-07 l=1e-07   res=0.149966
XXI2\<2\>\/XI2\<2\>\/XI2\<2\>\/XI2\<0\>\/RR1 (  \
 N_SEL2\<2\>_XI2\<2\>\/XI2\<2\>\/XI2\<2\>\/XI2\<0\>\/RR1_pos WLSEL\<674\> ) \
 R_1X_LL w=1e-07 l=1e-07   res=0.149966
XXI2\<2\>\/XI2\<2\>\/XI2\<2\>\/XI2\<0\>\/RR0 (  \
 N_SEL1\<2\>_XI2\<2\>\/XI2\<2\>\/XI2\<2\>\/XI2\<0\>\/RR0_pos WLSEL\<673\> ) \
 R_1X_LL w=1e-07 l=1e-07   res=0.149966
XXI2\<2\>\/XI2\<2\>\/XI2\<2\>\/XI2\<0\>\/RI2 (  \
 N_SEL0\<0\>_XI2\<2\>\/XI2\<2\>\/XI2\<2\>\/XI2\<0\>\/RI2_pos WLSEL\<672\> ) \
 R_1X_LL w=1e-07 l=1e-07   res=0.149966
XXI2\<2\>\/XI2\<2\>\/XI2\<1\>\/XI2\<3\>\/RR2 (  \
 N_SEL3\<2\>_XI2\<2\>\/XI2\<2\>\/XI2\<1\>\/XI2\<3\>\/RR2_pos WLSEL\<671\> ) \
 R_1X_LL w=1e-07 l=1e-07   res=0.149966
XXI2\<2\>\/XI2\<2\>\/XI2\<1\>\/XI2\<3\>\/RR1 (  \
 N_SEL2\<2\>_XI2\<2\>\/XI2\<2\>\/XI2\<1\>\/XI2\<3\>\/RR1_pos WLSEL\<670\> ) \
 R_1X_LL w=1e-07 l=1e-07   res=0.149966
XXI2\<2\>\/XI2\<2\>\/XI2\<1\>\/XI2\<3\>\/RR0 (  \
 N_SEL1\<1\>_XI2\<2\>\/XI2\<2\>\/XI2\<1\>\/XI2\<3\>\/RR0_pos WLSEL\<669\> ) \
 R_1X_LL w=1e-07 l=1e-07   res=0.149966
XXI2\<2\>\/XI2\<2\>\/XI2\<1\>\/XI2\<3\>\/RI2 (  \
 N_SEL0\<3\>_XI2\<2\>\/XI2\<2\>\/XI2\<1\>\/XI2\<3\>\/RI2_pos WLSEL\<668\> ) \
 R_1X_LL w=1e-07 l=1e-07   res=0.149966
XXI2\<2\>\/XI2\<2\>\/XI2\<1\>\/XI2\<2\>\/RR2 (  \
 N_SEL3\<2\>_XI2\<2\>\/XI2\<2\>\/XI2\<1\>\/XI2\<2\>\/RR2_pos WLSEL\<667\> ) \
 R_1X_LL w=1e-07 l=1e-07   res=0.149966
XXI2\<2\>\/XI2\<2\>\/XI2\<1\>\/XI2\<2\>\/RR1 (  \
 N_SEL2\<2\>_XI2\<2\>\/XI2\<2\>\/XI2\<1\>\/XI2\<2\>\/RR1_pos WLSEL\<666\> ) \
 R_1X_LL w=1e-07 l=1e-07   res=0.149966
XXI2\<2\>\/XI2\<2\>\/XI2\<1\>\/XI2\<2\>\/RR0 (  \
 N_SEL1\<1\>_XI2\<2\>\/XI2\<2\>\/XI2\<1\>\/XI2\<2\>\/RR0_pos WLSEL\<665\> ) \
 R_1X_LL w=1e-07 l=1e-07   res=0.149966
XXI2\<2\>\/XI2\<2\>\/XI2\<1\>\/XI2\<2\>\/RI2 (  \
 N_SEL0\<2\>_XI2\<2\>\/XI2\<2\>\/XI2\<1\>\/XI2\<2\>\/RI2_pos WLSEL\<664\> ) \
 R_1X_LL w=1e-07 l=1e-07   res=0.149966
XXI2\<2\>\/XI2\<2\>\/XI2\<1\>\/XI2\<1\>\/RR2 (  \
 N_SEL3\<2\>_XI2\<2\>\/XI2\<2\>\/XI2\<1\>\/XI2\<1\>\/RR2_pos WLSEL\<663\> ) \
 R_1X_LL w=1e-07 l=1e-07   res=0.149966
XXI2\<2\>\/XI2\<2\>\/XI2\<1\>\/XI2\<1\>\/RR1 (  \
 N_SEL2\<2\>_XI2\<2\>\/XI2\<2\>\/XI2\<1\>\/XI2\<1\>\/RR1_pos WLSEL\<662\> ) \
 R_1X_LL w=1e-07 l=1e-07   res=0.149966
XXI2\<2\>\/XI2\<2\>\/XI2\<1\>\/XI2\<1\>\/RR0 (  \
 N_SEL1\<1\>_XI2\<2\>\/XI2\<2\>\/XI2\<1\>\/XI2\<1\>\/RR0_pos WLSEL\<661\> ) \
 R_1X_LL w=1e-07 l=1e-07   res=0.149966
XXI2\<2\>\/XI2\<2\>\/XI2\<1\>\/XI2\<1\>\/RI2 (  \
 N_SEL0\<1\>_XI2\<2\>\/XI2\<2\>\/XI2\<1\>\/XI2\<1\>\/RI2_pos WLSEL\<660\> ) \
 R_1X_LL w=1e-07 l=1e-07   res=0.149966
XXI2\<2\>\/XI2\<2\>\/XI2\<1\>\/XI2\<0\>\/RR2 (  \
 N_SEL3\<2\>_XI2\<2\>\/XI2\<2\>\/XI2\<1\>\/XI2\<0\>\/RR2_pos WLSEL\<659\> ) \
 R_1X_LL w=1e-07 l=1e-07   res=0.149966
XXI2\<2\>\/XI2\<2\>\/XI2\<1\>\/XI2\<0\>\/RR1 (  \
 N_SEL2\<2\>_XI2\<2\>\/XI2\<2\>\/XI2\<1\>\/XI2\<0\>\/RR1_pos WLSEL\<658\> ) \
 R_1X_LL w=1e-07 l=1e-07   res=0.149966
XXI2\<2\>\/XI2\<2\>\/XI2\<1\>\/XI2\<0\>\/RR0 (  \
 N_SEL1\<1\>_XI2\<2\>\/XI2\<2\>\/XI2\<1\>\/XI2\<0\>\/RR0_pos WLSEL\<657\> ) \
 R_1X_LL w=1e-07 l=1e-07   res=0.149966
XXI2\<2\>\/XI2\<2\>\/XI2\<1\>\/XI2\<0\>\/RI2 (  \
 N_SEL0\<0\>_XI2\<2\>\/XI2\<2\>\/XI2\<1\>\/XI2\<0\>\/RI2_pos WLSEL\<656\> ) \
 R_1X_LL w=1e-07 l=1e-07   res=0.149966
XXI2\<2\>\/XI2\<2\>\/XI2\<0\>\/XI2\<3\>\/RR2 (  \
 N_SEL3\<2\>_XI2\<2\>\/XI2\<2\>\/XI2\<0\>\/XI2\<3\>\/RR2_pos WLSEL\<655\> ) \
 R_1X_LL w=1e-07 l=1e-07   res=0.149966
XXI2\<2\>\/XI2\<2\>\/XI2\<0\>\/XI2\<3\>\/RR1 (  \
 N_SEL2\<2\>_XI2\<2\>\/XI2\<2\>\/XI2\<0\>\/XI2\<3\>\/RR1_pos WLSEL\<654\> ) \
 R_1X_LL w=1e-07 l=1e-07   res=0.149966
XXI2\<2\>\/XI2\<2\>\/XI2\<0\>\/XI2\<3\>\/RR0 (  \
 N_SEL1\<0\>_XI2\<2\>\/XI2\<2\>\/XI2\<0\>\/XI2\<3\>\/RR0_pos WLSEL\<653\> ) \
 R_1X_LL w=1e-07 l=1e-07   res=0.149966
XXI2\<2\>\/XI2\<2\>\/XI2\<0\>\/XI2\<3\>\/RI2 (  \
 N_SEL0\<3\>_XI2\<2\>\/XI2\<2\>\/XI2\<0\>\/XI2\<3\>\/RI2_pos WLSEL\<652\> ) \
 R_1X_LL w=1e-07 l=1e-07   res=0.149966
XXI2\<2\>\/XI2\<2\>\/XI2\<0\>\/XI2\<2\>\/RR2 (  \
 N_SEL3\<2\>_XI2\<2\>\/XI2\<2\>\/XI2\<0\>\/XI2\<2\>\/RR2_pos WLSEL\<651\> ) \
 R_1X_LL w=1e-07 l=1e-07   res=0.149966
XXI2\<2\>\/XI2\<2\>\/XI2\<0\>\/XI2\<2\>\/RR1 (  \
 N_SEL2\<2\>_XI2\<2\>\/XI2\<2\>\/XI2\<0\>\/XI2\<2\>\/RR1_pos WLSEL\<650\> ) \
 R_1X_LL w=1e-07 l=1e-07   res=0.149966
XXI2\<2\>\/XI2\<2\>\/XI2\<0\>\/XI2\<2\>\/RR0 (  \
 N_SEL1\<0\>_XI2\<2\>\/XI2\<2\>\/XI2\<0\>\/XI2\<2\>\/RR0_pos WLSEL\<649\> ) \
 R_1X_LL w=1e-07 l=1e-07   res=0.149966
XXI2\<2\>\/XI2\<2\>\/XI2\<0\>\/XI2\<2\>\/RI2 (  \
 N_SEL0\<2\>_XI2\<2\>\/XI2\<2\>\/XI2\<0\>\/XI2\<2\>\/RI2_pos WLSEL\<648\> ) \
 R_1X_LL w=1e-07 l=1e-07   res=0.149966
XXI2\<2\>\/XI2\<2\>\/XI2\<0\>\/XI2\<1\>\/RR2 (  \
 N_SEL3\<2\>_XI2\<2\>\/XI2\<2\>\/XI2\<0\>\/XI2\<1\>\/RR2_pos WLSEL\<647\> ) \
 R_1X_LL w=1e-07 l=1e-07   res=0.149966
XXI2\<2\>\/XI2\<2\>\/XI2\<0\>\/XI2\<1\>\/RR1 (  \
 N_SEL2\<2\>_XI2\<2\>\/XI2\<2\>\/XI2\<0\>\/XI2\<1\>\/RR1_pos WLSEL\<646\> ) \
 R_1X_LL w=1e-07 l=1e-07   res=0.149966
XXI2\<2\>\/XI2\<2\>\/XI2\<0\>\/XI2\<1\>\/RR0 (  \
 N_SEL1\<0\>_XI2\<2\>\/XI2\<2\>\/XI2\<0\>\/XI2\<1\>\/RR0_pos WLSEL\<645\> ) \
 R_1X_LL w=1e-07 l=1e-07   res=0.149966
XXI2\<2\>\/XI2\<2\>\/XI2\<0\>\/XI2\<1\>\/RI2 (  \
 N_SEL0\<1\>_XI2\<2\>\/XI2\<2\>\/XI2\<0\>\/XI2\<1\>\/RI2_pos WLSEL\<644\> ) \
 R_1X_LL w=1e-07 l=1e-07   res=0.149966
XXI2\<2\>\/XI2\<2\>\/XI2\<0\>\/XI2\<0\>\/RR2 (  \
 N_SEL3\<2\>_XI2\<2\>\/XI2\<2\>\/XI2\<0\>\/XI2\<0\>\/RR2_pos WLSEL\<643\> ) \
 R_1X_LL w=1e-07 l=1e-07   res=0.149966
XXI2\<2\>\/XI2\<2\>\/XI2\<0\>\/XI2\<0\>\/RR1 (  \
 N_SEL2\<2\>_XI2\<2\>\/XI2\<2\>\/XI2\<0\>\/XI2\<0\>\/RR1_pos WLSEL\<642\> ) \
 R_1X_LL w=1e-07 l=1e-07   res=0.149966
XXI2\<2\>\/XI2\<2\>\/XI2\<0\>\/XI2\<0\>\/RR0 (  \
 N_SEL1\<0\>_XI2\<2\>\/XI2\<2\>\/XI2\<0\>\/XI2\<0\>\/RR0_pos WLSEL\<641\> ) \
 R_1X_LL w=1e-07 l=1e-07   res=0.149966
XXI2\<2\>\/XI2\<2\>\/XI2\<0\>\/XI2\<0\>\/RI2 (  \
 N_SEL0\<0\>_XI2\<2\>\/XI2\<2\>\/XI2\<0\>\/XI2\<0\>\/RI2_pos WLSEL\<640\> ) \
 R_1X_LL w=1e-07 l=1e-07   res=0.149966
XXI2\<2\>\/XI2\<1\>\/XI2\<3\>\/XI2\<3\>\/RR2 (  \
 N_SEL3\<2\>_XI2\<2\>\/XI2\<1\>\/XI2\<3\>\/XI2\<3\>\/RR2_pos WLSEL\<639\> ) \
 R_1X_LL w=1e-07 l=1e-07   res=0.149966
XXI2\<2\>\/XI2\<1\>\/XI2\<3\>\/XI2\<3\>\/RR1 (  \
 N_SEL2\<1\>_XI2\<2\>\/XI2\<1\>\/XI2\<3\>\/XI2\<3\>\/RR1_pos WLSEL\<638\> ) \
 R_1X_LL w=1e-07 l=1e-07   res=0.149966
XXI2\<2\>\/XI2\<1\>\/XI2\<3\>\/XI2\<3\>\/RR0 (  \
 N_SEL1\<3\>_XI2\<2\>\/XI2\<1\>\/XI2\<3\>\/XI2\<3\>\/RR0_pos WLSEL\<637\> ) \
 R_1X_LL w=1e-07 l=1e-07   res=0.149966
XXI2\<2\>\/XI2\<1\>\/XI2\<3\>\/XI2\<3\>\/RI2 (  \
 N_SEL0\<3\>_XI2\<2\>\/XI2\<1\>\/XI2\<3\>\/XI2\<3\>\/RI2_pos WLSEL\<636\> ) \
 R_1X_LL w=1e-07 l=1e-07   res=0.149966
XXI2\<2\>\/XI2\<1\>\/XI2\<3\>\/XI2\<2\>\/RR2 (  \
 N_SEL3\<2\>_XI2\<2\>\/XI2\<1\>\/XI2\<3\>\/XI2\<2\>\/RR2_pos WLSEL\<635\> ) \
 R_1X_LL w=1e-07 l=1e-07   res=0.149966
XXI2\<2\>\/XI2\<1\>\/XI2\<3\>\/XI2\<2\>\/RR1 (  \
 N_SEL2\<1\>_XI2\<2\>\/XI2\<1\>\/XI2\<3\>\/XI2\<2\>\/RR1_pos WLSEL\<634\> ) \
 R_1X_LL w=1e-07 l=1e-07   res=0.149966
XXI2\<2\>\/XI2\<1\>\/XI2\<3\>\/XI2\<2\>\/RR0 (  \
 N_SEL1\<3\>_XI2\<2\>\/XI2\<1\>\/XI2\<3\>\/XI2\<2\>\/RR0_pos WLSEL\<633\> ) \
 R_1X_LL w=1e-07 l=1e-07   res=0.149966
XXI2\<2\>\/XI2\<1\>\/XI2\<3\>\/XI2\<2\>\/RI2 (  \
 N_SEL0\<2\>_XI2\<2\>\/XI2\<1\>\/XI2\<3\>\/XI2\<2\>\/RI2_pos WLSEL\<632\> ) \
 R_1X_LL w=1e-07 l=1e-07   res=0.149966
XXI2\<2\>\/XI2\<1\>\/XI2\<3\>\/XI2\<1\>\/RR2 (  \
 N_SEL3\<2\>_XI2\<2\>\/XI2\<1\>\/XI2\<3\>\/XI2\<1\>\/RR2_pos WLSEL\<631\> ) \
 R_1X_LL w=1e-07 l=1e-07   res=0.149966
XXI2\<2\>\/XI2\<1\>\/XI2\<3\>\/XI2\<1\>\/RR1 (  \
 N_SEL2\<1\>_XI2\<2\>\/XI2\<1\>\/XI2\<3\>\/XI2\<1\>\/RR1_pos WLSEL\<630\> ) \
 R_1X_LL w=1e-07 l=1e-07   res=0.149966
XXI2\<2\>\/XI2\<1\>\/XI2\<3\>\/XI2\<1\>\/RR0 (  \
 N_SEL1\<3\>_XI2\<2\>\/XI2\<1\>\/XI2\<3\>\/XI2\<1\>\/RR0_pos WLSEL\<629\> ) \
 R_1X_LL w=1e-07 l=1e-07   res=0.149966
XXI2\<2\>\/XI2\<1\>\/XI2\<3\>\/XI2\<1\>\/RI2 (  \
 N_SEL0\<1\>_XI2\<2\>\/XI2\<1\>\/XI2\<3\>\/XI2\<1\>\/RI2_pos WLSEL\<628\> ) \
 R_1X_LL w=1e-07 l=1e-07   res=0.149966
XXI2\<2\>\/XI2\<1\>\/XI2\<3\>\/XI2\<0\>\/RR2 (  \
 N_SEL3\<2\>_XI2\<2\>\/XI2\<1\>\/XI2\<3\>\/XI2\<0\>\/RR2_pos WLSEL\<627\> ) \
 R_1X_LL w=1e-07 l=1e-07   res=0.149966
XXI2\<2\>\/XI2\<1\>\/XI2\<3\>\/XI2\<0\>\/RR1 (  \
 N_SEL2\<1\>_XI2\<2\>\/XI2\<1\>\/XI2\<3\>\/XI2\<0\>\/RR1_pos WLSEL\<626\> ) \
 R_1X_LL w=1e-07 l=1e-07   res=0.149966
XXI2\<2\>\/XI2\<1\>\/XI2\<3\>\/XI2\<0\>\/RR0 (  \
 N_SEL1\<3\>_XI2\<2\>\/XI2\<1\>\/XI2\<3\>\/XI2\<0\>\/RR0_pos WLSEL\<625\> ) \
 R_1X_LL w=1e-07 l=1e-07   res=0.149966
XXI2\<2\>\/XI2\<1\>\/XI2\<3\>\/XI2\<0\>\/RI2 (  \
 N_SEL0\<0\>_XI2\<2\>\/XI2\<1\>\/XI2\<3\>\/XI2\<0\>\/RI2_pos WLSEL\<624\> ) \
 R_1X_LL w=1e-07 l=1e-07   res=0.149966
XXI2\<2\>\/XI2\<1\>\/XI2\<2\>\/XI2\<3\>\/RR2 (  \
 N_SEL3\<2\>_XI2\<2\>\/XI2\<1\>\/XI2\<2\>\/XI2\<3\>\/RR2_pos WLSEL\<623\> ) \
 R_1X_LL w=1e-07 l=1e-07   res=0.149966
XXI2\<2\>\/XI2\<1\>\/XI2\<2\>\/XI2\<3\>\/RR1 (  \
 N_SEL2\<1\>_XI2\<2\>\/XI2\<1\>\/XI2\<2\>\/XI2\<3\>\/RR1_pos WLSEL\<622\> ) \
 R_1X_LL w=1e-07 l=1e-07   res=0.149966
XXI2\<2\>\/XI2\<1\>\/XI2\<2\>\/XI2\<3\>\/RR0 (  \
 N_SEL1\<2\>_XI2\<2\>\/XI2\<1\>\/XI2\<2\>\/XI2\<3\>\/RR0_pos WLSEL\<621\> ) \
 R_1X_LL w=1e-07 l=1e-07   res=0.149966
XXI2\<2\>\/XI2\<1\>\/XI2\<2\>\/XI2\<3\>\/RI2 (  \
 N_SEL0\<3\>_XI2\<2\>\/XI2\<1\>\/XI2\<2\>\/XI2\<3\>\/RI2_pos WLSEL\<620\> ) \
 R_1X_LL w=1e-07 l=1e-07   res=0.149966
XXI2\<2\>\/XI2\<1\>\/XI2\<2\>\/XI2\<2\>\/RR2 (  \
 N_SEL3\<2\>_XI2\<2\>\/XI2\<1\>\/XI2\<2\>\/XI2\<2\>\/RR2_pos WLSEL\<619\> ) \
 R_1X_LL w=1e-07 l=1e-07   res=0.149966
XXI2\<2\>\/XI2\<1\>\/XI2\<2\>\/XI2\<2\>\/RR1 (  \
 N_SEL2\<1\>_XI2\<2\>\/XI2\<1\>\/XI2\<2\>\/XI2\<2\>\/RR1_pos WLSEL\<618\> ) \
 R_1X_LL w=1e-07 l=1e-07   res=0.149966
XXI2\<2\>\/XI2\<1\>\/XI2\<2\>\/XI2\<2\>\/RR0 (  \
 N_SEL1\<2\>_XI2\<2\>\/XI2\<1\>\/XI2\<2\>\/XI2\<2\>\/RR0_pos WLSEL\<617\> ) \
 R_1X_LL w=1e-07 l=1e-07   res=0.149966
XXI2\<2\>\/XI2\<1\>\/XI2\<2\>\/XI2\<2\>\/RI2 (  \
 N_SEL0\<2\>_XI2\<2\>\/XI2\<1\>\/XI2\<2\>\/XI2\<2\>\/RI2_pos WLSEL\<616\> ) \
 R_1X_LL w=1e-07 l=1e-07   res=0.149966
XXI2\<2\>\/XI2\<1\>\/XI2\<2\>\/XI2\<1\>\/RR2 (  \
 N_SEL3\<2\>_XI2\<2\>\/XI2\<1\>\/XI2\<2\>\/XI2\<1\>\/RR2_pos WLSEL\<615\> ) \
 R_1X_LL w=1e-07 l=1e-07   res=0.149966
XXI2\<2\>\/XI2\<1\>\/XI2\<2\>\/XI2\<1\>\/RR1 (  \
 N_SEL2\<1\>_XI2\<2\>\/XI2\<1\>\/XI2\<2\>\/XI2\<1\>\/RR1_pos WLSEL\<614\> ) \
 R_1X_LL w=1e-07 l=1e-07   res=0.149966
XXI2\<2\>\/XI2\<1\>\/XI2\<2\>\/XI2\<1\>\/RR0 (  \
 N_SEL1\<2\>_XI2\<2\>\/XI2\<1\>\/XI2\<2\>\/XI2\<1\>\/RR0_pos WLSEL\<613\> ) \
 R_1X_LL w=1e-07 l=1e-07   res=0.149966
XXI2\<2\>\/XI2\<1\>\/XI2\<2\>\/XI2\<1\>\/RI2 (  \
 N_SEL0\<1\>_XI2\<2\>\/XI2\<1\>\/XI2\<2\>\/XI2\<1\>\/RI2_pos WLSEL\<612\> ) \
 R_1X_LL w=1e-07 l=1e-07   res=0.149966
XXI2\<2\>\/XI2\<1\>\/XI2\<2\>\/XI2\<0\>\/RR2 (  \
 N_SEL3\<2\>_XI2\<2\>\/XI2\<1\>\/XI2\<2\>\/XI2\<0\>\/RR2_pos WLSEL\<611\> ) \
 R_1X_LL w=1e-07 l=1e-07   res=0.149966
XXI2\<2\>\/XI2\<1\>\/XI2\<2\>\/XI2\<0\>\/RR1 (  \
 N_SEL2\<1\>_XI2\<2\>\/XI2\<1\>\/XI2\<2\>\/XI2\<0\>\/RR1_pos WLSEL\<610\> ) \
 R_1X_LL w=1e-07 l=1e-07   res=0.149966
XXI2\<2\>\/XI2\<1\>\/XI2\<2\>\/XI2\<0\>\/RR0 (  \
 N_SEL1\<2\>_XI2\<2\>\/XI2\<1\>\/XI2\<2\>\/XI2\<0\>\/RR0_pos WLSEL\<609\> ) \
 R_1X_LL w=1e-07 l=1e-07   res=0.149966
XXI2\<2\>\/XI2\<1\>\/XI2\<2\>\/XI2\<0\>\/RI2 (  \
 N_SEL0\<0\>_XI2\<2\>\/XI2\<1\>\/XI2\<2\>\/XI2\<0\>\/RI2_pos WLSEL\<608\> ) \
 R_1X_LL w=1e-07 l=1e-07   res=0.149966
XXI2\<2\>\/XI2\<1\>\/XI2\<1\>\/XI2\<3\>\/RR2 (  \
 N_SEL3\<2\>_XI2\<2\>\/XI2\<1\>\/XI2\<1\>\/XI2\<3\>\/RR2_pos WLSEL\<607\> ) \
 R_1X_LL w=1e-07 l=1e-07   res=0.149966
XXI2\<2\>\/XI2\<1\>\/XI2\<1\>\/XI2\<3\>\/RR1 (  \
 N_SEL2\<1\>_XI2\<2\>\/XI2\<1\>\/XI2\<1\>\/XI2\<3\>\/RR1_pos WLSEL\<606\> ) \
 R_1X_LL w=1e-07 l=1e-07   res=0.149966
XXI2\<2\>\/XI2\<1\>\/XI2\<1\>\/XI2\<3\>\/RR0 (  \
 N_SEL1\<1\>_XI2\<2\>\/XI2\<1\>\/XI2\<1\>\/XI2\<3\>\/RR0_pos WLSEL\<605\> ) \
 R_1X_LL w=1e-07 l=1e-07   res=0.149966
XXI2\<2\>\/XI2\<1\>\/XI2\<1\>\/XI2\<3\>\/RI2 (  \
 N_SEL0\<3\>_XI2\<2\>\/XI2\<1\>\/XI2\<1\>\/XI2\<3\>\/RI2_pos WLSEL\<604\> ) \
 R_1X_LL w=1e-07 l=1e-07   res=0.149966
XXI2\<2\>\/XI2\<1\>\/XI2\<1\>\/XI2\<2\>\/RR2 (  \
 N_SEL3\<2\>_XI2\<2\>\/XI2\<1\>\/XI2\<1\>\/XI2\<2\>\/RR2_pos WLSEL\<603\> ) \
 R_1X_LL w=1e-07 l=1e-07   res=0.149966
XXI2\<2\>\/XI2\<1\>\/XI2\<1\>\/XI2\<2\>\/RR1 (  \
 N_SEL2\<1\>_XI2\<2\>\/XI2\<1\>\/XI2\<1\>\/XI2\<2\>\/RR1_pos WLSEL\<602\> ) \
 R_1X_LL w=1e-07 l=1e-07   res=0.149966
XXI2\<2\>\/XI2\<1\>\/XI2\<1\>\/XI2\<2\>\/RR0 (  \
 N_SEL1\<1\>_XI2\<2\>\/XI2\<1\>\/XI2\<1\>\/XI2\<2\>\/RR0_pos WLSEL\<601\> ) \
 R_1X_LL w=1e-07 l=1e-07   res=0.149966
XXI2\<2\>\/XI2\<1\>\/XI2\<1\>\/XI2\<2\>\/RI2 (  \
 N_SEL0\<2\>_XI2\<2\>\/XI2\<1\>\/XI2\<1\>\/XI2\<2\>\/RI2_pos WLSEL\<600\> ) \
 R_1X_LL w=1e-07 l=1e-07   res=0.149966
XXI2\<2\>\/XI2\<1\>\/XI2\<1\>\/XI2\<1\>\/RR2 (  \
 N_SEL3\<2\>_XI2\<2\>\/XI2\<1\>\/XI2\<1\>\/XI2\<1\>\/RR2_pos WLSEL\<599\> ) \
 R_1X_LL w=1e-07 l=1e-07   res=0.149966
XXI2\<2\>\/XI2\<1\>\/XI2\<1\>\/XI2\<1\>\/RR1 (  \
 N_SEL2\<1\>_XI2\<2\>\/XI2\<1\>\/XI2\<1\>\/XI2\<1\>\/RR1_pos WLSEL\<598\> ) \
 R_1X_LL w=1e-07 l=1e-07   res=0.149966
XXI2\<2\>\/XI2\<1\>\/XI2\<1\>\/XI2\<1\>\/RR0 (  \
 N_SEL1\<1\>_XI2\<2\>\/XI2\<1\>\/XI2\<1\>\/XI2\<1\>\/RR0_pos WLSEL\<597\> ) \
 R_1X_LL w=1e-07 l=1e-07   res=0.149966
XXI2\<2\>\/XI2\<1\>\/XI2\<1\>\/XI2\<1\>\/RI2 (  \
 N_SEL0\<1\>_XI2\<2\>\/XI2\<1\>\/XI2\<1\>\/XI2\<1\>\/RI2_pos WLSEL\<596\> ) \
 R_1X_LL w=1e-07 l=1e-07   res=0.149966
XXI2\<2\>\/XI2\<1\>\/XI2\<1\>\/XI2\<0\>\/RR2 (  \
 N_SEL3\<2\>_XI2\<2\>\/XI2\<1\>\/XI2\<1\>\/XI2\<0\>\/RR2_pos WLSEL\<595\> ) \
 R_1X_LL w=1e-07 l=1e-07   res=0.149966
XXI2\<2\>\/XI2\<1\>\/XI2\<1\>\/XI2\<0\>\/RR1 (  \
 N_SEL2\<1\>_XI2\<2\>\/XI2\<1\>\/XI2\<1\>\/XI2\<0\>\/RR1_pos WLSEL\<594\> ) \
 R_1X_LL w=1e-07 l=1e-07   res=0.149966
XXI2\<2\>\/XI2\<1\>\/XI2\<1\>\/XI2\<0\>\/RR0 (  \
 N_SEL1\<1\>_XI2\<2\>\/XI2\<1\>\/XI2\<1\>\/XI2\<0\>\/RR0_pos WLSEL\<593\> ) \
 R_1X_LL w=1e-07 l=1e-07   res=0.149966
XXI2\<2\>\/XI2\<1\>\/XI2\<1\>\/XI2\<0\>\/RI2 (  \
 N_SEL0\<0\>_XI2\<2\>\/XI2\<1\>\/XI2\<1\>\/XI2\<0\>\/RI2_pos WLSEL\<592\> ) \
 R_1X_LL w=1e-07 l=1e-07   res=0.149966
XXI2\<2\>\/XI2\<1\>\/XI2\<0\>\/XI2\<3\>\/RR2 (  \
 N_SEL3\<2\>_XI2\<2\>\/XI2\<1\>\/XI2\<0\>\/XI2\<3\>\/RR2_pos WLSEL\<591\> ) \
 R_1X_LL w=1e-07 l=1e-07   res=0.149966
XXI2\<2\>\/XI2\<1\>\/XI2\<0\>\/XI2\<3\>\/RR1 (  \
 N_SEL2\<1\>_XI2\<2\>\/XI2\<1\>\/XI2\<0\>\/XI2\<3\>\/RR1_pos WLSEL\<590\> ) \
 R_1X_LL w=1e-07 l=1e-07   res=0.149966
XXI2\<2\>\/XI2\<1\>\/XI2\<0\>\/XI2\<3\>\/RR0 (  \
 N_SEL1\<0\>_XI2\<2\>\/XI2\<1\>\/XI2\<0\>\/XI2\<3\>\/RR0_pos WLSEL\<589\> ) \
 R_1X_LL w=1e-07 l=1e-07   res=0.149966
XXI2\<2\>\/XI2\<1\>\/XI2\<0\>\/XI2\<3\>\/RI2 (  \
 N_SEL0\<3\>_XI2\<2\>\/XI2\<1\>\/XI2\<0\>\/XI2\<3\>\/RI2_pos WLSEL\<588\> ) \
 R_1X_LL w=1e-07 l=1e-07   res=0.149966
XXI2\<2\>\/XI2\<1\>\/XI2\<0\>\/XI2\<2\>\/RR2 (  \
 N_SEL3\<2\>_XI2\<2\>\/XI2\<1\>\/XI2\<0\>\/XI2\<2\>\/RR2_pos WLSEL\<587\> ) \
 R_1X_LL w=1e-07 l=1e-07   res=0.149966
XXI2\<2\>\/XI2\<1\>\/XI2\<0\>\/XI2\<2\>\/RR1 (  \
 N_SEL2\<1\>_XI2\<2\>\/XI2\<1\>\/XI2\<0\>\/XI2\<2\>\/RR1_pos WLSEL\<586\> ) \
 R_1X_LL w=1e-07 l=1e-07   res=0.149966
XXI2\<2\>\/XI2\<1\>\/XI2\<0\>\/XI2\<2\>\/RR0 (  \
 N_SEL1\<0\>_XI2\<2\>\/XI2\<1\>\/XI2\<0\>\/XI2\<2\>\/RR0_pos WLSEL\<585\> ) \
 R_1X_LL w=1e-07 l=1e-07   res=0.149966
XXI2\<2\>\/XI2\<1\>\/XI2\<0\>\/XI2\<2\>\/RI2 (  \
 N_SEL0\<2\>_XI2\<2\>\/XI2\<1\>\/XI2\<0\>\/XI2\<2\>\/RI2_pos WLSEL\<584\> ) \
 R_1X_LL w=1e-07 l=1e-07   res=0.149966
XXI2\<2\>\/XI2\<1\>\/XI2\<0\>\/XI2\<1\>\/RR2 (  \
 N_SEL3\<2\>_XI2\<2\>\/XI2\<1\>\/XI2\<0\>\/XI2\<1\>\/RR2_pos WLSEL\<583\> ) \
 R_1X_LL w=1e-07 l=1e-07   res=0.149966
XXI2\<2\>\/XI2\<1\>\/XI2\<0\>\/XI2\<1\>\/RR1 (  \
 N_SEL2\<1\>_XI2\<2\>\/XI2\<1\>\/XI2\<0\>\/XI2\<1\>\/RR1_pos WLSEL\<582\> ) \
 R_1X_LL w=1e-07 l=1e-07   res=0.149966
XXI2\<2\>\/XI2\<1\>\/XI2\<0\>\/XI2\<1\>\/RR0 (  \
 N_SEL1\<0\>_XI2\<2\>\/XI2\<1\>\/XI2\<0\>\/XI2\<1\>\/RR0_pos WLSEL\<581\> ) \
 R_1X_LL w=1e-07 l=1e-07   res=0.149966
XXI2\<2\>\/XI2\<1\>\/XI2\<0\>\/XI2\<1\>\/RI2 (  \
 N_SEL0\<1\>_XI2\<2\>\/XI2\<1\>\/XI2\<0\>\/XI2\<1\>\/RI2_pos WLSEL\<580\> ) \
 R_1X_LL w=1e-07 l=1e-07   res=0.149966
XXI2\<2\>\/XI2\<1\>\/XI2\<0\>\/XI2\<0\>\/RR2 (  \
 N_SEL3\<2\>_XI2\<2\>\/XI2\<1\>\/XI2\<0\>\/XI2\<0\>\/RR2_pos WLSEL\<579\> ) \
 R_1X_LL w=1e-07 l=1e-07   res=0.149966
XXI2\<2\>\/XI2\<1\>\/XI2\<0\>\/XI2\<0\>\/RR1 (  \
 N_SEL2\<1\>_XI2\<2\>\/XI2\<1\>\/XI2\<0\>\/XI2\<0\>\/RR1_pos WLSEL\<578\> ) \
 R_1X_LL w=1e-07 l=1e-07   res=0.149966
XXI2\<2\>\/XI2\<1\>\/XI2\<0\>\/XI2\<0\>\/RR0 (  \
 N_SEL1\<0\>_XI2\<2\>\/XI2\<1\>\/XI2\<0\>\/XI2\<0\>\/RR0_pos WLSEL\<577\> ) \
 R_1X_LL w=1e-07 l=1e-07   res=0.149966
XXI2\<2\>\/XI2\<1\>\/XI2\<0\>\/XI2\<0\>\/RI2 (  \
 N_SEL0\<0\>_XI2\<2\>\/XI2\<1\>\/XI2\<0\>\/XI2\<0\>\/RI2_pos WLSEL\<576\> ) \
 R_1X_LL w=1e-07 l=1e-07   res=0.149966
XXI2\<2\>\/XI2\<0\>\/XI2\<3\>\/XI2\<3\>\/RR2 (  \
 N_SEL3\<2\>_XI2\<2\>\/XI2\<0\>\/XI2\<3\>\/XI2\<3\>\/RR2_pos WLSEL\<575\> ) \
 R_1X_LL w=1e-07 l=1e-07   res=0.149966
XXI2\<2\>\/XI2\<0\>\/XI2\<3\>\/XI2\<3\>\/RR1 (  \
 N_SEL2\<0\>_XI2\<2\>\/XI2\<0\>\/XI2\<3\>\/XI2\<3\>\/RR1_pos WLSEL\<574\> ) \
 R_1X_LL w=1e-07 l=1e-07   res=0.149966
XXI2\<2\>\/XI2\<0\>\/XI2\<3\>\/XI2\<3\>\/RR0 (  \
 N_SEL1\<3\>_XI2\<2\>\/XI2\<0\>\/XI2\<3\>\/XI2\<3\>\/RR0_pos WLSEL\<573\> ) \
 R_1X_LL w=1e-07 l=1e-07   res=0.149966
XXI2\<2\>\/XI2\<0\>\/XI2\<3\>\/XI2\<3\>\/RI2 (  \
 N_SEL0\<3\>_XI2\<2\>\/XI2\<0\>\/XI2\<3\>\/XI2\<3\>\/RI2_pos WLSEL\<572\> ) \
 R_1X_LL w=1e-07 l=1e-07   res=0.149966
XXI2\<2\>\/XI2\<0\>\/XI2\<3\>\/XI2\<2\>\/RR2 (  \
 N_SEL3\<2\>_XI2\<2\>\/XI2\<0\>\/XI2\<3\>\/XI2\<2\>\/RR2_pos WLSEL\<571\> ) \
 R_1X_LL w=1e-07 l=1e-07   res=0.149966
XXI2\<2\>\/XI2\<0\>\/XI2\<3\>\/XI2\<2\>\/RR1 (  \
 N_SEL2\<0\>_XI2\<2\>\/XI2\<0\>\/XI2\<3\>\/XI2\<2\>\/RR1_pos WLSEL\<570\> ) \
 R_1X_LL w=1e-07 l=1e-07   res=0.149966
XXI2\<2\>\/XI2\<0\>\/XI2\<3\>\/XI2\<2\>\/RR0 (  \
 N_SEL1\<3\>_XI2\<2\>\/XI2\<0\>\/XI2\<3\>\/XI2\<2\>\/RR0_pos WLSEL\<569\> ) \
 R_1X_LL w=1e-07 l=1e-07   res=0.149966
XXI2\<2\>\/XI2\<0\>\/XI2\<3\>\/XI2\<2\>\/RI2 (  \
 N_SEL0\<2\>_XI2\<2\>\/XI2\<0\>\/XI2\<3\>\/XI2\<2\>\/RI2_pos WLSEL\<568\> ) \
 R_1X_LL w=1e-07 l=1e-07   res=0.149966
XXI2\<2\>\/XI2\<0\>\/XI2\<3\>\/XI2\<1\>\/RR2 (  \
 N_SEL3\<2\>_XI2\<2\>\/XI2\<0\>\/XI2\<3\>\/XI2\<1\>\/RR2_pos WLSEL\<567\> ) \
 R_1X_LL w=1e-07 l=1e-07   res=0.149966
XXI2\<2\>\/XI2\<0\>\/XI2\<3\>\/XI2\<1\>\/RR1 (  \
 N_SEL2\<0\>_XI2\<2\>\/XI2\<0\>\/XI2\<3\>\/XI2\<1\>\/RR1_pos WLSEL\<566\> ) \
 R_1X_LL w=1e-07 l=1e-07   res=0.149966
XXI2\<2\>\/XI2\<0\>\/XI2\<3\>\/XI2\<1\>\/RR0 (  \
 N_SEL1\<3\>_XI2\<2\>\/XI2\<0\>\/XI2\<3\>\/XI2\<1\>\/RR0_pos WLSEL\<565\> ) \
 R_1X_LL w=1e-07 l=1e-07   res=0.149966
XXI2\<2\>\/XI2\<0\>\/XI2\<3\>\/XI2\<1\>\/RI2 (  \
 N_SEL0\<1\>_XI2\<2\>\/XI2\<0\>\/XI2\<3\>\/XI2\<1\>\/RI2_pos WLSEL\<564\> ) \
 R_1X_LL w=1e-07 l=1e-07   res=0.149966
XXI2\<2\>\/XI2\<0\>\/XI2\<3\>\/XI2\<0\>\/RR2 (  \
 N_SEL3\<2\>_XI2\<2\>\/XI2\<0\>\/XI2\<3\>\/XI2\<0\>\/RR2_pos WLSEL\<563\> ) \
 R_1X_LL w=1e-07 l=1e-07   res=0.149966
XXI2\<2\>\/XI2\<0\>\/XI2\<3\>\/XI2\<0\>\/RR1 (  \
 N_SEL2\<0\>_XI2\<2\>\/XI2\<0\>\/XI2\<3\>\/XI2\<0\>\/RR1_pos WLSEL\<562\> ) \
 R_1X_LL w=1e-07 l=1e-07   res=0.149966
XXI2\<2\>\/XI2\<0\>\/XI2\<3\>\/XI2\<0\>\/RR0 (  \
 N_SEL1\<3\>_XI2\<2\>\/XI2\<0\>\/XI2\<3\>\/XI2\<0\>\/RR0_pos WLSEL\<561\> ) \
 R_1X_LL w=1e-07 l=1e-07   res=0.149966
XXI2\<2\>\/XI2\<0\>\/XI2\<3\>\/XI2\<0\>\/RI2 (  \
 N_SEL0\<0\>_XI2\<2\>\/XI2\<0\>\/XI2\<3\>\/XI2\<0\>\/RI2_pos WLSEL\<560\> ) \
 R_1X_LL w=1e-07 l=1e-07   res=0.149966
XXI2\<2\>\/XI2\<0\>\/XI2\<2\>\/XI2\<3\>\/RR2 (  \
 N_SEL3\<2\>_XI2\<2\>\/XI2\<0\>\/XI2\<2\>\/XI2\<3\>\/RR2_pos WLSEL\<559\> ) \
 R_1X_LL w=1e-07 l=1e-07   res=0.149966
XXI2\<2\>\/XI2\<0\>\/XI2\<2\>\/XI2\<3\>\/RR1 (  \
 N_SEL2\<0\>_XI2\<2\>\/XI2\<0\>\/XI2\<2\>\/XI2\<3\>\/RR1_pos WLSEL\<558\> ) \
 R_1X_LL w=1e-07 l=1e-07   res=0.149966
XXI2\<2\>\/XI2\<0\>\/XI2\<2\>\/XI2\<3\>\/RR0 (  \
 N_SEL1\<2\>_XI2\<2\>\/XI2\<0\>\/XI2\<2\>\/XI2\<3\>\/RR0_pos WLSEL\<557\> ) \
 R_1X_LL w=1e-07 l=1e-07   res=0.149966
XXI2\<2\>\/XI2\<0\>\/XI2\<2\>\/XI2\<3\>\/RI2 (  \
 N_SEL0\<3\>_XI2\<2\>\/XI2\<0\>\/XI2\<2\>\/XI2\<3\>\/RI2_pos WLSEL\<556\> ) \
 R_1X_LL w=1e-07 l=1e-07   res=0.149966
XXI2\<2\>\/XI2\<0\>\/XI2\<2\>\/XI2\<2\>\/RR2 (  \
 N_SEL3\<2\>_XI2\<2\>\/XI2\<0\>\/XI2\<2\>\/XI2\<2\>\/RR2_pos WLSEL\<555\> ) \
 R_1X_LL w=1e-07 l=1e-07   res=0.149966
XXI2\<2\>\/XI2\<0\>\/XI2\<2\>\/XI2\<2\>\/RR1 (  \
 N_SEL2\<0\>_XI2\<2\>\/XI2\<0\>\/XI2\<2\>\/XI2\<2\>\/RR1_pos WLSEL\<554\> ) \
 R_1X_LL w=1e-07 l=1e-07   res=0.149966
XXI2\<2\>\/XI2\<0\>\/XI2\<2\>\/XI2\<2\>\/RR0 (  \
 N_SEL1\<2\>_XI2\<2\>\/XI2\<0\>\/XI2\<2\>\/XI2\<2\>\/RR0_pos WLSEL\<553\> ) \
 R_1X_LL w=1e-07 l=1e-07   res=0.149966
XXI2\<2\>\/XI2\<0\>\/XI2\<2\>\/XI2\<2\>\/RI2 (  \
 N_SEL0\<2\>_XI2\<2\>\/XI2\<0\>\/XI2\<2\>\/XI2\<2\>\/RI2_pos WLSEL\<552\> ) \
 R_1X_LL w=1e-07 l=1e-07   res=0.149966
XXI2\<2\>\/XI2\<0\>\/XI2\<2\>\/XI2\<1\>\/RR2 (  \
 N_SEL3\<2\>_XI2\<2\>\/XI2\<0\>\/XI2\<2\>\/XI2\<1\>\/RR2_pos WLSEL\<551\> ) \
 R_1X_LL w=1e-07 l=1e-07   res=0.149966
XXI2\<2\>\/XI2\<0\>\/XI2\<2\>\/XI2\<1\>\/RR1 (  \
 N_SEL2\<0\>_XI2\<2\>\/XI2\<0\>\/XI2\<2\>\/XI2\<1\>\/RR1_pos WLSEL\<550\> ) \
 R_1X_LL w=1e-07 l=1e-07   res=0.149966
XXI2\<2\>\/XI2\<0\>\/XI2\<2\>\/XI2\<1\>\/RR0 (  \
 N_SEL1\<2\>_XI2\<2\>\/XI2\<0\>\/XI2\<2\>\/XI2\<1\>\/RR0_pos WLSEL\<549\> ) \
 R_1X_LL w=1e-07 l=1e-07   res=0.149966
XXI2\<2\>\/XI2\<0\>\/XI2\<2\>\/XI2\<1\>\/RI2 (  \
 N_SEL0\<1\>_XI2\<2\>\/XI2\<0\>\/XI2\<2\>\/XI2\<1\>\/RI2_pos WLSEL\<548\> ) \
 R_1X_LL w=1e-07 l=1e-07   res=0.149966
XXI2\<2\>\/XI2\<0\>\/XI2\<2\>\/XI2\<0\>\/RR2 (  \
 N_SEL3\<2\>_XI2\<2\>\/XI2\<0\>\/XI2\<2\>\/XI2\<0\>\/RR2_pos WLSEL\<547\> ) \
 R_1X_LL w=1e-07 l=1e-07   res=0.149966
XXI2\<2\>\/XI2\<0\>\/XI2\<2\>\/XI2\<0\>\/RR1 (  \
 N_SEL2\<0\>_XI2\<2\>\/XI2\<0\>\/XI2\<2\>\/XI2\<0\>\/RR1_pos WLSEL\<546\> ) \
 R_1X_LL w=1e-07 l=1e-07   res=0.149966
XXI2\<2\>\/XI2\<0\>\/XI2\<2\>\/XI2\<0\>\/RR0 (  \
 N_SEL1\<2\>_XI2\<2\>\/XI2\<0\>\/XI2\<2\>\/XI2\<0\>\/RR0_pos WLSEL\<545\> ) \
 R_1X_LL w=1e-07 l=1e-07   res=0.149966
XXI2\<2\>\/XI2\<0\>\/XI2\<2\>\/XI2\<0\>\/RI2 (  \
 N_SEL0\<0\>_XI2\<2\>\/XI2\<0\>\/XI2\<2\>\/XI2\<0\>\/RI2_pos WLSEL\<544\> ) \
 R_1X_LL w=1e-07 l=1e-07   res=0.149966
XXI2\<2\>\/XI2\<0\>\/XI2\<1\>\/XI2\<3\>\/RR2 (  \
 N_SEL3\<2\>_XI2\<2\>\/XI2\<0\>\/XI2\<1\>\/XI2\<3\>\/RR2_pos WLSEL\<543\> ) \
 R_1X_LL w=1e-07 l=1e-07   res=0.149966
XXI2\<2\>\/XI2\<0\>\/XI2\<1\>\/XI2\<3\>\/RR1 (  \
 N_SEL2\<0\>_XI2\<2\>\/XI2\<0\>\/XI2\<1\>\/XI2\<3\>\/RR1_pos WLSEL\<542\> ) \
 R_1X_LL w=1e-07 l=1e-07   res=0.149966
XXI2\<2\>\/XI2\<0\>\/XI2\<1\>\/XI2\<3\>\/RR0 (  \
 N_SEL1\<1\>_XI2\<2\>\/XI2\<0\>\/XI2\<1\>\/XI2\<3\>\/RR0_pos WLSEL\<541\> ) \
 R_1X_LL w=1e-07 l=1e-07   res=0.149966
XXI2\<2\>\/XI2\<0\>\/XI2\<1\>\/XI2\<3\>\/RI2 (  \
 N_SEL0\<3\>_XI2\<2\>\/XI2\<0\>\/XI2\<1\>\/XI2\<3\>\/RI2_pos WLSEL\<540\> ) \
 R_1X_LL w=1e-07 l=1e-07   res=0.149966
XXI2\<2\>\/XI2\<0\>\/XI2\<1\>\/XI2\<2\>\/RR2 (  \
 N_SEL3\<2\>_XI2\<2\>\/XI2\<0\>\/XI2\<1\>\/XI2\<2\>\/RR2_pos WLSEL\<539\> ) \
 R_1X_LL w=1e-07 l=1e-07   res=0.149966
XXI2\<2\>\/XI2\<0\>\/XI2\<1\>\/XI2\<2\>\/RR1 (  \
 N_SEL2\<0\>_XI2\<2\>\/XI2\<0\>\/XI2\<1\>\/XI2\<2\>\/RR1_pos WLSEL\<538\> ) \
 R_1X_LL w=1e-07 l=1e-07   res=0.149966
XXI2\<2\>\/XI2\<0\>\/XI2\<1\>\/XI2\<2\>\/RR0 (  \
 N_SEL1\<1\>_XI2\<2\>\/XI2\<0\>\/XI2\<1\>\/XI2\<2\>\/RR0_pos WLSEL\<537\> ) \
 R_1X_LL w=1e-07 l=1e-07   res=0.149966
XXI2\<2\>\/XI2\<0\>\/XI2\<1\>\/XI2\<2\>\/RI2 (  \
 N_SEL0\<2\>_XI2\<2\>\/XI2\<0\>\/XI2\<1\>\/XI2\<2\>\/RI2_pos WLSEL\<536\> ) \
 R_1X_LL w=1e-07 l=1e-07   res=0.149966
XXI2\<2\>\/XI2\<0\>\/XI2\<1\>\/XI2\<1\>\/RR2 (  \
 N_SEL3\<2\>_XI2\<2\>\/XI2\<0\>\/XI2\<1\>\/XI2\<1\>\/RR2_pos WLSEL\<535\> ) \
 R_1X_LL w=1e-07 l=1e-07   res=0.149966
XXI2\<2\>\/XI2\<0\>\/XI2\<1\>\/XI2\<1\>\/RR1 (  \
 N_SEL2\<0\>_XI2\<2\>\/XI2\<0\>\/XI2\<1\>\/XI2\<1\>\/RR1_pos WLSEL\<534\> ) \
 R_1X_LL w=1e-07 l=1e-07   res=0.149966
XXI2\<2\>\/XI2\<0\>\/XI2\<1\>\/XI2\<1\>\/RR0 (  \
 N_SEL1\<1\>_XI2\<2\>\/XI2\<0\>\/XI2\<1\>\/XI2\<1\>\/RR0_pos WLSEL\<533\> ) \
 R_1X_LL w=1e-07 l=1e-07   res=0.149966
XXI2\<2\>\/XI2\<0\>\/XI2\<1\>\/XI2\<1\>\/RI2 (  \
 N_SEL0\<1\>_XI2\<2\>\/XI2\<0\>\/XI2\<1\>\/XI2\<1\>\/RI2_pos WLSEL\<532\> ) \
 R_1X_LL w=1e-07 l=1e-07   res=0.149966
XXI2\<2\>\/XI2\<0\>\/XI2\<1\>\/XI2\<0\>\/RR2 (  \
 N_SEL3\<2\>_XI2\<2\>\/XI2\<0\>\/XI2\<1\>\/XI2\<0\>\/RR2_pos WLSEL\<531\> ) \
 R_1X_LL w=1e-07 l=1e-07   res=0.149966
XXI2\<2\>\/XI2\<0\>\/XI2\<1\>\/XI2\<0\>\/RR1 (  \
 N_SEL2\<0\>_XI2\<2\>\/XI2\<0\>\/XI2\<1\>\/XI2\<0\>\/RR1_pos WLSEL\<530\> ) \
 R_1X_LL w=1e-07 l=1e-07   res=0.149966
XXI2\<2\>\/XI2\<0\>\/XI2\<1\>\/XI2\<0\>\/RR0 (  \
 N_SEL1\<1\>_XI2\<2\>\/XI2\<0\>\/XI2\<1\>\/XI2\<0\>\/RR0_pos WLSEL\<529\> ) \
 R_1X_LL w=1e-07 l=1e-07   res=0.149966
XXI2\<2\>\/XI2\<0\>\/XI2\<1\>\/XI2\<0\>\/RI2 (  \
 N_SEL0\<0\>_XI2\<2\>\/XI2\<0\>\/XI2\<1\>\/XI2\<0\>\/RI2_pos WLSEL\<528\> ) \
 R_1X_LL w=1e-07 l=1e-07   res=0.149966
XXI2\<2\>\/XI2\<0\>\/XI2\<0\>\/XI2\<3\>\/RR2 (  \
 N_SEL3\<2\>_XI2\<2\>\/XI2\<0\>\/XI2\<0\>\/XI2\<3\>\/RR2_pos WLSEL\<527\> ) \
 R_1X_LL w=1e-07 l=1e-07   res=0.149966
XXI2\<2\>\/XI2\<0\>\/XI2\<0\>\/XI2\<3\>\/RR1 (  \
 N_SEL2\<0\>_XI2\<2\>\/XI2\<0\>\/XI2\<0\>\/XI2\<3\>\/RR1_pos WLSEL\<526\> ) \
 R_1X_LL w=1e-07 l=1e-07   res=0.149966
XXI2\<2\>\/XI2\<0\>\/XI2\<0\>\/XI2\<3\>\/RR0 (  \
 N_SEL1\<0\>_XI2\<2\>\/XI2\<0\>\/XI2\<0\>\/XI2\<3\>\/RR0_pos WLSEL\<525\> ) \
 R_1X_LL w=1e-07 l=1e-07   res=0.149966
XXI2\<2\>\/XI2\<0\>\/XI2\<0\>\/XI2\<3\>\/RI2 (  \
 N_SEL0\<3\>_XI2\<2\>\/XI2\<0\>\/XI2\<0\>\/XI2\<3\>\/RI2_pos WLSEL\<524\> ) \
 R_1X_LL w=1e-07 l=1e-07   res=0.149966
XXI2\<2\>\/XI2\<0\>\/XI2\<0\>\/XI2\<2\>\/RR2 (  \
 N_SEL3\<2\>_XI2\<2\>\/XI2\<0\>\/XI2\<0\>\/XI2\<2\>\/RR2_pos WLSEL\<523\> ) \
 R_1X_LL w=1e-07 l=1e-07   res=0.149966
XXI2\<2\>\/XI2\<0\>\/XI2\<0\>\/XI2\<2\>\/RR1 (  \
 N_SEL2\<0\>_XI2\<2\>\/XI2\<0\>\/XI2\<0\>\/XI2\<2\>\/RR1_pos WLSEL\<522\> ) \
 R_1X_LL w=1e-07 l=1e-07   res=0.149966
XXI2\<2\>\/XI2\<0\>\/XI2\<0\>\/XI2\<2\>\/RR0 (  \
 N_SEL1\<0\>_XI2\<2\>\/XI2\<0\>\/XI2\<0\>\/XI2\<2\>\/RR0_pos WLSEL\<521\> ) \
 R_1X_LL w=1e-07 l=1e-07   res=0.149966
XXI2\<2\>\/XI2\<0\>\/XI2\<0\>\/XI2\<2\>\/RI2 (  \
 N_SEL0\<2\>_XI2\<2\>\/XI2\<0\>\/XI2\<0\>\/XI2\<2\>\/RI2_pos WLSEL\<520\> ) \
 R_1X_LL w=1e-07 l=1e-07   res=0.149966
XXI2\<2\>\/XI2\<0\>\/XI2\<0\>\/XI2\<1\>\/RR2 (  \
 N_SEL3\<2\>_XI2\<2\>\/XI2\<0\>\/XI2\<0\>\/XI2\<1\>\/RR2_pos WLSEL\<519\> ) \
 R_1X_LL w=1e-07 l=1e-07   res=0.149966
XXI2\<2\>\/XI2\<0\>\/XI2\<0\>\/XI2\<1\>\/RR1 (  \
 N_SEL2\<0\>_XI2\<2\>\/XI2\<0\>\/XI2\<0\>\/XI2\<1\>\/RR1_pos WLSEL\<518\> ) \
 R_1X_LL w=1e-07 l=1e-07   res=0.149966
XXI2\<2\>\/XI2\<0\>\/XI2\<0\>\/XI2\<1\>\/RR0 (  \
 N_SEL1\<0\>_XI2\<2\>\/XI2\<0\>\/XI2\<0\>\/XI2\<1\>\/RR0_pos WLSEL\<517\> ) \
 R_1X_LL w=1e-07 l=1e-07   res=0.149966
XXI2\<2\>\/XI2\<0\>\/XI2\<0\>\/XI2\<1\>\/RI2 (  \
 N_SEL0\<1\>_XI2\<2\>\/XI2\<0\>\/XI2\<0\>\/XI2\<1\>\/RI2_pos WLSEL\<516\> ) \
 R_1X_LL w=1e-07 l=1e-07   res=0.149966
XXI2\<2\>\/XI2\<0\>\/XI2\<0\>\/XI2\<0\>\/RR2 (  \
 N_SEL3\<2\>_XI2\<2\>\/XI2\<0\>\/XI2\<0\>\/XI2\<0\>\/RR2_pos WLSEL\<515\> ) \
 R_1X_LL w=1e-07 l=1e-07   res=0.149966
XXI2\<2\>\/XI2\<0\>\/XI2\<0\>\/XI2\<0\>\/RR1 (  \
 N_SEL2\<0\>_XI2\<2\>\/XI2\<0\>\/XI2\<0\>\/XI2\<0\>\/RR1_pos WLSEL\<514\> ) \
 R_1X_LL w=1e-07 l=1e-07   res=0.149966
XXI2\<2\>\/XI2\<0\>\/XI2\<0\>\/XI2\<0\>\/RR0 (  \
 N_SEL1\<0\>_XI2\<2\>\/XI2\<0\>\/XI2\<0\>\/XI2\<0\>\/RR0_pos WLSEL\<513\> ) \
 R_1X_LL w=1e-07 l=1e-07   res=0.149966
XXI2\<2\>\/XI2\<0\>\/XI2\<0\>\/XI2\<0\>\/RI2 (  \
 N_SEL0\<0\>_XI2\<2\>\/XI2\<0\>\/XI2\<0\>\/XI2\<0\>\/RI2_pos WLSEL\<512\> ) \
 R_1X_LL w=1e-07 l=1e-07   res=0.149966
XXI2\<1\>\/XI2\<3\>\/XI2\<3\>\/XI2\<3\>\/RR2 (  \
 N_SEL3\<1\>_XI2\<1\>\/XI2\<3\>\/XI2\<3\>\/XI2\<3\>\/RR2_pos WLSEL\<511\> ) \
 R_1X_LL w=1e-07 l=1e-07   res=0.149966
XXI2\<1\>\/XI2\<3\>\/XI2\<3\>\/XI2\<3\>\/RR1 (  \
 N_SEL2\<3\>_XI2\<1\>\/XI2\<3\>\/XI2\<3\>\/XI2\<3\>\/RR1_pos WLSEL\<510\> ) \
 R_1X_LL w=1e-07 l=1e-07   res=0.149966
XXI2\<1\>\/XI2\<3\>\/XI2\<3\>\/XI2\<3\>\/RR0 (  \
 N_SEL1\<3\>_XI2\<1\>\/XI2\<3\>\/XI2\<3\>\/XI2\<3\>\/RR0_pos WLSEL\<509\> ) \
 R_1X_LL w=1e-07 l=1e-07   res=0.149966
XXI2\<1\>\/XI2\<3\>\/XI2\<3\>\/XI2\<3\>\/RI2 (  \
 N_SEL0\<3\>_XI2\<1\>\/XI2\<3\>\/XI2\<3\>\/XI2\<3\>\/RI2_pos WLSEL\<508\> ) \
 R_1X_LL w=1e-07 l=1e-07   res=0.149966
XXI2\<1\>\/XI2\<3\>\/XI2\<3\>\/XI2\<2\>\/RR2 (  \
 N_SEL3\<1\>_XI2\<1\>\/XI2\<3\>\/XI2\<3\>\/XI2\<2\>\/RR2_pos WLSEL\<507\> ) \
 R_1X_LL w=1e-07 l=1e-07   res=0.149966
XXI2\<1\>\/XI2\<3\>\/XI2\<3\>\/XI2\<2\>\/RR1 (  \
 N_SEL2\<3\>_XI2\<1\>\/XI2\<3\>\/XI2\<3\>\/XI2\<2\>\/RR1_pos WLSEL\<506\> ) \
 R_1X_LL w=1e-07 l=1e-07   res=0.149966
XXI2\<1\>\/XI2\<3\>\/XI2\<3\>\/XI2\<2\>\/RR0 (  \
 N_SEL1\<3\>_XI2\<1\>\/XI2\<3\>\/XI2\<3\>\/XI2\<2\>\/RR0_pos WLSEL\<505\> ) \
 R_1X_LL w=1e-07 l=1e-07   res=0.149966
XXI2\<1\>\/XI2\<3\>\/XI2\<3\>\/XI2\<2\>\/RI2 (  \
 N_SEL0\<2\>_XI2\<1\>\/XI2\<3\>\/XI2\<3\>\/XI2\<2\>\/RI2_pos WLSEL\<504\> ) \
 R_1X_LL w=1e-07 l=1e-07   res=0.149966
XXI2\<1\>\/XI2\<3\>\/XI2\<3\>\/XI2\<1\>\/RR2 (  \
 N_SEL3\<1\>_XI2\<1\>\/XI2\<3\>\/XI2\<3\>\/XI2\<1\>\/RR2_pos WLSEL\<503\> ) \
 R_1X_LL w=1e-07 l=1e-07   res=0.149966
XXI2\<1\>\/XI2\<3\>\/XI2\<3\>\/XI2\<1\>\/RR1 (  \
 N_SEL2\<3\>_XI2\<1\>\/XI2\<3\>\/XI2\<3\>\/XI2\<1\>\/RR1_pos WLSEL\<502\> ) \
 R_1X_LL w=1e-07 l=1e-07   res=0.149966
XXI2\<1\>\/XI2\<3\>\/XI2\<3\>\/XI2\<1\>\/RR0 (  \
 N_SEL1\<3\>_XI2\<1\>\/XI2\<3\>\/XI2\<3\>\/XI2\<1\>\/RR0_pos WLSEL\<501\> ) \
 R_1X_LL w=1e-07 l=1e-07   res=0.149966
XXI2\<1\>\/XI2\<3\>\/XI2\<3\>\/XI2\<1\>\/RI2 (  \
 N_SEL0\<1\>_XI2\<1\>\/XI2\<3\>\/XI2\<3\>\/XI2\<1\>\/RI2_pos WLSEL\<500\> ) \
 R_1X_LL w=1e-07 l=1e-07   res=0.149966
XXI2\<1\>\/XI2\<3\>\/XI2\<3\>\/XI2\<0\>\/RR2 (  \
 N_SEL3\<1\>_XI2\<1\>\/XI2\<3\>\/XI2\<3\>\/XI2\<0\>\/RR2_pos WLSEL\<499\> ) \
 R_1X_LL w=1e-07 l=1e-07   res=0.149966
XXI2\<1\>\/XI2\<3\>\/XI2\<3\>\/XI2\<0\>\/RR1 (  \
 N_SEL2\<3\>_XI2\<1\>\/XI2\<3\>\/XI2\<3\>\/XI2\<0\>\/RR1_pos WLSEL\<498\> ) \
 R_1X_LL w=1e-07 l=1e-07   res=0.149966
XXI2\<1\>\/XI2\<3\>\/XI2\<3\>\/XI2\<0\>\/RR0 (  \
 N_SEL1\<3\>_XI2\<1\>\/XI2\<3\>\/XI2\<3\>\/XI2\<0\>\/RR0_pos WLSEL\<497\> ) \
 R_1X_LL w=1e-07 l=1e-07   res=0.149966
XXI2\<1\>\/XI2\<3\>\/XI2\<3\>\/XI2\<0\>\/RI2 (  \
 N_SEL0\<0\>_XI2\<1\>\/XI2\<3\>\/XI2\<3\>\/XI2\<0\>\/RI2_pos WLSEL\<496\> ) \
 R_1X_LL w=1e-07 l=1e-07   res=0.149966
XXI2\<1\>\/XI2\<3\>\/XI2\<2\>\/XI2\<3\>\/RR2 (  \
 N_SEL3\<1\>_XI2\<1\>\/XI2\<3\>\/XI2\<2\>\/XI2\<3\>\/RR2_pos WLSEL\<495\> ) \
 R_1X_LL w=1e-07 l=1e-07   res=0.149966
XXI2\<1\>\/XI2\<3\>\/XI2\<2\>\/XI2\<3\>\/RR1 (  \
 N_SEL2\<3\>_XI2\<1\>\/XI2\<3\>\/XI2\<2\>\/XI2\<3\>\/RR1_pos WLSEL\<494\> ) \
 R_1X_LL w=1e-07 l=1e-07   res=0.149966
XXI2\<1\>\/XI2\<3\>\/XI2\<2\>\/XI2\<3\>\/RR0 (  \
 N_SEL1\<2\>_XI2\<1\>\/XI2\<3\>\/XI2\<2\>\/XI2\<3\>\/RR0_pos WLSEL\<493\> ) \
 R_1X_LL w=1e-07 l=1e-07   res=0.149966
XXI2\<1\>\/XI2\<3\>\/XI2\<2\>\/XI2\<3\>\/RI2 (  \
 N_SEL0\<3\>_XI2\<1\>\/XI2\<3\>\/XI2\<2\>\/XI2\<3\>\/RI2_pos WLSEL\<492\> ) \
 R_1X_LL w=1e-07 l=1e-07   res=0.149966
XXI2\<1\>\/XI2\<3\>\/XI2\<2\>\/XI2\<2\>\/RR2 (  \
 N_SEL3\<1\>_XI2\<1\>\/XI2\<3\>\/XI2\<2\>\/XI2\<2\>\/RR2_pos WLSEL\<491\> ) \
 R_1X_LL w=1e-07 l=1e-07   res=0.149966
XXI2\<1\>\/XI2\<3\>\/XI2\<2\>\/XI2\<2\>\/RR1 (  \
 N_SEL2\<3\>_XI2\<1\>\/XI2\<3\>\/XI2\<2\>\/XI2\<2\>\/RR1_pos WLSEL\<490\> ) \
 R_1X_LL w=1e-07 l=1e-07   res=0.149966
XXI2\<1\>\/XI2\<3\>\/XI2\<2\>\/XI2\<2\>\/RR0 (  \
 N_SEL1\<2\>_XI2\<1\>\/XI2\<3\>\/XI2\<2\>\/XI2\<2\>\/RR0_pos WLSEL\<489\> ) \
 R_1X_LL w=1e-07 l=1e-07   res=0.149966
XXI2\<1\>\/XI2\<3\>\/XI2\<2\>\/XI2\<2\>\/RI2 (  \
 N_SEL0\<2\>_XI2\<1\>\/XI2\<3\>\/XI2\<2\>\/XI2\<2\>\/RI2_pos WLSEL\<488\> ) \
 R_1X_LL w=1e-07 l=1e-07   res=0.149966
XXI2\<1\>\/XI2\<3\>\/XI2\<2\>\/XI2\<1\>\/RR2 (  \
 N_SEL3\<1\>_XI2\<1\>\/XI2\<3\>\/XI2\<2\>\/XI2\<1\>\/RR2_pos WLSEL\<487\> ) \
 R_1X_LL w=1e-07 l=1e-07   res=0.149966
XXI2\<1\>\/XI2\<3\>\/XI2\<2\>\/XI2\<1\>\/RR1 (  \
 N_SEL2\<3\>_XI2\<1\>\/XI2\<3\>\/XI2\<2\>\/XI2\<1\>\/RR1_pos WLSEL\<486\> ) \
 R_1X_LL w=1e-07 l=1e-07   res=0.149966
XXI2\<1\>\/XI2\<3\>\/XI2\<2\>\/XI2\<1\>\/RR0 (  \
 N_SEL1\<2\>_XI2\<1\>\/XI2\<3\>\/XI2\<2\>\/XI2\<1\>\/RR0_pos WLSEL\<485\> ) \
 R_1X_LL w=1e-07 l=1e-07   res=0.149966
XXI2\<1\>\/XI2\<3\>\/XI2\<2\>\/XI2\<1\>\/RI2 (  \
 N_SEL0\<1\>_XI2\<1\>\/XI2\<3\>\/XI2\<2\>\/XI2\<1\>\/RI2_pos WLSEL\<484\> ) \
 R_1X_LL w=1e-07 l=1e-07   res=0.149966
XXI2\<1\>\/XI2\<3\>\/XI2\<2\>\/XI2\<0\>\/RR2 (  \
 N_SEL3\<1\>_XI2\<1\>\/XI2\<3\>\/XI2\<2\>\/XI2\<0\>\/RR2_pos WLSEL\<483\> ) \
 R_1X_LL w=1e-07 l=1e-07   res=0.149966
XXI2\<1\>\/XI2\<3\>\/XI2\<2\>\/XI2\<0\>\/RR1 (  \
 N_SEL2\<3\>_XI2\<1\>\/XI2\<3\>\/XI2\<2\>\/XI2\<0\>\/RR1_pos WLSEL\<482\> ) \
 R_1X_LL w=1e-07 l=1e-07   res=0.149966
XXI2\<1\>\/XI2\<3\>\/XI2\<2\>\/XI2\<0\>\/RR0 (  \
 N_SEL1\<2\>_XI2\<1\>\/XI2\<3\>\/XI2\<2\>\/XI2\<0\>\/RR0_pos WLSEL\<481\> ) \
 R_1X_LL w=1e-07 l=1e-07   res=0.149966
XXI2\<1\>\/XI2\<3\>\/XI2\<2\>\/XI2\<0\>\/RI2 (  \
 N_SEL0\<0\>_XI2\<1\>\/XI2\<3\>\/XI2\<2\>\/XI2\<0\>\/RI2_pos WLSEL\<480\> ) \
 R_1X_LL w=1e-07 l=1e-07   res=0.149966
XXI2\<1\>\/XI2\<3\>\/XI2\<1\>\/XI2\<3\>\/RR2 (  \
 N_SEL3\<1\>_XI2\<1\>\/XI2\<3\>\/XI2\<1\>\/XI2\<3\>\/RR2_pos WLSEL\<479\> ) \
 R_1X_LL w=1e-07 l=1e-07   res=0.149966
XXI2\<1\>\/XI2\<3\>\/XI2\<1\>\/XI2\<3\>\/RR1 (  \
 N_SEL2\<3\>_XI2\<1\>\/XI2\<3\>\/XI2\<1\>\/XI2\<3\>\/RR1_pos WLSEL\<478\> ) \
 R_1X_LL w=1e-07 l=1e-07   res=0.149966
XXI2\<1\>\/XI2\<3\>\/XI2\<1\>\/XI2\<3\>\/RR0 (  \
 N_SEL1\<1\>_XI2\<1\>\/XI2\<3\>\/XI2\<1\>\/XI2\<3\>\/RR0_pos WLSEL\<477\> ) \
 R_1X_LL w=1e-07 l=1e-07   res=0.149966
XXI2\<1\>\/XI2\<3\>\/XI2\<1\>\/XI2\<3\>\/RI2 (  \
 N_SEL0\<3\>_XI2\<1\>\/XI2\<3\>\/XI2\<1\>\/XI2\<3\>\/RI2_pos WLSEL\<476\> ) \
 R_1X_LL w=1e-07 l=1e-07   res=0.149966
XXI2\<1\>\/XI2\<3\>\/XI2\<1\>\/XI2\<2\>\/RR2 (  \
 N_SEL3\<1\>_XI2\<1\>\/XI2\<3\>\/XI2\<1\>\/XI2\<2\>\/RR2_pos WLSEL\<475\> ) \
 R_1X_LL w=1e-07 l=1e-07   res=0.149966
XXI2\<1\>\/XI2\<3\>\/XI2\<1\>\/XI2\<2\>\/RR1 (  \
 N_SEL2\<3\>_XI2\<1\>\/XI2\<3\>\/XI2\<1\>\/XI2\<2\>\/RR1_pos WLSEL\<474\> ) \
 R_1X_LL w=1e-07 l=1e-07   res=0.149966
XXI2\<1\>\/XI2\<3\>\/XI2\<1\>\/XI2\<2\>\/RR0 (  \
 N_SEL1\<1\>_XI2\<1\>\/XI2\<3\>\/XI2\<1\>\/XI2\<2\>\/RR0_pos WLSEL\<473\> ) \
 R_1X_LL w=1e-07 l=1e-07   res=0.149966
XXI2\<1\>\/XI2\<3\>\/XI2\<1\>\/XI2\<2\>\/RI2 (  \
 N_SEL0\<2\>_XI2\<1\>\/XI2\<3\>\/XI2\<1\>\/XI2\<2\>\/RI2_pos WLSEL\<472\> ) \
 R_1X_LL w=1e-07 l=1e-07   res=0.149966
XXI2\<1\>\/XI2\<3\>\/XI2\<1\>\/XI2\<1\>\/RR2 (  \
 N_SEL3\<1\>_XI2\<1\>\/XI2\<3\>\/XI2\<1\>\/XI2\<1\>\/RR2_pos WLSEL\<471\> ) \
 R_1X_LL w=1e-07 l=1e-07   res=0.149966
XXI2\<1\>\/XI2\<3\>\/XI2\<1\>\/XI2\<1\>\/RR1 (  \
 N_SEL2\<3\>_XI2\<1\>\/XI2\<3\>\/XI2\<1\>\/XI2\<1\>\/RR1_pos WLSEL\<470\> ) \
 R_1X_LL w=1e-07 l=1e-07   res=0.149966
XXI2\<1\>\/XI2\<3\>\/XI2\<1\>\/XI2\<1\>\/RR0 (  \
 N_SEL1\<1\>_XI2\<1\>\/XI2\<3\>\/XI2\<1\>\/XI2\<1\>\/RR0_pos WLSEL\<469\> ) \
 R_1X_LL w=1e-07 l=1e-07   res=0.149966
XXI2\<1\>\/XI2\<3\>\/XI2\<1\>\/XI2\<1\>\/RI2 (  \
 N_SEL0\<1\>_XI2\<1\>\/XI2\<3\>\/XI2\<1\>\/XI2\<1\>\/RI2_pos WLSEL\<468\> ) \
 R_1X_LL w=1e-07 l=1e-07   res=0.149966
XXI2\<1\>\/XI2\<3\>\/XI2\<1\>\/XI2\<0\>\/RR2 (  \
 N_SEL3\<1\>_XI2\<1\>\/XI2\<3\>\/XI2\<1\>\/XI2\<0\>\/RR2_pos WLSEL\<467\> ) \
 R_1X_LL w=1e-07 l=1e-07   res=0.149966
XXI2\<1\>\/XI2\<3\>\/XI2\<1\>\/XI2\<0\>\/RR1 (  \
 N_SEL2\<3\>_XI2\<1\>\/XI2\<3\>\/XI2\<1\>\/XI2\<0\>\/RR1_pos WLSEL\<466\> ) \
 R_1X_LL w=1e-07 l=1e-07   res=0.149966
XXI2\<1\>\/XI2\<3\>\/XI2\<1\>\/XI2\<0\>\/RR0 (  \
 N_SEL1\<1\>_XI2\<1\>\/XI2\<3\>\/XI2\<1\>\/XI2\<0\>\/RR0_pos WLSEL\<465\> ) \
 R_1X_LL w=1e-07 l=1e-07   res=0.149966
XXI2\<1\>\/XI2\<3\>\/XI2\<1\>\/XI2\<0\>\/RI2 (  \
 N_SEL0\<0\>_XI2\<1\>\/XI2\<3\>\/XI2\<1\>\/XI2\<0\>\/RI2_pos WLSEL\<464\> ) \
 R_1X_LL w=1e-07 l=1e-07   res=0.149966
XXI2\<1\>\/XI2\<3\>\/XI2\<0\>\/XI2\<3\>\/RR2 (  \
 N_SEL3\<1\>_XI2\<1\>\/XI2\<3\>\/XI2\<0\>\/XI2\<3\>\/RR2_pos WLSEL\<463\> ) \
 R_1X_LL w=1e-07 l=1e-07   res=0.149966
XXI2\<1\>\/XI2\<3\>\/XI2\<0\>\/XI2\<3\>\/RR1 (  \
 N_SEL2\<3\>_XI2\<1\>\/XI2\<3\>\/XI2\<0\>\/XI2\<3\>\/RR1_pos WLSEL\<462\> ) \
 R_1X_LL w=1e-07 l=1e-07   res=0.149966
XXI2\<1\>\/XI2\<3\>\/XI2\<0\>\/XI2\<3\>\/RR0 (  \
 N_SEL1\<0\>_XI2\<1\>\/XI2\<3\>\/XI2\<0\>\/XI2\<3\>\/RR0_pos WLSEL\<461\> ) \
 R_1X_LL w=1e-07 l=1e-07   res=0.149966
XXI2\<1\>\/XI2\<3\>\/XI2\<0\>\/XI2\<3\>\/RI2 (  \
 N_SEL0\<3\>_XI2\<1\>\/XI2\<3\>\/XI2\<0\>\/XI2\<3\>\/RI2_pos WLSEL\<460\> ) \
 R_1X_LL w=1e-07 l=1e-07   res=0.149966
XXI2\<1\>\/XI2\<3\>\/XI2\<0\>\/XI2\<2\>\/RR2 (  \
 N_SEL3\<1\>_XI2\<1\>\/XI2\<3\>\/XI2\<0\>\/XI2\<2\>\/RR2_pos WLSEL\<459\> ) \
 R_1X_LL w=1e-07 l=1e-07   res=0.149966
XXI2\<1\>\/XI2\<3\>\/XI2\<0\>\/XI2\<2\>\/RR1 (  \
 N_SEL2\<3\>_XI2\<1\>\/XI2\<3\>\/XI2\<0\>\/XI2\<2\>\/RR1_pos WLSEL\<458\> ) \
 R_1X_LL w=1e-07 l=1e-07   res=0.149966
XXI2\<1\>\/XI2\<3\>\/XI2\<0\>\/XI2\<2\>\/RR0 (  \
 N_SEL1\<0\>_XI2\<1\>\/XI2\<3\>\/XI2\<0\>\/XI2\<2\>\/RR0_pos WLSEL\<457\> ) \
 R_1X_LL w=1e-07 l=1e-07   res=0.149966
XXI2\<1\>\/XI2\<3\>\/XI2\<0\>\/XI2\<2\>\/RI2 (  \
 N_SEL0\<2\>_XI2\<1\>\/XI2\<3\>\/XI2\<0\>\/XI2\<2\>\/RI2_pos WLSEL\<456\> ) \
 R_1X_LL w=1e-07 l=1e-07   res=0.149966
XXI2\<1\>\/XI2\<3\>\/XI2\<0\>\/XI2\<1\>\/RR2 (  \
 N_SEL3\<1\>_XI2\<1\>\/XI2\<3\>\/XI2\<0\>\/XI2\<1\>\/RR2_pos WLSEL\<455\> ) \
 R_1X_LL w=1e-07 l=1e-07   res=0.149966
XXI2\<1\>\/XI2\<3\>\/XI2\<0\>\/XI2\<1\>\/RR1 (  \
 N_SEL2\<3\>_XI2\<1\>\/XI2\<3\>\/XI2\<0\>\/XI2\<1\>\/RR1_pos WLSEL\<454\> ) \
 R_1X_LL w=1e-07 l=1e-07   res=0.149966
XXI2\<1\>\/XI2\<3\>\/XI2\<0\>\/XI2\<1\>\/RR0 (  \
 N_SEL1\<0\>_XI2\<1\>\/XI2\<3\>\/XI2\<0\>\/XI2\<1\>\/RR0_pos WLSEL\<453\> ) \
 R_1X_LL w=1e-07 l=1e-07   res=0.149966
XXI2\<1\>\/XI2\<3\>\/XI2\<0\>\/XI2\<1\>\/RI2 (  \
 N_SEL0\<1\>_XI2\<1\>\/XI2\<3\>\/XI2\<0\>\/XI2\<1\>\/RI2_pos WLSEL\<452\> ) \
 R_1X_LL w=1e-07 l=1e-07   res=0.149966
XXI2\<1\>\/XI2\<3\>\/XI2\<0\>\/XI2\<0\>\/RR2 (  \
 N_SEL3\<1\>_XI2\<1\>\/XI2\<3\>\/XI2\<0\>\/XI2\<0\>\/RR2_pos WLSEL\<451\> ) \
 R_1X_LL w=1e-07 l=1e-07   res=0.149966
XXI2\<1\>\/XI2\<3\>\/XI2\<0\>\/XI2\<0\>\/RR1 (  \
 N_SEL2\<3\>_XI2\<1\>\/XI2\<3\>\/XI2\<0\>\/XI2\<0\>\/RR1_pos WLSEL\<450\> ) \
 R_1X_LL w=1e-07 l=1e-07   res=0.149966
XXI2\<1\>\/XI2\<3\>\/XI2\<0\>\/XI2\<0\>\/RR0 (  \
 N_SEL1\<0\>_XI2\<1\>\/XI2\<3\>\/XI2\<0\>\/XI2\<0\>\/RR0_pos WLSEL\<449\> ) \
 R_1X_LL w=1e-07 l=1e-07   res=0.149966
XXI2\<1\>\/XI2\<3\>\/XI2\<0\>\/XI2\<0\>\/RI2 (  \
 N_SEL0\<0\>_XI2\<1\>\/XI2\<3\>\/XI2\<0\>\/XI2\<0\>\/RI2_pos WLSEL\<448\> ) \
 R_1X_LL w=1e-07 l=1e-07   res=0.149966
XXI2\<1\>\/XI2\<2\>\/XI2\<3\>\/XI2\<3\>\/RR2 (  \
 N_SEL3\<1\>_XI2\<1\>\/XI2\<2\>\/XI2\<3\>\/XI2\<3\>\/RR2_pos WLSEL\<447\> ) \
 R_1X_LL w=1e-07 l=1e-07   res=0.149966
XXI2\<1\>\/XI2\<2\>\/XI2\<3\>\/XI2\<3\>\/RR1 (  \
 N_SEL2\<2\>_XI2\<1\>\/XI2\<2\>\/XI2\<3\>\/XI2\<3\>\/RR1_pos WLSEL\<446\> ) \
 R_1X_LL w=1e-07 l=1e-07   res=0.149966
XXI2\<1\>\/XI2\<2\>\/XI2\<3\>\/XI2\<3\>\/RR0 (  \
 N_SEL1\<3\>_XI2\<1\>\/XI2\<2\>\/XI2\<3\>\/XI2\<3\>\/RR0_pos WLSEL\<445\> ) \
 R_1X_LL w=1e-07 l=1e-07   res=0.149966
XXI2\<1\>\/XI2\<2\>\/XI2\<3\>\/XI2\<3\>\/RI2 (  \
 N_SEL0\<3\>_XI2\<1\>\/XI2\<2\>\/XI2\<3\>\/XI2\<3\>\/RI2_pos WLSEL\<444\> ) \
 R_1X_LL w=1e-07 l=1e-07   res=0.149966
XXI2\<1\>\/XI2\<2\>\/XI2\<3\>\/XI2\<2\>\/RR2 (  \
 N_SEL3\<1\>_XI2\<1\>\/XI2\<2\>\/XI2\<3\>\/XI2\<2\>\/RR2_pos WLSEL\<443\> ) \
 R_1X_LL w=1e-07 l=1e-07   res=0.149966
XXI2\<1\>\/XI2\<2\>\/XI2\<3\>\/XI2\<2\>\/RR1 (  \
 N_SEL2\<2\>_XI2\<1\>\/XI2\<2\>\/XI2\<3\>\/XI2\<2\>\/RR1_pos WLSEL\<442\> ) \
 R_1X_LL w=1e-07 l=1e-07   res=0.149966
XXI2\<1\>\/XI2\<2\>\/XI2\<3\>\/XI2\<2\>\/RR0 (  \
 N_SEL1\<3\>_XI2\<1\>\/XI2\<2\>\/XI2\<3\>\/XI2\<2\>\/RR0_pos WLSEL\<441\> ) \
 R_1X_LL w=1e-07 l=1e-07   res=0.149966
XXI2\<1\>\/XI2\<2\>\/XI2\<3\>\/XI2\<2\>\/RI2 (  \
 N_SEL0\<2\>_XI2\<1\>\/XI2\<2\>\/XI2\<3\>\/XI2\<2\>\/RI2_pos WLSEL\<440\> ) \
 R_1X_LL w=1e-07 l=1e-07   res=0.149966
XXI2\<1\>\/XI2\<2\>\/XI2\<3\>\/XI2\<1\>\/RR2 (  \
 N_SEL3\<1\>_XI2\<1\>\/XI2\<2\>\/XI2\<3\>\/XI2\<1\>\/RR2_pos WLSEL\<439\> ) \
 R_1X_LL w=1e-07 l=1e-07   res=0.149966
XXI2\<1\>\/XI2\<2\>\/XI2\<3\>\/XI2\<1\>\/RR1 (  \
 N_SEL2\<2\>_XI2\<1\>\/XI2\<2\>\/XI2\<3\>\/XI2\<1\>\/RR1_pos WLSEL\<438\> ) \
 R_1X_LL w=1e-07 l=1e-07   res=0.149966
XXI2\<1\>\/XI2\<2\>\/XI2\<3\>\/XI2\<1\>\/RR0 (  \
 N_SEL1\<3\>_XI2\<1\>\/XI2\<2\>\/XI2\<3\>\/XI2\<1\>\/RR0_pos WLSEL\<437\> ) \
 R_1X_LL w=1e-07 l=1e-07   res=0.149966
XXI2\<1\>\/XI2\<2\>\/XI2\<3\>\/XI2\<1\>\/RI2 (  \
 N_SEL0\<1\>_XI2\<1\>\/XI2\<2\>\/XI2\<3\>\/XI2\<1\>\/RI2_pos WLSEL\<436\> ) \
 R_1X_LL w=1e-07 l=1e-07   res=0.149966
XXI2\<1\>\/XI2\<2\>\/XI2\<3\>\/XI2\<0\>\/RR2 (  \
 N_SEL3\<1\>_XI2\<1\>\/XI2\<2\>\/XI2\<3\>\/XI2\<0\>\/RR2_pos WLSEL\<435\> ) \
 R_1X_LL w=1e-07 l=1e-07   res=0.149966
XXI2\<1\>\/XI2\<2\>\/XI2\<3\>\/XI2\<0\>\/RR1 (  \
 N_SEL2\<2\>_XI2\<1\>\/XI2\<2\>\/XI2\<3\>\/XI2\<0\>\/RR1_pos WLSEL\<434\> ) \
 R_1X_LL w=1e-07 l=1e-07   res=0.149966
XXI2\<1\>\/XI2\<2\>\/XI2\<3\>\/XI2\<0\>\/RR0 (  \
 N_SEL1\<3\>_XI2\<1\>\/XI2\<2\>\/XI2\<3\>\/XI2\<0\>\/RR0_pos WLSEL\<433\> ) \
 R_1X_LL w=1e-07 l=1e-07   res=0.149966
XXI2\<1\>\/XI2\<2\>\/XI2\<3\>\/XI2\<0\>\/RI2 (  \
 N_SEL0\<0\>_XI2\<1\>\/XI2\<2\>\/XI2\<3\>\/XI2\<0\>\/RI2_pos WLSEL\<432\> ) \
 R_1X_LL w=1e-07 l=1e-07   res=0.149966
XXI2\<1\>\/XI2\<2\>\/XI2\<2\>\/XI2\<3\>\/RR2 (  \
 N_SEL3\<1\>_XI2\<1\>\/XI2\<2\>\/XI2\<2\>\/XI2\<3\>\/RR2_pos WLSEL\<431\> ) \
 R_1X_LL w=1e-07 l=1e-07   res=0.149966
XXI2\<1\>\/XI2\<2\>\/XI2\<2\>\/XI2\<3\>\/RR1 (  \
 N_SEL2\<2\>_XI2\<1\>\/XI2\<2\>\/XI2\<2\>\/XI2\<3\>\/RR1_pos WLSEL\<430\> ) \
 R_1X_LL w=1e-07 l=1e-07   res=0.149966
XXI2\<1\>\/XI2\<2\>\/XI2\<2\>\/XI2\<3\>\/RR0 (  \
 N_SEL1\<2\>_XI2\<1\>\/XI2\<2\>\/XI2\<2\>\/XI2\<3\>\/RR0_pos WLSEL\<429\> ) \
 R_1X_LL w=1e-07 l=1e-07   res=0.149966
XXI2\<1\>\/XI2\<2\>\/XI2\<2\>\/XI2\<3\>\/RI2 (  \
 N_SEL0\<3\>_XI2\<1\>\/XI2\<2\>\/XI2\<2\>\/XI2\<3\>\/RI2_pos WLSEL\<428\> ) \
 R_1X_LL w=1e-07 l=1e-07   res=0.149966
XXI2\<1\>\/XI2\<2\>\/XI2\<2\>\/XI2\<2\>\/RR2 (  \
 N_SEL3\<1\>_XI2\<1\>\/XI2\<2\>\/XI2\<2\>\/XI2\<2\>\/RR2_pos WLSEL\<427\> ) \
 R_1X_LL w=1e-07 l=1e-07   res=0.149966
XXI2\<1\>\/XI2\<2\>\/XI2\<2\>\/XI2\<2\>\/RR1 (  \
 N_SEL2\<2\>_XI2\<1\>\/XI2\<2\>\/XI2\<2\>\/XI2\<2\>\/RR1_pos WLSEL\<426\> ) \
 R_1X_LL w=1e-07 l=1e-07   res=0.149966
XXI2\<1\>\/XI2\<2\>\/XI2\<2\>\/XI2\<2\>\/RR0 (  \
 N_SEL1\<2\>_XI2\<1\>\/XI2\<2\>\/XI2\<2\>\/XI2\<2\>\/RR0_pos WLSEL\<425\> ) \
 R_1X_LL w=1e-07 l=1e-07   res=0.149966
XXI2\<1\>\/XI2\<2\>\/XI2\<2\>\/XI2\<2\>\/RI2 (  \
 N_SEL0\<2\>_XI2\<1\>\/XI2\<2\>\/XI2\<2\>\/XI2\<2\>\/RI2_pos WLSEL\<424\> ) \
 R_1X_LL w=1e-07 l=1e-07   res=0.149966
XXI2\<1\>\/XI2\<2\>\/XI2\<2\>\/XI2\<1\>\/RR2 (  \
 N_SEL3\<1\>_XI2\<1\>\/XI2\<2\>\/XI2\<2\>\/XI2\<1\>\/RR2_pos WLSEL\<423\> ) \
 R_1X_LL w=1e-07 l=1e-07   res=0.149966
XXI2\<1\>\/XI2\<2\>\/XI2\<2\>\/XI2\<1\>\/RR1 (  \
 N_SEL2\<2\>_XI2\<1\>\/XI2\<2\>\/XI2\<2\>\/XI2\<1\>\/RR1_pos WLSEL\<422\> ) \
 R_1X_LL w=1e-07 l=1e-07   res=0.149966
XXI2\<1\>\/XI2\<2\>\/XI2\<2\>\/XI2\<1\>\/RR0 (  \
 N_SEL1\<2\>_XI2\<1\>\/XI2\<2\>\/XI2\<2\>\/XI2\<1\>\/RR0_pos WLSEL\<421\> ) \
 R_1X_LL w=1e-07 l=1e-07   res=0.149966
XXI2\<1\>\/XI2\<2\>\/XI2\<2\>\/XI2\<1\>\/RI2 (  \
 N_SEL0\<1\>_XI2\<1\>\/XI2\<2\>\/XI2\<2\>\/XI2\<1\>\/RI2_pos WLSEL\<420\> ) \
 R_1X_LL w=1e-07 l=1e-07   res=0.149966
XXI2\<1\>\/XI2\<2\>\/XI2\<2\>\/XI2\<0\>\/RR2 (  \
 N_SEL3\<1\>_XI2\<1\>\/XI2\<2\>\/XI2\<2\>\/XI2\<0\>\/RR2_pos WLSEL\<419\> ) \
 R_1X_LL w=1e-07 l=1e-07   res=0.149966
XXI2\<1\>\/XI2\<2\>\/XI2\<2\>\/XI2\<0\>\/RR1 (  \
 N_SEL2\<2\>_XI2\<1\>\/XI2\<2\>\/XI2\<2\>\/XI2\<0\>\/RR1_pos WLSEL\<418\> ) \
 R_1X_LL w=1e-07 l=1e-07   res=0.149966
XXI2\<1\>\/XI2\<2\>\/XI2\<2\>\/XI2\<0\>\/RR0 (  \
 N_SEL1\<2\>_XI2\<1\>\/XI2\<2\>\/XI2\<2\>\/XI2\<0\>\/RR0_pos WLSEL\<417\> ) \
 R_1X_LL w=1e-07 l=1e-07   res=0.149966
XXI2\<1\>\/XI2\<2\>\/XI2\<2\>\/XI2\<0\>\/RI2 (  \
 N_SEL0\<0\>_XI2\<1\>\/XI2\<2\>\/XI2\<2\>\/XI2\<0\>\/RI2_pos WLSEL\<416\> ) \
 R_1X_LL w=1e-07 l=1e-07   res=0.149966
XXI2\<1\>\/XI2\<2\>\/XI2\<1\>\/XI2\<3\>\/RR2 (  \
 N_SEL3\<1\>_XI2\<1\>\/XI2\<2\>\/XI2\<1\>\/XI2\<3\>\/RR2_pos WLSEL\<415\> ) \
 R_1X_LL w=1e-07 l=1e-07   res=0.149966
XXI2\<1\>\/XI2\<2\>\/XI2\<1\>\/XI2\<3\>\/RR1 (  \
 N_SEL2\<2\>_XI2\<1\>\/XI2\<2\>\/XI2\<1\>\/XI2\<3\>\/RR1_pos WLSEL\<414\> ) \
 R_1X_LL w=1e-07 l=1e-07   res=0.149966
XXI2\<1\>\/XI2\<2\>\/XI2\<1\>\/XI2\<3\>\/RR0 (  \
 N_SEL1\<1\>_XI2\<1\>\/XI2\<2\>\/XI2\<1\>\/XI2\<3\>\/RR0_pos WLSEL\<413\> ) \
 R_1X_LL w=1e-07 l=1e-07   res=0.149966
XXI2\<1\>\/XI2\<2\>\/XI2\<1\>\/XI2\<3\>\/RI2 (  \
 N_SEL0\<3\>_XI2\<1\>\/XI2\<2\>\/XI2\<1\>\/XI2\<3\>\/RI2_pos WLSEL\<412\> ) \
 R_1X_LL w=1e-07 l=1e-07   res=0.149966
XXI2\<1\>\/XI2\<2\>\/XI2\<1\>\/XI2\<2\>\/RR2 (  \
 N_SEL3\<1\>_XI2\<1\>\/XI2\<2\>\/XI2\<1\>\/XI2\<2\>\/RR2_pos WLSEL\<411\> ) \
 R_1X_LL w=1e-07 l=1e-07   res=0.149966
XXI2\<1\>\/XI2\<2\>\/XI2\<1\>\/XI2\<2\>\/RR1 (  \
 N_SEL2\<2\>_XI2\<1\>\/XI2\<2\>\/XI2\<1\>\/XI2\<2\>\/RR1_pos WLSEL\<410\> ) \
 R_1X_LL w=1e-07 l=1e-07   res=0.149966
XXI2\<1\>\/XI2\<2\>\/XI2\<1\>\/XI2\<2\>\/RR0 (  \
 N_SEL1\<1\>_XI2\<1\>\/XI2\<2\>\/XI2\<1\>\/XI2\<2\>\/RR0_pos WLSEL\<409\> ) \
 R_1X_LL w=1e-07 l=1e-07   res=0.149966
XXI2\<1\>\/XI2\<2\>\/XI2\<1\>\/XI2\<2\>\/RI2 (  \
 N_SEL0\<2\>_XI2\<1\>\/XI2\<2\>\/XI2\<1\>\/XI2\<2\>\/RI2_pos WLSEL\<408\> ) \
 R_1X_LL w=1e-07 l=1e-07   res=0.149966
XXI2\<1\>\/XI2\<2\>\/XI2\<1\>\/XI2\<1\>\/RR2 (  \
 N_SEL3\<1\>_XI2\<1\>\/XI2\<2\>\/XI2\<1\>\/XI2\<1\>\/RR2_pos WLSEL\<407\> ) \
 R_1X_LL w=1e-07 l=1e-07   res=0.149966
XXI2\<1\>\/XI2\<2\>\/XI2\<1\>\/XI2\<1\>\/RR1 (  \
 N_SEL2\<2\>_XI2\<1\>\/XI2\<2\>\/XI2\<1\>\/XI2\<1\>\/RR1_pos WLSEL\<406\> ) \
 R_1X_LL w=1e-07 l=1e-07   res=0.149966
XXI2\<1\>\/XI2\<2\>\/XI2\<1\>\/XI2\<1\>\/RR0 (  \
 N_SEL1\<1\>_XI2\<1\>\/XI2\<2\>\/XI2\<1\>\/XI2\<1\>\/RR0_pos WLSEL\<405\> ) \
 R_1X_LL w=1e-07 l=1e-07   res=0.149966
XXI2\<1\>\/XI2\<2\>\/XI2\<1\>\/XI2\<1\>\/RI2 (  \
 N_SEL0\<1\>_XI2\<1\>\/XI2\<2\>\/XI2\<1\>\/XI2\<1\>\/RI2_pos WLSEL\<404\> ) \
 R_1X_LL w=1e-07 l=1e-07   res=0.149966
XXI2\<1\>\/XI2\<2\>\/XI2\<1\>\/XI2\<0\>\/RR2 (  \
 N_SEL3\<1\>_XI2\<1\>\/XI2\<2\>\/XI2\<1\>\/XI2\<0\>\/RR2_pos WLSEL\<403\> ) \
 R_1X_LL w=1e-07 l=1e-07   res=0.149966
XXI2\<1\>\/XI2\<2\>\/XI2\<1\>\/XI2\<0\>\/RR1 (  \
 N_SEL2\<2\>_XI2\<1\>\/XI2\<2\>\/XI2\<1\>\/XI2\<0\>\/RR1_pos WLSEL\<402\> ) \
 R_1X_LL w=1e-07 l=1e-07   res=0.149966
XXI2\<1\>\/XI2\<2\>\/XI2\<1\>\/XI2\<0\>\/RR0 (  \
 N_SEL1\<1\>_XI2\<1\>\/XI2\<2\>\/XI2\<1\>\/XI2\<0\>\/RR0_pos WLSEL\<401\> ) \
 R_1X_LL w=1e-07 l=1e-07   res=0.149966
XXI2\<1\>\/XI2\<2\>\/XI2\<1\>\/XI2\<0\>\/RI2 (  \
 N_SEL0\<0\>_XI2\<1\>\/XI2\<2\>\/XI2\<1\>\/XI2\<0\>\/RI2_pos WLSEL\<400\> ) \
 R_1X_LL w=1e-07 l=1e-07   res=0.149966
XXI2\<1\>\/XI2\<2\>\/XI2\<0\>\/XI2\<3\>\/RR2 (  \
 N_SEL3\<1\>_XI2\<1\>\/XI2\<2\>\/XI2\<0\>\/XI2\<3\>\/RR2_pos WLSEL\<399\> ) \
 R_1X_LL w=1e-07 l=1e-07   res=0.149966
XXI2\<1\>\/XI2\<2\>\/XI2\<0\>\/XI2\<3\>\/RR1 (  \
 N_SEL2\<2\>_XI2\<1\>\/XI2\<2\>\/XI2\<0\>\/XI2\<3\>\/RR1_pos WLSEL\<398\> ) \
 R_1X_LL w=1e-07 l=1e-07   res=0.149966
XXI2\<1\>\/XI2\<2\>\/XI2\<0\>\/XI2\<3\>\/RR0 (  \
 N_SEL1\<0\>_XI2\<1\>\/XI2\<2\>\/XI2\<0\>\/XI2\<3\>\/RR0_pos WLSEL\<397\> ) \
 R_1X_LL w=1e-07 l=1e-07   res=0.149966
XXI2\<1\>\/XI2\<2\>\/XI2\<0\>\/XI2\<3\>\/RI2 (  \
 N_SEL0\<3\>_XI2\<1\>\/XI2\<2\>\/XI2\<0\>\/XI2\<3\>\/RI2_pos WLSEL\<396\> ) \
 R_1X_LL w=1e-07 l=1e-07   res=0.149966
XXI2\<1\>\/XI2\<2\>\/XI2\<0\>\/XI2\<2\>\/RR2 (  \
 N_SEL3\<1\>_XI2\<1\>\/XI2\<2\>\/XI2\<0\>\/XI2\<2\>\/RR2_pos WLSEL\<395\> ) \
 R_1X_LL w=1e-07 l=1e-07   res=0.149966
XXI2\<1\>\/XI2\<2\>\/XI2\<0\>\/XI2\<2\>\/RR1 (  \
 N_SEL2\<2\>_XI2\<1\>\/XI2\<2\>\/XI2\<0\>\/XI2\<2\>\/RR1_pos WLSEL\<394\> ) \
 R_1X_LL w=1e-07 l=1e-07   res=0.149966
XXI2\<1\>\/XI2\<2\>\/XI2\<0\>\/XI2\<2\>\/RR0 (  \
 N_SEL1\<0\>_XI2\<1\>\/XI2\<2\>\/XI2\<0\>\/XI2\<2\>\/RR0_pos WLSEL\<393\> ) \
 R_1X_LL w=1e-07 l=1e-07   res=0.149966
XXI2\<1\>\/XI2\<2\>\/XI2\<0\>\/XI2\<2\>\/RI2 (  \
 N_SEL0\<2\>_XI2\<1\>\/XI2\<2\>\/XI2\<0\>\/XI2\<2\>\/RI2_pos WLSEL\<392\> ) \
 R_1X_LL w=1e-07 l=1e-07   res=0.149966
XXI2\<1\>\/XI2\<2\>\/XI2\<0\>\/XI2\<1\>\/RR2 (  \
 N_SEL3\<1\>_XI2\<1\>\/XI2\<2\>\/XI2\<0\>\/XI2\<1\>\/RR2_pos WLSEL\<391\> ) \
 R_1X_LL w=1e-07 l=1e-07   res=0.149966
XXI2\<1\>\/XI2\<2\>\/XI2\<0\>\/XI2\<1\>\/RR1 (  \
 N_SEL2\<2\>_XI2\<1\>\/XI2\<2\>\/XI2\<0\>\/XI2\<1\>\/RR1_pos WLSEL\<390\> ) \
 R_1X_LL w=1e-07 l=1e-07   res=0.149966
XXI2\<1\>\/XI2\<2\>\/XI2\<0\>\/XI2\<1\>\/RR0 (  \
 N_SEL1\<0\>_XI2\<1\>\/XI2\<2\>\/XI2\<0\>\/XI2\<1\>\/RR0_pos WLSEL\<389\> ) \
 R_1X_LL w=1e-07 l=1e-07   res=0.149966
XXI2\<1\>\/XI2\<2\>\/XI2\<0\>\/XI2\<1\>\/RI2 (  \
 N_SEL0\<1\>_XI2\<1\>\/XI2\<2\>\/XI2\<0\>\/XI2\<1\>\/RI2_pos WLSEL\<388\> ) \
 R_1X_LL w=1e-07 l=1e-07   res=0.149966
XXI2\<1\>\/XI2\<2\>\/XI2\<0\>\/XI2\<0\>\/RR2 (  \
 N_SEL3\<1\>_XI2\<1\>\/XI2\<2\>\/XI2\<0\>\/XI2\<0\>\/RR2_pos WLSEL\<387\> ) \
 R_1X_LL w=1e-07 l=1e-07   res=0.149966
XXI2\<1\>\/XI2\<2\>\/XI2\<0\>\/XI2\<0\>\/RR1 (  \
 N_SEL2\<2\>_XI2\<1\>\/XI2\<2\>\/XI2\<0\>\/XI2\<0\>\/RR1_pos WLSEL\<386\> ) \
 R_1X_LL w=1e-07 l=1e-07   res=0.149966
XXI2\<1\>\/XI2\<2\>\/XI2\<0\>\/XI2\<0\>\/RR0 (  \
 N_SEL1\<0\>_XI2\<1\>\/XI2\<2\>\/XI2\<0\>\/XI2\<0\>\/RR0_pos WLSEL\<385\> ) \
 R_1X_LL w=1e-07 l=1e-07   res=0.149966
XXI2\<1\>\/XI2\<2\>\/XI2\<0\>\/XI2\<0\>\/RI2 (  \
 N_SEL0\<0\>_XI2\<1\>\/XI2\<2\>\/XI2\<0\>\/XI2\<0\>\/RI2_pos WLSEL\<384\> ) \
 R_1X_LL w=1e-07 l=1e-07   res=0.149966
XXI2\<1\>\/XI2\<1\>\/XI2\<3\>\/XI2\<3\>\/RR2 (  \
 N_SEL3\<1\>_XI2\<1\>\/XI2\<1\>\/XI2\<3\>\/XI2\<3\>\/RR2_pos WLSEL\<383\> ) \
 R_1X_LL w=1e-07 l=1e-07   res=0.149966
XXI2\<1\>\/XI2\<1\>\/XI2\<3\>\/XI2\<3\>\/RR1 (  \
 N_SEL2\<1\>_XI2\<1\>\/XI2\<1\>\/XI2\<3\>\/XI2\<3\>\/RR1_pos WLSEL\<382\> ) \
 R_1X_LL w=1e-07 l=1e-07   res=0.149966
XXI2\<1\>\/XI2\<1\>\/XI2\<3\>\/XI2\<3\>\/RR0 (  \
 N_SEL1\<3\>_XI2\<1\>\/XI2\<1\>\/XI2\<3\>\/XI2\<3\>\/RR0_pos WLSEL\<381\> ) \
 R_1X_LL w=1e-07 l=1e-07   res=0.149966
XXI2\<1\>\/XI2\<1\>\/XI2\<3\>\/XI2\<3\>\/RI2 (  \
 N_SEL0\<3\>_XI2\<1\>\/XI2\<1\>\/XI2\<3\>\/XI2\<3\>\/RI2_pos WLSEL\<380\> ) \
 R_1X_LL w=1e-07 l=1e-07   res=0.149966
XXI2\<1\>\/XI2\<1\>\/XI2\<3\>\/XI2\<2\>\/RR2 (  \
 N_SEL3\<1\>_XI2\<1\>\/XI2\<1\>\/XI2\<3\>\/XI2\<2\>\/RR2_pos WLSEL\<379\> ) \
 R_1X_LL w=1e-07 l=1e-07   res=0.149966
XXI2\<1\>\/XI2\<1\>\/XI2\<3\>\/XI2\<2\>\/RR1 (  \
 N_SEL2\<1\>_XI2\<1\>\/XI2\<1\>\/XI2\<3\>\/XI2\<2\>\/RR1_pos WLSEL\<378\> ) \
 R_1X_LL w=1e-07 l=1e-07   res=0.149966
XXI2\<1\>\/XI2\<1\>\/XI2\<3\>\/XI2\<2\>\/RR0 (  \
 N_SEL1\<3\>_XI2\<1\>\/XI2\<1\>\/XI2\<3\>\/XI2\<2\>\/RR0_pos WLSEL\<377\> ) \
 R_1X_LL w=1e-07 l=1e-07   res=0.149966
XXI2\<1\>\/XI2\<1\>\/XI2\<3\>\/XI2\<2\>\/RI2 (  \
 N_SEL0\<2\>_XI2\<1\>\/XI2\<1\>\/XI2\<3\>\/XI2\<2\>\/RI2_pos WLSEL\<376\> ) \
 R_1X_LL w=1e-07 l=1e-07   res=0.149966
XXI2\<1\>\/XI2\<1\>\/XI2\<3\>\/XI2\<1\>\/RR2 (  \
 N_SEL3\<1\>_XI2\<1\>\/XI2\<1\>\/XI2\<3\>\/XI2\<1\>\/RR2_pos WLSEL\<375\> ) \
 R_1X_LL w=1e-07 l=1e-07   res=0.149966
XXI2\<1\>\/XI2\<1\>\/XI2\<3\>\/XI2\<1\>\/RR1 (  \
 N_SEL2\<1\>_XI2\<1\>\/XI2\<1\>\/XI2\<3\>\/XI2\<1\>\/RR1_pos WLSEL\<374\> ) \
 R_1X_LL w=1e-07 l=1e-07   res=0.149966
XXI2\<1\>\/XI2\<1\>\/XI2\<3\>\/XI2\<1\>\/RR0 (  \
 N_SEL1\<3\>_XI2\<1\>\/XI2\<1\>\/XI2\<3\>\/XI2\<1\>\/RR0_pos WLSEL\<373\> ) \
 R_1X_LL w=1e-07 l=1e-07   res=0.149966
XXI2\<1\>\/XI2\<1\>\/XI2\<3\>\/XI2\<1\>\/RI2 (  \
 N_SEL0\<1\>_XI2\<1\>\/XI2\<1\>\/XI2\<3\>\/XI2\<1\>\/RI2_pos WLSEL\<372\> ) \
 R_1X_LL w=1e-07 l=1e-07   res=0.149966
XXI2\<1\>\/XI2\<1\>\/XI2\<3\>\/XI2\<0\>\/RR2 (  \
 N_SEL3\<1\>_XI2\<1\>\/XI2\<1\>\/XI2\<3\>\/XI2\<0\>\/RR2_pos WLSEL\<371\> ) \
 R_1X_LL w=1e-07 l=1e-07   res=0.149966
XXI2\<1\>\/XI2\<1\>\/XI2\<3\>\/XI2\<0\>\/RR1 (  \
 N_SEL2\<1\>_XI2\<1\>\/XI2\<1\>\/XI2\<3\>\/XI2\<0\>\/RR1_pos WLSEL\<370\> ) \
 R_1X_LL w=1e-07 l=1e-07   res=0.149966
XXI2\<1\>\/XI2\<1\>\/XI2\<3\>\/XI2\<0\>\/RR0 (  \
 N_SEL1\<3\>_XI2\<1\>\/XI2\<1\>\/XI2\<3\>\/XI2\<0\>\/RR0_pos WLSEL\<369\> ) \
 R_1X_LL w=1e-07 l=1e-07   res=0.149966
XXI2\<1\>\/XI2\<1\>\/XI2\<3\>\/XI2\<0\>\/RI2 (  \
 N_SEL0\<0\>_XI2\<1\>\/XI2\<1\>\/XI2\<3\>\/XI2\<0\>\/RI2_pos WLSEL\<368\> ) \
 R_1X_LL w=1e-07 l=1e-07   res=0.149966
XXI2\<1\>\/XI2\<1\>\/XI2\<2\>\/XI2\<3\>\/RR2 (  \
 N_SEL3\<1\>_XI2\<1\>\/XI2\<1\>\/XI2\<2\>\/XI2\<3\>\/RR2_pos WLSEL\<367\> ) \
 R_1X_LL w=1e-07 l=1e-07   res=0.149966
XXI2\<1\>\/XI2\<1\>\/XI2\<2\>\/XI2\<3\>\/RR1 (  \
 N_SEL2\<1\>_XI2\<1\>\/XI2\<1\>\/XI2\<2\>\/XI2\<3\>\/RR1_pos WLSEL\<366\> ) \
 R_1X_LL w=1e-07 l=1e-07   res=0.149966
XXI2\<1\>\/XI2\<1\>\/XI2\<2\>\/XI2\<3\>\/RR0 (  \
 N_SEL1\<2\>_XI2\<1\>\/XI2\<1\>\/XI2\<2\>\/XI2\<3\>\/RR0_pos WLSEL\<365\> ) \
 R_1X_LL w=1e-07 l=1e-07   res=0.149966
XXI2\<1\>\/XI2\<1\>\/XI2\<2\>\/XI2\<3\>\/RI2 (  \
 N_SEL0\<3\>_XI2\<1\>\/XI2\<1\>\/XI2\<2\>\/XI2\<3\>\/RI2_pos WLSEL\<364\> ) \
 R_1X_LL w=1e-07 l=1e-07   res=0.149966
XXI2\<1\>\/XI2\<1\>\/XI2\<2\>\/XI2\<2\>\/RR2 (  \
 N_SEL3\<1\>_XI2\<1\>\/XI2\<1\>\/XI2\<2\>\/XI2\<2\>\/RR2_pos WLSEL\<363\> ) \
 R_1X_LL w=1e-07 l=1e-07   res=0.149966
XXI2\<1\>\/XI2\<1\>\/XI2\<2\>\/XI2\<2\>\/RR1 (  \
 N_SEL2\<1\>_XI2\<1\>\/XI2\<1\>\/XI2\<2\>\/XI2\<2\>\/RR1_pos WLSEL\<362\> ) \
 R_1X_LL w=1e-07 l=1e-07   res=0.149966
XXI2\<1\>\/XI2\<1\>\/XI2\<2\>\/XI2\<2\>\/RR0 (  \
 N_SEL1\<2\>_XI2\<1\>\/XI2\<1\>\/XI2\<2\>\/XI2\<2\>\/RR0_pos WLSEL\<361\> ) \
 R_1X_LL w=1e-07 l=1e-07   res=0.149966
XXI2\<1\>\/XI2\<1\>\/XI2\<2\>\/XI2\<2\>\/RI2 (  \
 N_SEL0\<2\>_XI2\<1\>\/XI2\<1\>\/XI2\<2\>\/XI2\<2\>\/RI2_pos WLSEL\<360\> ) \
 R_1X_LL w=1e-07 l=1e-07   res=0.149966
XXI2\<1\>\/XI2\<1\>\/XI2\<2\>\/XI2\<1\>\/RR2 (  \
 N_SEL3\<1\>_XI2\<1\>\/XI2\<1\>\/XI2\<2\>\/XI2\<1\>\/RR2_pos WLSEL\<359\> ) \
 R_1X_LL w=1e-07 l=1e-07   res=0.149966
XXI2\<1\>\/XI2\<1\>\/XI2\<2\>\/XI2\<1\>\/RR1 (  \
 N_SEL2\<1\>_XI2\<1\>\/XI2\<1\>\/XI2\<2\>\/XI2\<1\>\/RR1_pos WLSEL\<358\> ) \
 R_1X_LL w=1e-07 l=1e-07   res=0.149966
XXI2\<1\>\/XI2\<1\>\/XI2\<2\>\/XI2\<1\>\/RR0 (  \
 N_SEL1\<2\>_XI2\<1\>\/XI2\<1\>\/XI2\<2\>\/XI2\<1\>\/RR0_pos WLSEL\<357\> ) \
 R_1X_LL w=1e-07 l=1e-07   res=0.149966
XXI2\<1\>\/XI2\<1\>\/XI2\<2\>\/XI2\<1\>\/RI2 (  \
 N_SEL0\<1\>_XI2\<1\>\/XI2\<1\>\/XI2\<2\>\/XI2\<1\>\/RI2_pos WLSEL\<356\> ) \
 R_1X_LL w=1e-07 l=1e-07   res=0.149966
XXI2\<1\>\/XI2\<1\>\/XI2\<2\>\/XI2\<0\>\/RR2 (  \
 N_SEL3\<1\>_XI2\<1\>\/XI2\<1\>\/XI2\<2\>\/XI2\<0\>\/RR2_pos WLSEL\<355\> ) \
 R_1X_LL w=1e-07 l=1e-07   res=0.149966
XXI2\<1\>\/XI2\<1\>\/XI2\<2\>\/XI2\<0\>\/RR1 (  \
 N_SEL2\<1\>_XI2\<1\>\/XI2\<1\>\/XI2\<2\>\/XI2\<0\>\/RR1_pos WLSEL\<354\> ) \
 R_1X_LL w=1e-07 l=1e-07   res=0.149966
XXI2\<1\>\/XI2\<1\>\/XI2\<2\>\/XI2\<0\>\/RR0 (  \
 N_SEL1\<2\>_XI2\<1\>\/XI2\<1\>\/XI2\<2\>\/XI2\<0\>\/RR0_pos WLSEL\<353\> ) \
 R_1X_LL w=1e-07 l=1e-07   res=0.149966
XXI2\<1\>\/XI2\<1\>\/XI2\<2\>\/XI2\<0\>\/RI2 (  \
 N_SEL0\<0\>_XI2\<1\>\/XI2\<1\>\/XI2\<2\>\/XI2\<0\>\/RI2_pos WLSEL\<352\> ) \
 R_1X_LL w=1e-07 l=1e-07   res=0.149966
XXI2\<1\>\/XI2\<1\>\/XI2\<1\>\/XI2\<3\>\/RR2 (  \
 N_SEL3\<1\>_XI2\<1\>\/XI2\<1\>\/XI2\<1\>\/XI2\<3\>\/RR2_pos WLSEL\<351\> ) \
 R_1X_LL w=1e-07 l=1e-07   res=0.149966
XXI2\<1\>\/XI2\<1\>\/XI2\<1\>\/XI2\<3\>\/RR1 (  \
 N_SEL2\<1\>_XI2\<1\>\/XI2\<1\>\/XI2\<1\>\/XI2\<3\>\/RR1_pos WLSEL\<350\> ) \
 R_1X_LL w=1e-07 l=1e-07   res=0.149966
XXI2\<1\>\/XI2\<1\>\/XI2\<1\>\/XI2\<3\>\/RR0 (  \
 N_SEL1\<1\>_XI2\<1\>\/XI2\<1\>\/XI2\<1\>\/XI2\<3\>\/RR0_pos WLSEL\<349\> ) \
 R_1X_LL w=1e-07 l=1e-07   res=0.149966
XXI2\<1\>\/XI2\<1\>\/XI2\<1\>\/XI2\<3\>\/RI2 (  \
 N_SEL0\<3\>_XI2\<1\>\/XI2\<1\>\/XI2\<1\>\/XI2\<3\>\/RI2_pos WLSEL\<348\> ) \
 R_1X_LL w=1e-07 l=1e-07   res=0.149966
XXI2\<1\>\/XI2\<1\>\/XI2\<1\>\/XI2\<2\>\/RR2 (  \
 N_SEL3\<1\>_XI2\<1\>\/XI2\<1\>\/XI2\<1\>\/XI2\<2\>\/RR2_pos WLSEL\<347\> ) \
 R_1X_LL w=1e-07 l=1e-07   res=0.149966
XXI2\<1\>\/XI2\<1\>\/XI2\<1\>\/XI2\<2\>\/RR1 (  \
 N_SEL2\<1\>_XI2\<1\>\/XI2\<1\>\/XI2\<1\>\/XI2\<2\>\/RR1_pos WLSEL\<346\> ) \
 R_1X_LL w=1e-07 l=1e-07   res=0.149966
XXI2\<1\>\/XI2\<1\>\/XI2\<1\>\/XI2\<2\>\/RR0 (  \
 N_SEL1\<1\>_XI2\<1\>\/XI2\<1\>\/XI2\<1\>\/XI2\<2\>\/RR0_pos WLSEL\<345\> ) \
 R_1X_LL w=1e-07 l=1e-07   res=0.149966
XXI2\<1\>\/XI2\<1\>\/XI2\<1\>\/XI2\<2\>\/RI2 (  \
 N_SEL0\<2\>_XI2\<1\>\/XI2\<1\>\/XI2\<1\>\/XI2\<2\>\/RI2_pos WLSEL\<344\> ) \
 R_1X_LL w=1e-07 l=1e-07   res=0.149966
XXI2\<1\>\/XI2\<1\>\/XI2\<1\>\/XI2\<1\>\/RR2 (  \
 N_SEL3\<1\>_XI2\<1\>\/XI2\<1\>\/XI2\<1\>\/XI2\<1\>\/RR2_pos WLSEL\<343\> ) \
 R_1X_LL w=1e-07 l=1e-07   res=0.149966
XXI2\<1\>\/XI2\<1\>\/XI2\<1\>\/XI2\<1\>\/RR1 (  \
 N_SEL2\<1\>_XI2\<1\>\/XI2\<1\>\/XI2\<1\>\/XI2\<1\>\/RR1_pos WLSEL\<342\> ) \
 R_1X_LL w=1e-07 l=1e-07   res=0.149966
XXI2\<1\>\/XI2\<1\>\/XI2\<1\>\/XI2\<1\>\/RR0 (  \
 N_SEL1\<1\>_XI2\<1\>\/XI2\<1\>\/XI2\<1\>\/XI2\<1\>\/RR0_pos WLSEL\<341\> ) \
 R_1X_LL w=1e-07 l=1e-07   res=0.149966
XXI2\<1\>\/XI2\<1\>\/XI2\<1\>\/XI2\<1\>\/RI2 (  \
 N_SEL0\<1\>_XI2\<1\>\/XI2\<1\>\/XI2\<1\>\/XI2\<1\>\/RI2_pos WLSEL\<340\> ) \
 R_1X_LL w=1e-07 l=1e-07   res=0.149966
XXI2\<1\>\/XI2\<1\>\/XI2\<1\>\/XI2\<0\>\/RR2 (  \
 N_SEL3\<1\>_XI2\<1\>\/XI2\<1\>\/XI2\<1\>\/XI2\<0\>\/RR2_pos WLSEL\<339\> ) \
 R_1X_LL w=1e-07 l=1e-07   res=0.149966
XXI2\<1\>\/XI2\<1\>\/XI2\<1\>\/XI2\<0\>\/RR1 (  \
 N_SEL2\<1\>_XI2\<1\>\/XI2\<1\>\/XI2\<1\>\/XI2\<0\>\/RR1_pos WLSEL\<338\> ) \
 R_1X_LL w=1e-07 l=1e-07   res=0.149966
XXI2\<1\>\/XI2\<1\>\/XI2\<1\>\/XI2\<0\>\/RR0 (  \
 N_SEL1\<1\>_XI2\<1\>\/XI2\<1\>\/XI2\<1\>\/XI2\<0\>\/RR0_pos WLSEL\<337\> ) \
 R_1X_LL w=1e-07 l=1e-07   res=0.149966
XXI2\<1\>\/XI2\<1\>\/XI2\<1\>\/XI2\<0\>\/RI2 (  \
 N_SEL0\<0\>_XI2\<1\>\/XI2\<1\>\/XI2\<1\>\/XI2\<0\>\/RI2_pos WLSEL\<336\> ) \
 R_1X_LL w=1e-07 l=1e-07   res=0.149966
XXI2\<1\>\/XI2\<1\>\/XI2\<0\>\/XI2\<3\>\/RR2 (  \
 N_SEL3\<1\>_XI2\<1\>\/XI2\<1\>\/XI2\<0\>\/XI2\<3\>\/RR2_pos WLSEL\<335\> ) \
 R_1X_LL w=1e-07 l=1e-07   res=0.149966
XXI2\<1\>\/XI2\<1\>\/XI2\<0\>\/XI2\<3\>\/RR1 (  \
 N_SEL2\<1\>_XI2\<1\>\/XI2\<1\>\/XI2\<0\>\/XI2\<3\>\/RR1_pos WLSEL\<334\> ) \
 R_1X_LL w=1e-07 l=1e-07   res=0.149966
XXI2\<1\>\/XI2\<1\>\/XI2\<0\>\/XI2\<3\>\/RR0 (  \
 N_SEL1\<0\>_XI2\<1\>\/XI2\<1\>\/XI2\<0\>\/XI2\<3\>\/RR0_pos WLSEL\<333\> ) \
 R_1X_LL w=1e-07 l=1e-07   res=0.149966
XXI2\<1\>\/XI2\<1\>\/XI2\<0\>\/XI2\<3\>\/RI2 (  \
 N_SEL0\<3\>_XI2\<1\>\/XI2\<1\>\/XI2\<0\>\/XI2\<3\>\/RI2_pos WLSEL\<332\> ) \
 R_1X_LL w=1e-07 l=1e-07   res=0.149966
XXI2\<1\>\/XI2\<1\>\/XI2\<0\>\/XI2\<2\>\/RR2 (  \
 N_SEL3\<1\>_XI2\<1\>\/XI2\<1\>\/XI2\<0\>\/XI2\<2\>\/RR2_pos WLSEL\<331\> ) \
 R_1X_LL w=1e-07 l=1e-07   res=0.149966
XXI2\<1\>\/XI2\<1\>\/XI2\<0\>\/XI2\<2\>\/RR1 (  \
 N_SEL2\<1\>_XI2\<1\>\/XI2\<1\>\/XI2\<0\>\/XI2\<2\>\/RR1_pos WLSEL\<330\> ) \
 R_1X_LL w=1e-07 l=1e-07   res=0.149966
XXI2\<1\>\/XI2\<1\>\/XI2\<0\>\/XI2\<2\>\/RR0 (  \
 N_SEL1\<0\>_XI2\<1\>\/XI2\<1\>\/XI2\<0\>\/XI2\<2\>\/RR0_pos WLSEL\<329\> ) \
 R_1X_LL w=1e-07 l=1e-07   res=0.149966
XXI2\<1\>\/XI2\<1\>\/XI2\<0\>\/XI2\<2\>\/RI2 (  \
 N_SEL0\<2\>_XI2\<1\>\/XI2\<1\>\/XI2\<0\>\/XI2\<2\>\/RI2_pos WLSEL\<328\> ) \
 R_1X_LL w=1e-07 l=1e-07   res=0.149966
XXI2\<1\>\/XI2\<1\>\/XI2\<0\>\/XI2\<1\>\/RR2 (  \
 N_SEL3\<1\>_XI2\<1\>\/XI2\<1\>\/XI2\<0\>\/XI2\<1\>\/RR2_pos WLSEL\<327\> ) \
 R_1X_LL w=1e-07 l=1e-07   res=0.149966
XXI2\<1\>\/XI2\<1\>\/XI2\<0\>\/XI2\<1\>\/RR1 (  \
 N_SEL2\<1\>_XI2\<1\>\/XI2\<1\>\/XI2\<0\>\/XI2\<1\>\/RR1_pos WLSEL\<326\> ) \
 R_1X_LL w=1e-07 l=1e-07   res=0.149966
XXI2\<1\>\/XI2\<1\>\/XI2\<0\>\/XI2\<1\>\/RR0 (  \
 N_SEL1\<0\>_XI2\<1\>\/XI2\<1\>\/XI2\<0\>\/XI2\<1\>\/RR0_pos WLSEL\<325\> ) \
 R_1X_LL w=1e-07 l=1e-07   res=0.149966
XXI2\<1\>\/XI2\<1\>\/XI2\<0\>\/XI2\<1\>\/RI2 (  \
 N_SEL0\<1\>_XI2\<1\>\/XI2\<1\>\/XI2\<0\>\/XI2\<1\>\/RI2_pos WLSEL\<324\> ) \
 R_1X_LL w=1e-07 l=1e-07   res=0.149966
XXI2\<1\>\/XI2\<1\>\/XI2\<0\>\/XI2\<0\>\/RR2 (  \
 N_SEL3\<1\>_XI2\<1\>\/XI2\<1\>\/XI2\<0\>\/XI2\<0\>\/RR2_pos WLSEL\<323\> ) \
 R_1X_LL w=1e-07 l=1e-07   res=0.149966
XXI2\<1\>\/XI2\<1\>\/XI2\<0\>\/XI2\<0\>\/RR1 (  \
 N_SEL2\<1\>_XI2\<1\>\/XI2\<1\>\/XI2\<0\>\/XI2\<0\>\/RR1_pos WLSEL\<322\> ) \
 R_1X_LL w=1e-07 l=1e-07   res=0.149966
XXI2\<1\>\/XI2\<1\>\/XI2\<0\>\/XI2\<0\>\/RR0 (  \
 N_SEL1\<0\>_XI2\<1\>\/XI2\<1\>\/XI2\<0\>\/XI2\<0\>\/RR0_pos WLSEL\<321\> ) \
 R_1X_LL w=1e-07 l=1e-07   res=0.149966
XXI2\<1\>\/XI2\<1\>\/XI2\<0\>\/XI2\<0\>\/RI2 (  \
 N_SEL0\<0\>_XI2\<1\>\/XI2\<1\>\/XI2\<0\>\/XI2\<0\>\/RI2_pos WLSEL\<320\> ) \
 R_1X_LL w=1e-07 l=1e-07   res=0.149966
XXI2\<1\>\/XI2\<0\>\/XI2\<3\>\/XI2\<3\>\/RR2 (  \
 N_SEL3\<1\>_XI2\<1\>\/XI2\<0\>\/XI2\<3\>\/XI2\<3\>\/RR2_pos WLSEL\<319\> ) \
 R_1X_LL w=1e-07 l=1e-07   res=0.149966
XXI2\<1\>\/XI2\<0\>\/XI2\<3\>\/XI2\<3\>\/RR1 (  \
 N_SEL2\<0\>_XI2\<1\>\/XI2\<0\>\/XI2\<3\>\/XI2\<3\>\/RR1_pos WLSEL\<318\> ) \
 R_1X_LL w=1e-07 l=1e-07   res=0.149966
XXI2\<1\>\/XI2\<0\>\/XI2\<3\>\/XI2\<3\>\/RR0 (  \
 N_SEL1\<3\>_XI2\<1\>\/XI2\<0\>\/XI2\<3\>\/XI2\<3\>\/RR0_pos WLSEL\<317\> ) \
 R_1X_LL w=1e-07 l=1e-07   res=0.149966
XXI2\<1\>\/XI2\<0\>\/XI2\<3\>\/XI2\<3\>\/RI2 (  \
 N_SEL0\<3\>_XI2\<1\>\/XI2\<0\>\/XI2\<3\>\/XI2\<3\>\/RI2_pos WLSEL\<316\> ) \
 R_1X_LL w=1e-07 l=1e-07   res=0.149966
XXI2\<1\>\/XI2\<0\>\/XI2\<3\>\/XI2\<2\>\/RR2 (  \
 N_SEL3\<1\>_XI2\<1\>\/XI2\<0\>\/XI2\<3\>\/XI2\<2\>\/RR2_pos WLSEL\<315\> ) \
 R_1X_LL w=1e-07 l=1e-07   res=0.149966
XXI2\<1\>\/XI2\<0\>\/XI2\<3\>\/XI2\<2\>\/RR1 (  \
 N_SEL2\<0\>_XI2\<1\>\/XI2\<0\>\/XI2\<3\>\/XI2\<2\>\/RR1_pos WLSEL\<314\> ) \
 R_1X_LL w=1e-07 l=1e-07   res=0.149966
XXI2\<1\>\/XI2\<0\>\/XI2\<3\>\/XI2\<2\>\/RR0 (  \
 N_SEL1\<3\>_XI2\<1\>\/XI2\<0\>\/XI2\<3\>\/XI2\<2\>\/RR0_pos WLSEL\<313\> ) \
 R_1X_LL w=1e-07 l=1e-07   res=0.149966
XXI2\<1\>\/XI2\<0\>\/XI2\<3\>\/XI2\<2\>\/RI2 (  \
 N_SEL0\<2\>_XI2\<1\>\/XI2\<0\>\/XI2\<3\>\/XI2\<2\>\/RI2_pos WLSEL\<312\> ) \
 R_1X_LL w=1e-07 l=1e-07   res=0.149966
XXI2\<1\>\/XI2\<0\>\/XI2\<3\>\/XI2\<1\>\/RR2 (  \
 N_SEL3\<1\>_XI2\<1\>\/XI2\<0\>\/XI2\<3\>\/XI2\<1\>\/RR2_pos WLSEL\<311\> ) \
 R_1X_LL w=1e-07 l=1e-07   res=0.149966
XXI2\<1\>\/XI2\<0\>\/XI2\<3\>\/XI2\<1\>\/RR1 (  \
 N_SEL2\<0\>_XI2\<1\>\/XI2\<0\>\/XI2\<3\>\/XI2\<1\>\/RR1_pos WLSEL\<310\> ) \
 R_1X_LL w=1e-07 l=1e-07   res=0.149966
XXI2\<1\>\/XI2\<0\>\/XI2\<3\>\/XI2\<1\>\/RR0 (  \
 N_SEL1\<3\>_XI2\<1\>\/XI2\<0\>\/XI2\<3\>\/XI2\<1\>\/RR0_pos WLSEL\<309\> ) \
 R_1X_LL w=1e-07 l=1e-07   res=0.149966
XXI2\<1\>\/XI2\<0\>\/XI2\<3\>\/XI2\<1\>\/RI2 (  \
 N_SEL0\<1\>_XI2\<1\>\/XI2\<0\>\/XI2\<3\>\/XI2\<1\>\/RI2_pos WLSEL\<308\> ) \
 R_1X_LL w=1e-07 l=1e-07   res=0.149966
XXI2\<1\>\/XI2\<0\>\/XI2\<3\>\/XI2\<0\>\/RR2 (  \
 N_SEL3\<1\>_XI2\<1\>\/XI2\<0\>\/XI2\<3\>\/XI2\<0\>\/RR2_pos WLSEL\<307\> ) \
 R_1X_LL w=1e-07 l=1e-07   res=0.149966
XXI2\<1\>\/XI2\<0\>\/XI2\<3\>\/XI2\<0\>\/RR1 (  \
 N_SEL2\<0\>_XI2\<1\>\/XI2\<0\>\/XI2\<3\>\/XI2\<0\>\/RR1_pos WLSEL\<306\> ) \
 R_1X_LL w=1e-07 l=1e-07   res=0.149966
XXI2\<1\>\/XI2\<0\>\/XI2\<3\>\/XI2\<0\>\/RR0 (  \
 N_SEL1\<3\>_XI2\<1\>\/XI2\<0\>\/XI2\<3\>\/XI2\<0\>\/RR0_pos WLSEL\<305\> ) \
 R_1X_LL w=1e-07 l=1e-07   res=0.149966
XXI2\<1\>\/XI2\<0\>\/XI2\<3\>\/XI2\<0\>\/RI2 (  \
 N_SEL0\<0\>_XI2\<1\>\/XI2\<0\>\/XI2\<3\>\/XI2\<0\>\/RI2_pos WLSEL\<304\> ) \
 R_1X_LL w=1e-07 l=1e-07   res=0.149966
XXI2\<1\>\/XI2\<0\>\/XI2\<2\>\/XI2\<3\>\/RR2 (  \
 N_SEL3\<1\>_XI2\<1\>\/XI2\<0\>\/XI2\<2\>\/XI2\<3\>\/RR2_pos WLSEL\<303\> ) \
 R_1X_LL w=1e-07 l=1e-07   res=0.149966
XXI2\<1\>\/XI2\<0\>\/XI2\<2\>\/XI2\<3\>\/RR1 (  \
 N_SEL2\<0\>_XI2\<1\>\/XI2\<0\>\/XI2\<2\>\/XI2\<3\>\/RR1_pos WLSEL\<302\> ) \
 R_1X_LL w=1e-07 l=1e-07   res=0.149966
XXI2\<1\>\/XI2\<0\>\/XI2\<2\>\/XI2\<3\>\/RR0 (  \
 N_SEL1\<2\>_XI2\<1\>\/XI2\<0\>\/XI2\<2\>\/XI2\<3\>\/RR0_pos WLSEL\<301\> ) \
 R_1X_LL w=1e-07 l=1e-07   res=0.149966
XXI2\<1\>\/XI2\<0\>\/XI2\<2\>\/XI2\<3\>\/RI2 (  \
 N_SEL0\<3\>_XI2\<1\>\/XI2\<0\>\/XI2\<2\>\/XI2\<3\>\/RI2_pos WLSEL\<300\> ) \
 R_1X_LL w=1e-07 l=1e-07   res=0.149966
XXI2\<1\>\/XI2\<0\>\/XI2\<2\>\/XI2\<2\>\/RR2 (  \
 N_SEL3\<1\>_XI2\<1\>\/XI2\<0\>\/XI2\<2\>\/XI2\<2\>\/RR2_pos WLSEL\<299\> ) \
 R_1X_LL w=1e-07 l=1e-07   res=0.149966
XXI2\<1\>\/XI2\<0\>\/XI2\<2\>\/XI2\<2\>\/RR1 (  \
 N_SEL2\<0\>_XI2\<1\>\/XI2\<0\>\/XI2\<2\>\/XI2\<2\>\/RR1_pos WLSEL\<298\> ) \
 R_1X_LL w=1e-07 l=1e-07   res=0.149966
XXI2\<1\>\/XI2\<0\>\/XI2\<2\>\/XI2\<2\>\/RR0 (  \
 N_SEL1\<2\>_XI2\<1\>\/XI2\<0\>\/XI2\<2\>\/XI2\<2\>\/RR0_pos WLSEL\<297\> ) \
 R_1X_LL w=1e-07 l=1e-07   res=0.149966
XXI2\<1\>\/XI2\<0\>\/XI2\<2\>\/XI2\<2\>\/RI2 (  \
 N_SEL0\<2\>_XI2\<1\>\/XI2\<0\>\/XI2\<2\>\/XI2\<2\>\/RI2_pos WLSEL\<296\> ) \
 R_1X_LL w=1e-07 l=1e-07   res=0.149966
XXI2\<1\>\/XI2\<0\>\/XI2\<2\>\/XI2\<1\>\/RR2 (  \
 N_SEL3\<1\>_XI2\<1\>\/XI2\<0\>\/XI2\<2\>\/XI2\<1\>\/RR2_pos WLSEL\<295\> ) \
 R_1X_LL w=1e-07 l=1e-07   res=0.149966
XXI2\<1\>\/XI2\<0\>\/XI2\<2\>\/XI2\<1\>\/RR1 (  \
 N_SEL2\<0\>_XI2\<1\>\/XI2\<0\>\/XI2\<2\>\/XI2\<1\>\/RR1_pos WLSEL\<294\> ) \
 R_1X_LL w=1e-07 l=1e-07   res=0.149966
XXI2\<1\>\/XI2\<0\>\/XI2\<2\>\/XI2\<1\>\/RR0 (  \
 N_SEL1\<2\>_XI2\<1\>\/XI2\<0\>\/XI2\<2\>\/XI2\<1\>\/RR0_pos WLSEL\<293\> ) \
 R_1X_LL w=1e-07 l=1e-07   res=0.149966
XXI2\<1\>\/XI2\<0\>\/XI2\<2\>\/XI2\<1\>\/RI2 (  \
 N_SEL0\<1\>_XI2\<1\>\/XI2\<0\>\/XI2\<2\>\/XI2\<1\>\/RI2_pos WLSEL\<292\> ) \
 R_1X_LL w=1e-07 l=1e-07   res=0.149966
XXI2\<1\>\/XI2\<0\>\/XI2\<2\>\/XI2\<0\>\/RR2 (  \
 N_SEL3\<1\>_XI2\<1\>\/XI2\<0\>\/XI2\<2\>\/XI2\<0\>\/RR2_pos WLSEL\<291\> ) \
 R_1X_LL w=1e-07 l=1e-07   res=0.149966
XXI2\<1\>\/XI2\<0\>\/XI2\<2\>\/XI2\<0\>\/RR1 (  \
 N_SEL2\<0\>_XI2\<1\>\/XI2\<0\>\/XI2\<2\>\/XI2\<0\>\/RR1_pos WLSEL\<290\> ) \
 R_1X_LL w=1e-07 l=1e-07   res=0.149966
XXI2\<1\>\/XI2\<0\>\/XI2\<2\>\/XI2\<0\>\/RR0 (  \
 N_SEL1\<2\>_XI2\<1\>\/XI2\<0\>\/XI2\<2\>\/XI2\<0\>\/RR0_pos WLSEL\<289\> ) \
 R_1X_LL w=1e-07 l=1e-07   res=0.149966
XXI2\<1\>\/XI2\<0\>\/XI2\<2\>\/XI2\<0\>\/RI2 (  \
 N_SEL0\<0\>_XI2\<1\>\/XI2\<0\>\/XI2\<2\>\/XI2\<0\>\/RI2_pos WLSEL\<288\> ) \
 R_1X_LL w=1e-07 l=1e-07   res=0.149966
XXI2\<1\>\/XI2\<0\>\/XI2\<1\>\/XI2\<3\>\/RR2 (  \
 N_SEL3\<1\>_XI2\<1\>\/XI2\<0\>\/XI2\<1\>\/XI2\<3\>\/RR2_pos WLSEL\<287\> ) \
 R_1X_LL w=1e-07 l=1e-07   res=0.149966
XXI2\<1\>\/XI2\<0\>\/XI2\<1\>\/XI2\<3\>\/RR1 (  \
 N_SEL2\<0\>_XI2\<1\>\/XI2\<0\>\/XI2\<1\>\/XI2\<3\>\/RR1_pos WLSEL\<286\> ) \
 R_1X_LL w=1e-07 l=1e-07   res=0.149966
XXI2\<1\>\/XI2\<0\>\/XI2\<1\>\/XI2\<3\>\/RR0 (  \
 N_SEL1\<1\>_XI2\<1\>\/XI2\<0\>\/XI2\<1\>\/XI2\<3\>\/RR0_pos WLSEL\<285\> ) \
 R_1X_LL w=1e-07 l=1e-07   res=0.149966
XXI2\<1\>\/XI2\<0\>\/XI2\<1\>\/XI2\<3\>\/RI2 (  \
 N_SEL0\<3\>_XI2\<1\>\/XI2\<0\>\/XI2\<1\>\/XI2\<3\>\/RI2_pos WLSEL\<284\> ) \
 R_1X_LL w=1e-07 l=1e-07   res=0.149966
XXI2\<1\>\/XI2\<0\>\/XI2\<1\>\/XI2\<2\>\/RR2 (  \
 N_SEL3\<1\>_XI2\<1\>\/XI2\<0\>\/XI2\<1\>\/XI2\<2\>\/RR2_pos WLSEL\<283\> ) \
 R_1X_LL w=1e-07 l=1e-07   res=0.149966
XXI2\<1\>\/XI2\<0\>\/XI2\<1\>\/XI2\<2\>\/RR1 (  \
 N_SEL2\<0\>_XI2\<1\>\/XI2\<0\>\/XI2\<1\>\/XI2\<2\>\/RR1_pos WLSEL\<282\> ) \
 R_1X_LL w=1e-07 l=1e-07   res=0.149966
XXI2\<1\>\/XI2\<0\>\/XI2\<1\>\/XI2\<2\>\/RR0 (  \
 N_SEL1\<1\>_XI2\<1\>\/XI2\<0\>\/XI2\<1\>\/XI2\<2\>\/RR0_pos WLSEL\<281\> ) \
 R_1X_LL w=1e-07 l=1e-07   res=0.149966
XXI2\<1\>\/XI2\<0\>\/XI2\<1\>\/XI2\<2\>\/RI2 (  \
 N_SEL0\<2\>_XI2\<1\>\/XI2\<0\>\/XI2\<1\>\/XI2\<2\>\/RI2_pos WLSEL\<280\> ) \
 R_1X_LL w=1e-07 l=1e-07   res=0.149966
XXI2\<1\>\/XI2\<0\>\/XI2\<1\>\/XI2\<1\>\/RR2 (  \
 N_SEL3\<1\>_XI2\<1\>\/XI2\<0\>\/XI2\<1\>\/XI2\<1\>\/RR2_pos WLSEL\<279\> ) \
 R_1X_LL w=1e-07 l=1e-07   res=0.149966
XXI2\<1\>\/XI2\<0\>\/XI2\<1\>\/XI2\<1\>\/RR1 (  \
 N_SEL2\<0\>_XI2\<1\>\/XI2\<0\>\/XI2\<1\>\/XI2\<1\>\/RR1_pos WLSEL\<278\> ) \
 R_1X_LL w=1e-07 l=1e-07   res=0.149966
XXI2\<1\>\/XI2\<0\>\/XI2\<1\>\/XI2\<1\>\/RR0 (  \
 N_SEL1\<1\>_XI2\<1\>\/XI2\<0\>\/XI2\<1\>\/XI2\<1\>\/RR0_pos WLSEL\<277\> ) \
 R_1X_LL w=1e-07 l=1e-07   res=0.149966
XXI2\<1\>\/XI2\<0\>\/XI2\<1\>\/XI2\<1\>\/RI2 (  \
 N_SEL0\<1\>_XI2\<1\>\/XI2\<0\>\/XI2\<1\>\/XI2\<1\>\/RI2_pos WLSEL\<276\> ) \
 R_1X_LL w=1e-07 l=1e-07   res=0.149966
XXI2\<1\>\/XI2\<0\>\/XI2\<1\>\/XI2\<0\>\/RR2 (  \
 N_SEL3\<1\>_XI2\<1\>\/XI2\<0\>\/XI2\<1\>\/XI2\<0\>\/RR2_pos WLSEL\<275\> ) \
 R_1X_LL w=1e-07 l=1e-07   res=0.149966
XXI2\<1\>\/XI2\<0\>\/XI2\<1\>\/XI2\<0\>\/RR1 (  \
 N_SEL2\<0\>_XI2\<1\>\/XI2\<0\>\/XI2\<1\>\/XI2\<0\>\/RR1_pos WLSEL\<274\> ) \
 R_1X_LL w=1e-07 l=1e-07   res=0.149966
XXI2\<1\>\/XI2\<0\>\/XI2\<1\>\/XI2\<0\>\/RR0 (  \
 N_SEL1\<1\>_XI2\<1\>\/XI2\<0\>\/XI2\<1\>\/XI2\<0\>\/RR0_pos WLSEL\<273\> ) \
 R_1X_LL w=1e-07 l=1e-07   res=0.149966
XXI2\<1\>\/XI2\<0\>\/XI2\<1\>\/XI2\<0\>\/RI2 (  \
 N_SEL0\<0\>_XI2\<1\>\/XI2\<0\>\/XI2\<1\>\/XI2\<0\>\/RI2_pos WLSEL\<272\> ) \
 R_1X_LL w=1e-07 l=1e-07   res=0.149966
XXI2\<1\>\/XI2\<0\>\/XI2\<0\>\/XI2\<3\>\/RR2 (  \
 N_SEL3\<1\>_XI2\<1\>\/XI2\<0\>\/XI2\<0\>\/XI2\<3\>\/RR2_pos WLSEL\<271\> ) \
 R_1X_LL w=1e-07 l=1e-07   res=0.149966
XXI2\<1\>\/XI2\<0\>\/XI2\<0\>\/XI2\<3\>\/RR1 (  \
 N_SEL2\<0\>_XI2\<1\>\/XI2\<0\>\/XI2\<0\>\/XI2\<3\>\/RR1_pos WLSEL\<270\> ) \
 R_1X_LL w=1e-07 l=1e-07   res=0.149966
XXI2\<1\>\/XI2\<0\>\/XI2\<0\>\/XI2\<3\>\/RR0 (  \
 N_SEL1\<0\>_XI2\<1\>\/XI2\<0\>\/XI2\<0\>\/XI2\<3\>\/RR0_pos WLSEL\<269\> ) \
 R_1X_LL w=1e-07 l=1e-07   res=0.149966
XXI2\<1\>\/XI2\<0\>\/XI2\<0\>\/XI2\<3\>\/RI2 (  \
 N_SEL0\<3\>_XI2\<1\>\/XI2\<0\>\/XI2\<0\>\/XI2\<3\>\/RI2_pos WLSEL\<268\> ) \
 R_1X_LL w=1e-07 l=1e-07   res=0.149966
XXI2\<1\>\/XI2\<0\>\/XI2\<0\>\/XI2\<2\>\/RR2 (  \
 N_SEL3\<1\>_XI2\<1\>\/XI2\<0\>\/XI2\<0\>\/XI2\<2\>\/RR2_pos WLSEL\<267\> ) \
 R_1X_LL w=1e-07 l=1e-07   res=0.149966
XXI2\<1\>\/XI2\<0\>\/XI2\<0\>\/XI2\<2\>\/RR1 (  \
 N_SEL2\<0\>_XI2\<1\>\/XI2\<0\>\/XI2\<0\>\/XI2\<2\>\/RR1_pos WLSEL\<266\> ) \
 R_1X_LL w=1e-07 l=1e-07   res=0.149966
XXI2\<1\>\/XI2\<0\>\/XI2\<0\>\/XI2\<2\>\/RR0 (  \
 N_SEL1\<0\>_XI2\<1\>\/XI2\<0\>\/XI2\<0\>\/XI2\<2\>\/RR0_pos WLSEL\<265\> ) \
 R_1X_LL w=1e-07 l=1e-07   res=0.149966
XXI2\<1\>\/XI2\<0\>\/XI2\<0\>\/XI2\<2\>\/RI2 (  \
 N_SEL0\<2\>_XI2\<1\>\/XI2\<0\>\/XI2\<0\>\/XI2\<2\>\/RI2_pos WLSEL\<264\> ) \
 R_1X_LL w=1e-07 l=1e-07   res=0.149966
XXI2\<1\>\/XI2\<0\>\/XI2\<0\>\/XI2\<1\>\/RR2 (  \
 N_SEL3\<1\>_XI2\<1\>\/XI2\<0\>\/XI2\<0\>\/XI2\<1\>\/RR2_pos WLSEL\<263\> ) \
 R_1X_LL w=1e-07 l=1e-07   res=0.149966
XXI2\<1\>\/XI2\<0\>\/XI2\<0\>\/XI2\<1\>\/RR1 (  \
 N_SEL2\<0\>_XI2\<1\>\/XI2\<0\>\/XI2\<0\>\/XI2\<1\>\/RR1_pos WLSEL\<262\> ) \
 R_1X_LL w=1e-07 l=1e-07   res=0.149966
XXI2\<1\>\/XI2\<0\>\/XI2\<0\>\/XI2\<1\>\/RR0 (  \
 N_SEL1\<0\>_XI2\<1\>\/XI2\<0\>\/XI2\<0\>\/XI2\<1\>\/RR0_pos WLSEL\<261\> ) \
 R_1X_LL w=1e-07 l=1e-07   res=0.149966
XXI2\<1\>\/XI2\<0\>\/XI2\<0\>\/XI2\<1\>\/RI2 (  \
 N_SEL0\<1\>_XI2\<1\>\/XI2\<0\>\/XI2\<0\>\/XI2\<1\>\/RI2_pos WLSEL\<260\> ) \
 R_1X_LL w=1e-07 l=1e-07   res=0.149966
XXI2\<1\>\/XI2\<0\>\/XI2\<0\>\/XI2\<0\>\/RR2 (  \
 N_SEL3\<1\>_XI2\<1\>\/XI2\<0\>\/XI2\<0\>\/XI2\<0\>\/RR2_pos WLSEL\<259\> ) \
 R_1X_LL w=1e-07 l=1e-07   res=0.149966
XXI2\<1\>\/XI2\<0\>\/XI2\<0\>\/XI2\<0\>\/RR1 (  \
 N_SEL2\<0\>_XI2\<1\>\/XI2\<0\>\/XI2\<0\>\/XI2\<0\>\/RR1_pos WLSEL\<258\> ) \
 R_1X_LL w=1e-07 l=1e-07   res=0.149966
XXI2\<1\>\/XI2\<0\>\/XI2\<0\>\/XI2\<0\>\/RR0 (  \
 N_SEL1\<0\>_XI2\<1\>\/XI2\<0\>\/XI2\<0\>\/XI2\<0\>\/RR0_pos WLSEL\<257\> ) \
 R_1X_LL w=1e-07 l=1e-07   res=0.149966
XXI2\<1\>\/XI2\<0\>\/XI2\<0\>\/XI2\<0\>\/RI2 (  \
 N_SEL0\<0\>_XI2\<1\>\/XI2\<0\>\/XI2\<0\>\/XI2\<0\>\/RI2_pos WLSEL\<256\> ) \
 R_1X_LL w=1e-07 l=1e-07   res=0.149966
XXI2\<0\>\/XI2\<3\>\/XI2\<3\>\/XI2\<3\>\/RR2 (  \
 N_SEL3\<0\>_XI2\<0\>\/XI2\<3\>\/XI2\<3\>\/XI2\<3\>\/RR2_pos WLSEL\<255\> ) \
 R_1X_LL w=1e-07 l=1e-07   res=0.149966
XXI2\<0\>\/XI2\<3\>\/XI2\<3\>\/XI2\<3\>\/RR1 (  \
 N_SEL2\<3\>_XI2\<0\>\/XI2\<3\>\/XI2\<3\>\/XI2\<3\>\/RR1_pos WLSEL\<254\> ) \
 R_1X_LL w=1e-07 l=1e-07   res=0.149966
XXI2\<0\>\/XI2\<3\>\/XI2\<3\>\/XI2\<3\>\/RR0 (  \
 N_SEL1\<3\>_XI2\<0\>\/XI2\<3\>\/XI2\<3\>\/XI2\<3\>\/RR0_pos WLSEL\<253\> ) \
 R_1X_LL w=1e-07 l=1e-07   res=0.149966
XXI2\<0\>\/XI2\<3\>\/XI2\<3\>\/XI2\<3\>\/RI2 (  \
 N_SEL0\<3\>_XI2\<0\>\/XI2\<3\>\/XI2\<3\>\/XI2\<3\>\/RI2_pos WLSEL\<252\> ) \
 R_1X_LL w=1e-07 l=1e-07   res=0.149966
XXI2\<0\>\/XI2\<3\>\/XI2\<3\>\/XI2\<2\>\/RR2 (  \
 N_SEL3\<0\>_XI2\<0\>\/XI2\<3\>\/XI2\<3\>\/XI2\<2\>\/RR2_pos WLSEL\<251\> ) \
 R_1X_LL w=1e-07 l=1e-07   res=0.149966
XXI2\<0\>\/XI2\<3\>\/XI2\<3\>\/XI2\<2\>\/RR1 (  \
 N_SEL2\<3\>_XI2\<0\>\/XI2\<3\>\/XI2\<3\>\/XI2\<2\>\/RR1_pos WLSEL\<250\> ) \
 R_1X_LL w=1e-07 l=1e-07   res=0.149966
XXI2\<0\>\/XI2\<3\>\/XI2\<3\>\/XI2\<2\>\/RR0 (  \
 N_SEL1\<3\>_XI2\<0\>\/XI2\<3\>\/XI2\<3\>\/XI2\<2\>\/RR0_pos WLSEL\<249\> ) \
 R_1X_LL w=1e-07 l=1e-07   res=0.149966
XXI2\<0\>\/XI2\<3\>\/XI2\<3\>\/XI2\<2\>\/RI2 (  \
 N_SEL0\<2\>_XI2\<0\>\/XI2\<3\>\/XI2\<3\>\/XI2\<2\>\/RI2_pos WLSEL\<248\> ) \
 R_1X_LL w=1e-07 l=1e-07   res=0.149966
XXI2\<0\>\/XI2\<3\>\/XI2\<3\>\/XI2\<1\>\/RR2 (  \
 N_SEL3\<0\>_XI2\<0\>\/XI2\<3\>\/XI2\<3\>\/XI2\<1\>\/RR2_pos WLSEL\<247\> ) \
 R_1X_LL w=1e-07 l=1e-07   res=0.149966
XXI2\<0\>\/XI2\<3\>\/XI2\<3\>\/XI2\<1\>\/RR1 (  \
 N_SEL2\<3\>_XI2\<0\>\/XI2\<3\>\/XI2\<3\>\/XI2\<1\>\/RR1_pos WLSEL\<246\> ) \
 R_1X_LL w=1e-07 l=1e-07   res=0.149966
XXI2\<0\>\/XI2\<3\>\/XI2\<3\>\/XI2\<1\>\/RR0 (  \
 N_SEL1\<3\>_XI2\<0\>\/XI2\<3\>\/XI2\<3\>\/XI2\<1\>\/RR0_pos WLSEL\<245\> ) \
 R_1X_LL w=1e-07 l=1e-07   res=0.149966
XXI2\<0\>\/XI2\<3\>\/XI2\<3\>\/XI2\<1\>\/RI2 (  \
 N_SEL0\<1\>_XI2\<0\>\/XI2\<3\>\/XI2\<3\>\/XI2\<1\>\/RI2_pos WLSEL\<244\> ) \
 R_1X_LL w=1e-07 l=1e-07   res=0.149966
XXI2\<0\>\/XI2\<3\>\/XI2\<3\>\/XI2\<0\>\/RR2 (  \
 N_SEL3\<0\>_XI2\<0\>\/XI2\<3\>\/XI2\<3\>\/XI2\<0\>\/RR2_pos WLSEL\<243\> ) \
 R_1X_LL w=1e-07 l=1e-07   res=0.149966
XXI2\<0\>\/XI2\<3\>\/XI2\<3\>\/XI2\<0\>\/RR1 (  \
 N_SEL2\<3\>_XI2\<0\>\/XI2\<3\>\/XI2\<3\>\/XI2\<0\>\/RR1_pos WLSEL\<242\> ) \
 R_1X_LL w=1e-07 l=1e-07   res=0.149966
XXI2\<0\>\/XI2\<3\>\/XI2\<3\>\/XI2\<0\>\/RR0 (  \
 N_SEL1\<3\>_XI2\<0\>\/XI2\<3\>\/XI2\<3\>\/XI2\<0\>\/RR0_pos WLSEL\<241\> ) \
 R_1X_LL w=1e-07 l=1e-07   res=0.149966
XXI2\<0\>\/XI2\<3\>\/XI2\<3\>\/XI2\<0\>\/RI2 (  \
 N_SEL0\<0\>_XI2\<0\>\/XI2\<3\>\/XI2\<3\>\/XI2\<0\>\/RI2_pos WLSEL\<240\> ) \
 R_1X_LL w=1e-07 l=1e-07   res=0.149966
XXI2\<0\>\/XI2\<3\>\/XI2\<2\>\/XI2\<3\>\/RR2 (  \
 N_SEL3\<0\>_XI2\<0\>\/XI2\<3\>\/XI2\<2\>\/XI2\<3\>\/RR2_pos WLSEL\<239\> ) \
 R_1X_LL w=1e-07 l=1e-07   res=0.149966
XXI2\<0\>\/XI2\<3\>\/XI2\<2\>\/XI2\<3\>\/RR1 (  \
 N_SEL2\<3\>_XI2\<0\>\/XI2\<3\>\/XI2\<2\>\/XI2\<3\>\/RR1_pos WLSEL\<238\> ) \
 R_1X_LL w=1e-07 l=1e-07   res=0.149966
XXI2\<0\>\/XI2\<3\>\/XI2\<2\>\/XI2\<3\>\/RR0 (  \
 N_SEL1\<2\>_XI2\<0\>\/XI2\<3\>\/XI2\<2\>\/XI2\<3\>\/RR0_pos WLSEL\<237\> ) \
 R_1X_LL w=1e-07 l=1e-07   res=0.149966
XXI2\<0\>\/XI2\<3\>\/XI2\<2\>\/XI2\<3\>\/RI2 (  \
 N_SEL0\<3\>_XI2\<0\>\/XI2\<3\>\/XI2\<2\>\/XI2\<3\>\/RI2_pos WLSEL\<236\> ) \
 R_1X_LL w=1e-07 l=1e-07   res=0.149966
XXI2\<0\>\/XI2\<3\>\/XI2\<2\>\/XI2\<2\>\/RR2 (  \
 N_SEL3\<0\>_XI2\<0\>\/XI2\<3\>\/XI2\<2\>\/XI2\<2\>\/RR2_pos WLSEL\<235\> ) \
 R_1X_LL w=1e-07 l=1e-07   res=0.149966
XXI2\<0\>\/XI2\<3\>\/XI2\<2\>\/XI2\<2\>\/RR1 (  \
 N_SEL2\<3\>_XI2\<0\>\/XI2\<3\>\/XI2\<2\>\/XI2\<2\>\/RR1_pos WLSEL\<234\> ) \
 R_1X_LL w=1e-07 l=1e-07   res=0.149966
XXI2\<0\>\/XI2\<3\>\/XI2\<2\>\/XI2\<2\>\/RR0 (  \
 N_SEL1\<2\>_XI2\<0\>\/XI2\<3\>\/XI2\<2\>\/XI2\<2\>\/RR0_pos WLSEL\<233\> ) \
 R_1X_LL w=1e-07 l=1e-07   res=0.149966
XXI2\<0\>\/XI2\<3\>\/XI2\<2\>\/XI2\<2\>\/RI2 (  \
 N_SEL0\<2\>_XI2\<0\>\/XI2\<3\>\/XI2\<2\>\/XI2\<2\>\/RI2_pos WLSEL\<232\> ) \
 R_1X_LL w=1e-07 l=1e-07   res=0.149966
XXI2\<0\>\/XI2\<3\>\/XI2\<2\>\/XI2\<1\>\/RR2 (  \
 N_SEL3\<0\>_XI2\<0\>\/XI2\<3\>\/XI2\<2\>\/XI2\<1\>\/RR2_pos WLSEL\<231\> ) \
 R_1X_LL w=1e-07 l=1e-07   res=0.149966
XXI2\<0\>\/XI2\<3\>\/XI2\<2\>\/XI2\<1\>\/RR1 (  \
 N_SEL2\<3\>_XI2\<0\>\/XI2\<3\>\/XI2\<2\>\/XI2\<1\>\/RR1_pos WLSEL\<230\> ) \
 R_1X_LL w=1e-07 l=1e-07   res=0.149966
XXI2\<0\>\/XI2\<3\>\/XI2\<2\>\/XI2\<1\>\/RR0 (  \
 N_SEL1\<2\>_XI2\<0\>\/XI2\<3\>\/XI2\<2\>\/XI2\<1\>\/RR0_pos WLSEL\<229\> ) \
 R_1X_LL w=1e-07 l=1e-07   res=0.149966
XXI2\<0\>\/XI2\<3\>\/XI2\<2\>\/XI2\<1\>\/RI2 (  \
 N_SEL0\<1\>_XI2\<0\>\/XI2\<3\>\/XI2\<2\>\/XI2\<1\>\/RI2_pos WLSEL\<228\> ) \
 R_1X_LL w=1e-07 l=1e-07   res=0.149966
XXI2\<0\>\/XI2\<3\>\/XI2\<2\>\/XI2\<0\>\/RR2 (  \
 N_SEL3\<0\>_XI2\<0\>\/XI2\<3\>\/XI2\<2\>\/XI2\<0\>\/RR2_pos WLSEL\<227\> ) \
 R_1X_LL w=1e-07 l=1e-07   res=0.149966
XXI2\<0\>\/XI2\<3\>\/XI2\<2\>\/XI2\<0\>\/RR1 (  \
 N_SEL2\<3\>_XI2\<0\>\/XI2\<3\>\/XI2\<2\>\/XI2\<0\>\/RR1_pos WLSEL\<226\> ) \
 R_1X_LL w=1e-07 l=1e-07   res=0.149966
XXI2\<0\>\/XI2\<3\>\/XI2\<2\>\/XI2\<0\>\/RR0 (  \
 N_SEL1\<2\>_XI2\<0\>\/XI2\<3\>\/XI2\<2\>\/XI2\<0\>\/RR0_pos WLSEL\<225\> ) \
 R_1X_LL w=1e-07 l=1e-07   res=0.149966
XXI2\<0\>\/XI2\<3\>\/XI2\<2\>\/XI2\<0\>\/RI2 (  \
 N_SEL0\<0\>_XI2\<0\>\/XI2\<3\>\/XI2\<2\>\/XI2\<0\>\/RI2_pos WLSEL\<224\> ) \
 R_1X_LL w=1e-07 l=1e-07   res=0.149966
XXI2\<0\>\/XI2\<3\>\/XI2\<1\>\/XI2\<3\>\/RR2 (  \
 N_SEL3\<0\>_XI2\<0\>\/XI2\<3\>\/XI2\<1\>\/XI2\<3\>\/RR2_pos WLSEL\<223\> ) \
 R_1X_LL w=1e-07 l=1e-07   res=0.149966
XXI2\<0\>\/XI2\<3\>\/XI2\<1\>\/XI2\<3\>\/RR1 (  \
 N_SEL2\<3\>_XI2\<0\>\/XI2\<3\>\/XI2\<1\>\/XI2\<3\>\/RR1_pos WLSEL\<222\> ) \
 R_1X_LL w=1e-07 l=1e-07   res=0.149966
XXI2\<0\>\/XI2\<3\>\/XI2\<1\>\/XI2\<3\>\/RR0 (  \
 N_SEL1\<1\>_XI2\<0\>\/XI2\<3\>\/XI2\<1\>\/XI2\<3\>\/RR0_pos WLSEL\<221\> ) \
 R_1X_LL w=1e-07 l=1e-07   res=0.149966
XXI2\<0\>\/XI2\<3\>\/XI2\<1\>\/XI2\<3\>\/RI2 (  \
 N_SEL0\<3\>_XI2\<0\>\/XI2\<3\>\/XI2\<1\>\/XI2\<3\>\/RI2_pos WLSEL\<220\> ) \
 R_1X_LL w=1e-07 l=1e-07   res=0.149966
XXI2\<0\>\/XI2\<3\>\/XI2\<1\>\/XI2\<2\>\/RR2 (  \
 N_SEL3\<0\>_XI2\<0\>\/XI2\<3\>\/XI2\<1\>\/XI2\<2\>\/RR2_pos WLSEL\<219\> ) \
 R_1X_LL w=1e-07 l=1e-07   res=0.149966
XXI2\<0\>\/XI2\<3\>\/XI2\<1\>\/XI2\<2\>\/RR1 (  \
 N_SEL2\<3\>_XI2\<0\>\/XI2\<3\>\/XI2\<1\>\/XI2\<2\>\/RR1_pos WLSEL\<218\> ) \
 R_1X_LL w=1e-07 l=1e-07   res=0.149966
XXI2\<0\>\/XI2\<3\>\/XI2\<1\>\/XI2\<2\>\/RR0 (  \
 N_SEL1\<1\>_XI2\<0\>\/XI2\<3\>\/XI2\<1\>\/XI2\<2\>\/RR0_pos WLSEL\<217\> ) \
 R_1X_LL w=1e-07 l=1e-07   res=0.149966
XXI2\<0\>\/XI2\<3\>\/XI2\<1\>\/XI2\<2\>\/RI2 (  \
 N_SEL0\<2\>_XI2\<0\>\/XI2\<3\>\/XI2\<1\>\/XI2\<2\>\/RI2_pos WLSEL\<216\> ) \
 R_1X_LL w=1e-07 l=1e-07   res=0.149966
XXI2\<0\>\/XI2\<3\>\/XI2\<1\>\/XI2\<1\>\/RR2 (  \
 N_SEL3\<0\>_XI2\<0\>\/XI2\<3\>\/XI2\<1\>\/XI2\<1\>\/RR2_pos WLSEL\<215\> ) \
 R_1X_LL w=1e-07 l=1e-07   res=0.149966
XXI2\<0\>\/XI2\<3\>\/XI2\<1\>\/XI2\<1\>\/RR1 (  \
 N_SEL2\<3\>_XI2\<0\>\/XI2\<3\>\/XI2\<1\>\/XI2\<1\>\/RR1_pos WLSEL\<214\> ) \
 R_1X_LL w=1e-07 l=1e-07   res=0.149966
XXI2\<0\>\/XI2\<3\>\/XI2\<1\>\/XI2\<1\>\/RR0 (  \
 N_SEL1\<1\>_XI2\<0\>\/XI2\<3\>\/XI2\<1\>\/XI2\<1\>\/RR0_pos WLSEL\<213\> ) \
 R_1X_LL w=1e-07 l=1e-07   res=0.149966
XXI2\<0\>\/XI2\<3\>\/XI2\<1\>\/XI2\<1\>\/RI2 (  \
 N_SEL0\<1\>_XI2\<0\>\/XI2\<3\>\/XI2\<1\>\/XI2\<1\>\/RI2_pos WLSEL\<212\> ) \
 R_1X_LL w=1e-07 l=1e-07   res=0.149966
XXI2\<0\>\/XI2\<3\>\/XI2\<1\>\/XI2\<0\>\/RR2 (  \
 N_SEL3\<0\>_XI2\<0\>\/XI2\<3\>\/XI2\<1\>\/XI2\<0\>\/RR2_pos WLSEL\<211\> ) \
 R_1X_LL w=1e-07 l=1e-07   res=0.149966
XXI2\<0\>\/XI2\<3\>\/XI2\<1\>\/XI2\<0\>\/RR1 (  \
 N_SEL2\<3\>_XI2\<0\>\/XI2\<3\>\/XI2\<1\>\/XI2\<0\>\/RR1_pos WLSEL\<210\> ) \
 R_1X_LL w=1e-07 l=1e-07   res=0.149966
XXI2\<0\>\/XI2\<3\>\/XI2\<1\>\/XI2\<0\>\/RR0 (  \
 N_SEL1\<1\>_XI2\<0\>\/XI2\<3\>\/XI2\<1\>\/XI2\<0\>\/RR0_pos WLSEL\<209\> ) \
 R_1X_LL w=1e-07 l=1e-07   res=0.149966
XXI2\<0\>\/XI2\<3\>\/XI2\<1\>\/XI2\<0\>\/RI2 (  \
 N_SEL0\<0\>_XI2\<0\>\/XI2\<3\>\/XI2\<1\>\/XI2\<0\>\/RI2_pos WLSEL\<208\> ) \
 R_1X_LL w=1e-07 l=1e-07   res=0.149966
XXI2\<0\>\/XI2\<3\>\/XI2\<0\>\/XI2\<3\>\/RR2 (  \
 N_SEL3\<0\>_XI2\<0\>\/XI2\<3\>\/XI2\<0\>\/XI2\<3\>\/RR2_pos WLSEL\<207\> ) \
 R_1X_LL w=1e-07 l=1e-07   res=0.149966
XXI2\<0\>\/XI2\<3\>\/XI2\<0\>\/XI2\<3\>\/RR1 (  \
 N_SEL2\<3\>_XI2\<0\>\/XI2\<3\>\/XI2\<0\>\/XI2\<3\>\/RR1_pos WLSEL\<206\> ) \
 R_1X_LL w=1e-07 l=1e-07   res=0.149966
XXI2\<0\>\/XI2\<3\>\/XI2\<0\>\/XI2\<3\>\/RR0 (  \
 N_SEL1\<0\>_XI2\<0\>\/XI2\<3\>\/XI2\<0\>\/XI2\<3\>\/RR0_pos WLSEL\<205\> ) \
 R_1X_LL w=1e-07 l=1e-07   res=0.149966
XXI2\<0\>\/XI2\<3\>\/XI2\<0\>\/XI2\<3\>\/RI2 (  \
 N_SEL0\<3\>_XI2\<0\>\/XI2\<3\>\/XI2\<0\>\/XI2\<3\>\/RI2_pos WLSEL\<204\> ) \
 R_1X_LL w=1e-07 l=1e-07   res=0.149966
XXI2\<0\>\/XI2\<3\>\/XI2\<0\>\/XI2\<2\>\/RR2 (  \
 N_SEL3\<0\>_XI2\<0\>\/XI2\<3\>\/XI2\<0\>\/XI2\<2\>\/RR2_pos WLSEL\<203\> ) \
 R_1X_LL w=1e-07 l=1e-07   res=0.149966
XXI2\<0\>\/XI2\<3\>\/XI2\<0\>\/XI2\<2\>\/RR1 (  \
 N_SEL2\<3\>_XI2\<0\>\/XI2\<3\>\/XI2\<0\>\/XI2\<2\>\/RR1_pos WLSEL\<202\> ) \
 R_1X_LL w=1e-07 l=1e-07   res=0.149966
XXI2\<0\>\/XI2\<3\>\/XI2\<0\>\/XI2\<2\>\/RR0 (  \
 N_SEL1\<0\>_XI2\<0\>\/XI2\<3\>\/XI2\<0\>\/XI2\<2\>\/RR0_pos WLSEL\<201\> ) \
 R_1X_LL w=1e-07 l=1e-07   res=0.149966
XXI2\<0\>\/XI2\<3\>\/XI2\<0\>\/XI2\<2\>\/RI2 (  \
 N_SEL0\<2\>_XI2\<0\>\/XI2\<3\>\/XI2\<0\>\/XI2\<2\>\/RI2_pos WLSEL\<200\> ) \
 R_1X_LL w=1e-07 l=1e-07   res=0.149966
XXI2\<0\>\/XI2\<3\>\/XI2\<0\>\/XI2\<1\>\/RR2 (  \
 N_SEL3\<0\>_XI2\<0\>\/XI2\<3\>\/XI2\<0\>\/XI2\<1\>\/RR2_pos WLSEL\<199\> ) \
 R_1X_LL w=1e-07 l=1e-07   res=0.149966
XXI2\<0\>\/XI2\<3\>\/XI2\<0\>\/XI2\<1\>\/RR1 (  \
 N_SEL2\<3\>_XI2\<0\>\/XI2\<3\>\/XI2\<0\>\/XI2\<1\>\/RR1_pos WLSEL\<198\> ) \
 R_1X_LL w=1e-07 l=1e-07   res=0.149966
XXI2\<0\>\/XI2\<3\>\/XI2\<0\>\/XI2\<1\>\/RR0 (  \
 N_SEL1\<0\>_XI2\<0\>\/XI2\<3\>\/XI2\<0\>\/XI2\<1\>\/RR0_pos WLSEL\<197\> ) \
 R_1X_LL w=1e-07 l=1e-07   res=0.149966
XXI2\<0\>\/XI2\<3\>\/XI2\<0\>\/XI2\<1\>\/RI2 (  \
 N_SEL0\<1\>_XI2\<0\>\/XI2\<3\>\/XI2\<0\>\/XI2\<1\>\/RI2_pos WLSEL\<196\> ) \
 R_1X_LL w=1e-07 l=1e-07   res=0.149966
XXI2\<0\>\/XI2\<3\>\/XI2\<0\>\/XI2\<0\>\/RR2 (  \
 N_SEL3\<0\>_XI2\<0\>\/XI2\<3\>\/XI2\<0\>\/XI2\<0\>\/RR2_pos WLSEL\<195\> ) \
 R_1X_LL w=1e-07 l=1e-07   res=0.149966
XXI2\<0\>\/XI2\<3\>\/XI2\<0\>\/XI2\<0\>\/RR1 (  \
 N_SEL2\<3\>_XI2\<0\>\/XI2\<3\>\/XI2\<0\>\/XI2\<0\>\/RR1_pos WLSEL\<194\> ) \
 R_1X_LL w=1e-07 l=1e-07   res=0.149966
XXI2\<0\>\/XI2\<3\>\/XI2\<0\>\/XI2\<0\>\/RR0 (  \
 N_SEL1\<0\>_XI2\<0\>\/XI2\<3\>\/XI2\<0\>\/XI2\<0\>\/RR0_pos WLSEL\<193\> ) \
 R_1X_LL w=1e-07 l=1e-07   res=0.149966
XXI2\<0\>\/XI2\<3\>\/XI2\<0\>\/XI2\<0\>\/RI2 (  \
 N_SEL0\<0\>_XI2\<0\>\/XI2\<3\>\/XI2\<0\>\/XI2\<0\>\/RI2_pos WLSEL\<192\> ) \
 R_1X_LL w=1e-07 l=1e-07   res=0.149966
XXI2\<0\>\/XI2\<2\>\/XI2\<3\>\/XI2\<3\>\/RR2 (  \
 N_SEL3\<0\>_XI2\<0\>\/XI2\<2\>\/XI2\<3\>\/XI2\<3\>\/RR2_pos WLSEL\<191\> ) \
 R_1X_LL w=1e-07 l=1e-07   res=0.149966
XXI2\<0\>\/XI2\<2\>\/XI2\<3\>\/XI2\<3\>\/RR1 (  \
 N_SEL2\<2\>_XI2\<0\>\/XI2\<2\>\/XI2\<3\>\/XI2\<3\>\/RR1_pos WLSEL\<190\> ) \
 R_1X_LL w=1e-07 l=1e-07   res=0.149966
XXI2\<0\>\/XI2\<2\>\/XI2\<3\>\/XI2\<3\>\/RR0 (  \
 N_SEL1\<3\>_XI2\<0\>\/XI2\<2\>\/XI2\<3\>\/XI2\<3\>\/RR0_pos WLSEL\<189\> ) \
 R_1X_LL w=1e-07 l=1e-07   res=0.149966
XXI2\<0\>\/XI2\<2\>\/XI2\<3\>\/XI2\<3\>\/RI2 (  \
 N_SEL0\<3\>_XI2\<0\>\/XI2\<2\>\/XI2\<3\>\/XI2\<3\>\/RI2_pos WLSEL\<188\> ) \
 R_1X_LL w=1e-07 l=1e-07   res=0.149966
XXI2\<0\>\/XI2\<2\>\/XI2\<3\>\/XI2\<2\>\/RR2 (  \
 N_SEL3\<0\>_XI2\<0\>\/XI2\<2\>\/XI2\<3\>\/XI2\<2\>\/RR2_pos WLSEL\<187\> ) \
 R_1X_LL w=1e-07 l=1e-07   res=0.149966
XXI2\<0\>\/XI2\<2\>\/XI2\<3\>\/XI2\<2\>\/RR1 (  \
 N_SEL2\<2\>_XI2\<0\>\/XI2\<2\>\/XI2\<3\>\/XI2\<2\>\/RR1_pos WLSEL\<186\> ) \
 R_1X_LL w=1e-07 l=1e-07   res=0.149966
XXI2\<0\>\/XI2\<2\>\/XI2\<3\>\/XI2\<2\>\/RR0 (  \
 N_SEL1\<3\>_XI2\<0\>\/XI2\<2\>\/XI2\<3\>\/XI2\<2\>\/RR0_pos WLSEL\<185\> ) \
 R_1X_LL w=1e-07 l=1e-07   res=0.149966
XXI2\<0\>\/XI2\<2\>\/XI2\<3\>\/XI2\<2\>\/RI2 (  \
 N_SEL0\<2\>_XI2\<0\>\/XI2\<2\>\/XI2\<3\>\/XI2\<2\>\/RI2_pos WLSEL\<184\> ) \
 R_1X_LL w=1e-07 l=1e-07   res=0.149966
XXI2\<0\>\/XI2\<2\>\/XI2\<3\>\/XI2\<1\>\/RR2 (  \
 N_SEL3\<0\>_XI2\<0\>\/XI2\<2\>\/XI2\<3\>\/XI2\<1\>\/RR2_pos WLSEL\<183\> ) \
 R_1X_LL w=1e-07 l=1e-07   res=0.149966
XXI2\<0\>\/XI2\<2\>\/XI2\<3\>\/XI2\<1\>\/RR1 (  \
 N_SEL2\<2\>_XI2\<0\>\/XI2\<2\>\/XI2\<3\>\/XI2\<1\>\/RR1_pos WLSEL\<182\> ) \
 R_1X_LL w=1e-07 l=1e-07   res=0.149966
XXI2\<0\>\/XI2\<2\>\/XI2\<3\>\/XI2\<1\>\/RR0 (  \
 N_SEL1\<3\>_XI2\<0\>\/XI2\<2\>\/XI2\<3\>\/XI2\<1\>\/RR0_pos WLSEL\<181\> ) \
 R_1X_LL w=1e-07 l=1e-07   res=0.149966
XXI2\<0\>\/XI2\<2\>\/XI2\<3\>\/XI2\<1\>\/RI2 (  \
 N_SEL0\<1\>_XI2\<0\>\/XI2\<2\>\/XI2\<3\>\/XI2\<1\>\/RI2_pos WLSEL\<180\> ) \
 R_1X_LL w=1e-07 l=1e-07   res=0.149966
XXI2\<0\>\/XI2\<2\>\/XI2\<3\>\/XI2\<0\>\/RR2 (  \
 N_SEL3\<0\>_XI2\<0\>\/XI2\<2\>\/XI2\<3\>\/XI2\<0\>\/RR2_pos WLSEL\<179\> ) \
 R_1X_LL w=1e-07 l=1e-07   res=0.149966
XXI2\<0\>\/XI2\<2\>\/XI2\<3\>\/XI2\<0\>\/RR1 (  \
 N_SEL2\<2\>_XI2\<0\>\/XI2\<2\>\/XI2\<3\>\/XI2\<0\>\/RR1_pos WLSEL\<178\> ) \
 R_1X_LL w=1e-07 l=1e-07   res=0.149966
XXI2\<0\>\/XI2\<2\>\/XI2\<3\>\/XI2\<0\>\/RR0 (  \
 N_SEL1\<3\>_XI2\<0\>\/XI2\<2\>\/XI2\<3\>\/XI2\<0\>\/RR0_pos WLSEL\<177\> ) \
 R_1X_LL w=1e-07 l=1e-07   res=0.149966
XXI2\<0\>\/XI2\<2\>\/XI2\<3\>\/XI2\<0\>\/RI2 (  \
 N_SEL0\<0\>_XI2\<0\>\/XI2\<2\>\/XI2\<3\>\/XI2\<0\>\/RI2_pos WLSEL\<176\> ) \
 R_1X_LL w=1e-07 l=1e-07   res=0.149966
XXI2\<0\>\/XI2\<2\>\/XI2\<2\>\/XI2\<3\>\/RR2 (  \
 N_SEL3\<0\>_XI2\<0\>\/XI2\<2\>\/XI2\<2\>\/XI2\<3\>\/RR2_pos WLSEL\<175\> ) \
 R_1X_LL w=1e-07 l=1e-07   res=0.149966
XXI2\<0\>\/XI2\<2\>\/XI2\<2\>\/XI2\<3\>\/RR1 (  \
 N_SEL2\<2\>_XI2\<0\>\/XI2\<2\>\/XI2\<2\>\/XI2\<3\>\/RR1_pos WLSEL\<174\> ) \
 R_1X_LL w=1e-07 l=1e-07   res=0.149966
XXI2\<0\>\/XI2\<2\>\/XI2\<2\>\/XI2\<3\>\/RR0 (  \
 N_SEL1\<2\>_XI2\<0\>\/XI2\<2\>\/XI2\<2\>\/XI2\<3\>\/RR0_pos WLSEL\<173\> ) \
 R_1X_LL w=1e-07 l=1e-07   res=0.149966
XXI2\<0\>\/XI2\<2\>\/XI2\<2\>\/XI2\<3\>\/RI2 (  \
 N_SEL0\<3\>_XI2\<0\>\/XI2\<2\>\/XI2\<2\>\/XI2\<3\>\/RI2_pos WLSEL\<172\> ) \
 R_1X_LL w=1e-07 l=1e-07   res=0.149966
XXI2\<0\>\/XI2\<2\>\/XI2\<2\>\/XI2\<2\>\/RR2 (  \
 N_SEL3\<0\>_XI2\<0\>\/XI2\<2\>\/XI2\<2\>\/XI2\<2\>\/RR2_pos WLSEL\<171\> ) \
 R_1X_LL w=1e-07 l=1e-07   res=0.149966
XXI2\<0\>\/XI2\<2\>\/XI2\<2\>\/XI2\<2\>\/RR1 (  \
 N_SEL2\<2\>_XI2\<0\>\/XI2\<2\>\/XI2\<2\>\/XI2\<2\>\/RR1_pos WLSEL\<170\> ) \
 R_1X_LL w=1e-07 l=1e-07   res=0.149966
XXI2\<0\>\/XI2\<2\>\/XI2\<2\>\/XI2\<2\>\/RR0 (  \
 N_SEL1\<2\>_XI2\<0\>\/XI2\<2\>\/XI2\<2\>\/XI2\<2\>\/RR0_pos WLSEL\<169\> ) \
 R_1X_LL w=1e-07 l=1e-07   res=0.149966
XXI2\<0\>\/XI2\<2\>\/XI2\<2\>\/XI2\<2\>\/RI2 (  \
 N_SEL0\<2\>_XI2\<0\>\/XI2\<2\>\/XI2\<2\>\/XI2\<2\>\/RI2_pos WLSEL\<168\> ) \
 R_1X_LL w=1e-07 l=1e-07   res=0.149966
XXI2\<0\>\/XI2\<2\>\/XI2\<2\>\/XI2\<1\>\/RR2 (  \
 N_SEL3\<0\>_XI2\<0\>\/XI2\<2\>\/XI2\<2\>\/XI2\<1\>\/RR2_pos WLSEL\<167\> ) \
 R_1X_LL w=1e-07 l=1e-07   res=0.149966
XXI2\<0\>\/XI2\<2\>\/XI2\<2\>\/XI2\<1\>\/RR1 (  \
 N_SEL2\<2\>_XI2\<0\>\/XI2\<2\>\/XI2\<2\>\/XI2\<1\>\/RR1_pos WLSEL\<166\> ) \
 R_1X_LL w=1e-07 l=1e-07   res=0.149966
XXI2\<0\>\/XI2\<2\>\/XI2\<2\>\/XI2\<1\>\/RR0 (  \
 N_SEL1\<2\>_XI2\<0\>\/XI2\<2\>\/XI2\<2\>\/XI2\<1\>\/RR0_pos WLSEL\<165\> ) \
 R_1X_LL w=1e-07 l=1e-07   res=0.149966
XXI2\<0\>\/XI2\<2\>\/XI2\<2\>\/XI2\<1\>\/RI2 (  \
 N_SEL0\<1\>_XI2\<0\>\/XI2\<2\>\/XI2\<2\>\/XI2\<1\>\/RI2_pos WLSEL\<164\> ) \
 R_1X_LL w=1e-07 l=1e-07   res=0.149966
XXI2\<0\>\/XI2\<2\>\/XI2\<2\>\/XI2\<0\>\/RR2 (  \
 N_SEL3\<0\>_XI2\<0\>\/XI2\<2\>\/XI2\<2\>\/XI2\<0\>\/RR2_pos WLSEL\<163\> ) \
 R_1X_LL w=1e-07 l=1e-07   res=0.149966
XXI2\<0\>\/XI2\<2\>\/XI2\<2\>\/XI2\<0\>\/RR1 (  \
 N_SEL2\<2\>_XI2\<0\>\/XI2\<2\>\/XI2\<2\>\/XI2\<0\>\/RR1_pos WLSEL\<162\> ) \
 R_1X_LL w=1e-07 l=1e-07   res=0.149966
XXI2\<0\>\/XI2\<2\>\/XI2\<2\>\/XI2\<0\>\/RR0 (  \
 N_SEL1\<2\>_XI2\<0\>\/XI2\<2\>\/XI2\<2\>\/XI2\<0\>\/RR0_pos WLSEL\<161\> ) \
 R_1X_LL w=1e-07 l=1e-07   res=0.149966
XXI2\<0\>\/XI2\<2\>\/XI2\<2\>\/XI2\<0\>\/RI2 (  \
 N_SEL0\<0\>_XI2\<0\>\/XI2\<2\>\/XI2\<2\>\/XI2\<0\>\/RI2_pos WLSEL\<160\> ) \
 R_1X_LL w=1e-07 l=1e-07   res=0.149966
XXI2\<0\>\/XI2\<2\>\/XI2\<1\>\/XI2\<3\>\/RR2 (  \
 N_SEL3\<0\>_XI2\<0\>\/XI2\<2\>\/XI2\<1\>\/XI2\<3\>\/RR2_pos WLSEL\<159\> ) \
 R_1X_LL w=1e-07 l=1e-07   res=0.149966
XXI2\<0\>\/XI2\<2\>\/XI2\<1\>\/XI2\<3\>\/RR1 (  \
 N_SEL2\<2\>_XI2\<0\>\/XI2\<2\>\/XI2\<1\>\/XI2\<3\>\/RR1_pos WLSEL\<158\> ) \
 R_1X_LL w=1e-07 l=1e-07   res=0.149966
XXI2\<0\>\/XI2\<2\>\/XI2\<1\>\/XI2\<3\>\/RR0 (  \
 N_SEL1\<1\>_XI2\<0\>\/XI2\<2\>\/XI2\<1\>\/XI2\<3\>\/RR0_pos WLSEL\<157\> ) \
 R_1X_LL w=1e-07 l=1e-07   res=0.149966
XXI2\<0\>\/XI2\<2\>\/XI2\<1\>\/XI2\<3\>\/RI2 (  \
 N_SEL0\<3\>_XI2\<0\>\/XI2\<2\>\/XI2\<1\>\/XI2\<3\>\/RI2_pos WLSEL\<156\> ) \
 R_1X_LL w=1e-07 l=1e-07   res=0.149966
XXI2\<0\>\/XI2\<2\>\/XI2\<1\>\/XI2\<2\>\/RR2 (  \
 N_SEL3\<0\>_XI2\<0\>\/XI2\<2\>\/XI2\<1\>\/XI2\<2\>\/RR2_pos WLSEL\<155\> ) \
 R_1X_LL w=1e-07 l=1e-07   res=0.149966
XXI2\<0\>\/XI2\<2\>\/XI2\<1\>\/XI2\<2\>\/RR1 (  \
 N_SEL2\<2\>_XI2\<0\>\/XI2\<2\>\/XI2\<1\>\/XI2\<2\>\/RR1_pos WLSEL\<154\> ) \
 R_1X_LL w=1e-07 l=1e-07   res=0.149966
XXI2\<0\>\/XI2\<2\>\/XI2\<1\>\/XI2\<2\>\/RR0 (  \
 N_SEL1\<1\>_XI2\<0\>\/XI2\<2\>\/XI2\<1\>\/XI2\<2\>\/RR0_pos WLSEL\<153\> ) \
 R_1X_LL w=1e-07 l=1e-07   res=0.149966
XXI2\<0\>\/XI2\<2\>\/XI2\<1\>\/XI2\<2\>\/RI2 (  \
 N_SEL0\<2\>_XI2\<0\>\/XI2\<2\>\/XI2\<1\>\/XI2\<2\>\/RI2_pos WLSEL\<152\> ) \
 R_1X_LL w=1e-07 l=1e-07   res=0.149966
XXI2\<0\>\/XI2\<2\>\/XI2\<1\>\/XI2\<1\>\/RR2 (  \
 N_SEL3\<0\>_XI2\<0\>\/XI2\<2\>\/XI2\<1\>\/XI2\<1\>\/RR2_pos WLSEL\<151\> ) \
 R_1X_LL w=1e-07 l=1e-07   res=0.149966
XXI2\<0\>\/XI2\<2\>\/XI2\<1\>\/XI2\<1\>\/RR1 (  \
 N_SEL2\<2\>_XI2\<0\>\/XI2\<2\>\/XI2\<1\>\/XI2\<1\>\/RR1_pos WLSEL\<150\> ) \
 R_1X_LL w=1e-07 l=1e-07   res=0.149966
XXI2\<0\>\/XI2\<2\>\/XI2\<1\>\/XI2\<1\>\/RR0 (  \
 N_SEL1\<1\>_XI2\<0\>\/XI2\<2\>\/XI2\<1\>\/XI2\<1\>\/RR0_pos WLSEL\<149\> ) \
 R_1X_LL w=1e-07 l=1e-07   res=0.149966
XXI2\<0\>\/XI2\<2\>\/XI2\<1\>\/XI2\<1\>\/RI2 (  \
 N_SEL0\<1\>_XI2\<0\>\/XI2\<2\>\/XI2\<1\>\/XI2\<1\>\/RI2_pos WLSEL\<148\> ) \
 R_1X_LL w=1e-07 l=1e-07   res=0.149966
XXI2\<0\>\/XI2\<2\>\/XI2\<1\>\/XI2\<0\>\/RR2 (  \
 N_SEL3\<0\>_XI2\<0\>\/XI2\<2\>\/XI2\<1\>\/XI2\<0\>\/RR2_pos WLSEL\<147\> ) \
 R_1X_LL w=1e-07 l=1e-07   res=0.149966
XXI2\<0\>\/XI2\<2\>\/XI2\<1\>\/XI2\<0\>\/RR1 (  \
 N_SEL2\<2\>_XI2\<0\>\/XI2\<2\>\/XI2\<1\>\/XI2\<0\>\/RR1_pos WLSEL\<146\> ) \
 R_1X_LL w=1e-07 l=1e-07   res=0.149966
XXI2\<0\>\/XI2\<2\>\/XI2\<1\>\/XI2\<0\>\/RR0 (  \
 N_SEL1\<1\>_XI2\<0\>\/XI2\<2\>\/XI2\<1\>\/XI2\<0\>\/RR0_pos WLSEL\<145\> ) \
 R_1X_LL w=1e-07 l=1e-07   res=0.149966
XXI2\<0\>\/XI2\<2\>\/XI2\<1\>\/XI2\<0\>\/RI2 (  \
 N_SEL0\<0\>_XI2\<0\>\/XI2\<2\>\/XI2\<1\>\/XI2\<0\>\/RI2_pos WLSEL\<144\> ) \
 R_1X_LL w=1e-07 l=1e-07   res=0.149966
XXI2\<0\>\/XI2\<2\>\/XI2\<0\>\/XI2\<3\>\/RR2 (  \
 N_SEL3\<0\>_XI2\<0\>\/XI2\<2\>\/XI2\<0\>\/XI2\<3\>\/RR2_pos WLSEL\<143\> ) \
 R_1X_LL w=1e-07 l=1e-07   res=0.149966
XXI2\<0\>\/XI2\<2\>\/XI2\<0\>\/XI2\<3\>\/RR1 (  \
 N_SEL2\<2\>_XI2\<0\>\/XI2\<2\>\/XI2\<0\>\/XI2\<3\>\/RR1_pos WLSEL\<142\> ) \
 R_1X_LL w=1e-07 l=1e-07   res=0.149966
XXI2\<0\>\/XI2\<2\>\/XI2\<0\>\/XI2\<3\>\/RR0 (  \
 N_SEL1\<0\>_XI2\<0\>\/XI2\<2\>\/XI2\<0\>\/XI2\<3\>\/RR0_pos WLSEL\<141\> ) \
 R_1X_LL w=1e-07 l=1e-07   res=0.149966
XXI2\<0\>\/XI2\<2\>\/XI2\<0\>\/XI2\<3\>\/RI2 (  \
 N_SEL0\<3\>_XI2\<0\>\/XI2\<2\>\/XI2\<0\>\/XI2\<3\>\/RI2_pos WLSEL\<140\> ) \
 R_1X_LL w=1e-07 l=1e-07   res=0.149966
XXI2\<0\>\/XI2\<2\>\/XI2\<0\>\/XI2\<2\>\/RR2 (  \
 N_SEL3\<0\>_XI2\<0\>\/XI2\<2\>\/XI2\<0\>\/XI2\<2\>\/RR2_pos WLSEL\<139\> ) \
 R_1X_LL w=1e-07 l=1e-07   res=0.149966
XXI2\<0\>\/XI2\<2\>\/XI2\<0\>\/XI2\<2\>\/RR1 (  \
 N_SEL2\<2\>_XI2\<0\>\/XI2\<2\>\/XI2\<0\>\/XI2\<2\>\/RR1_pos WLSEL\<138\> ) \
 R_1X_LL w=1e-07 l=1e-07   res=0.149966
XXI2\<0\>\/XI2\<2\>\/XI2\<0\>\/XI2\<2\>\/RR0 (  \
 N_SEL1\<0\>_XI2\<0\>\/XI2\<2\>\/XI2\<0\>\/XI2\<2\>\/RR0_pos WLSEL\<137\> ) \
 R_1X_LL w=1e-07 l=1e-07   res=0.149966
XXI2\<0\>\/XI2\<2\>\/XI2\<0\>\/XI2\<2\>\/RI2 (  \
 N_SEL0\<2\>_XI2\<0\>\/XI2\<2\>\/XI2\<0\>\/XI2\<2\>\/RI2_pos WLSEL\<136\> ) \
 R_1X_LL w=1e-07 l=1e-07   res=0.149966
XXI2\<0\>\/XI2\<2\>\/XI2\<0\>\/XI2\<1\>\/RR2 (  \
 N_SEL3\<0\>_XI2\<0\>\/XI2\<2\>\/XI2\<0\>\/XI2\<1\>\/RR2_pos WLSEL\<135\> ) \
 R_1X_LL w=1e-07 l=1e-07   res=0.149966
XXI2\<0\>\/XI2\<2\>\/XI2\<0\>\/XI2\<1\>\/RR1 (  \
 N_SEL2\<2\>_XI2\<0\>\/XI2\<2\>\/XI2\<0\>\/XI2\<1\>\/RR1_pos WLSEL\<134\> ) \
 R_1X_LL w=1e-07 l=1e-07   res=0.149966
XXI2\<0\>\/XI2\<2\>\/XI2\<0\>\/XI2\<1\>\/RR0 (  \
 N_SEL1\<0\>_XI2\<0\>\/XI2\<2\>\/XI2\<0\>\/XI2\<1\>\/RR0_pos WLSEL\<133\> ) \
 R_1X_LL w=1e-07 l=1e-07   res=0.149966
XXI2\<0\>\/XI2\<2\>\/XI2\<0\>\/XI2\<1\>\/RI2 (  \
 N_SEL0\<1\>_XI2\<0\>\/XI2\<2\>\/XI2\<0\>\/XI2\<1\>\/RI2_pos WLSEL\<132\> ) \
 R_1X_LL w=1e-07 l=1e-07   res=0.149966
XXI2\<0\>\/XI2\<2\>\/XI2\<0\>\/XI2\<0\>\/RR2 (  \
 N_SEL3\<0\>_XI2\<0\>\/XI2\<2\>\/XI2\<0\>\/XI2\<0\>\/RR2_pos WLSEL\<131\> ) \
 R_1X_LL w=1e-07 l=1e-07   res=0.149966
XXI2\<0\>\/XI2\<2\>\/XI2\<0\>\/XI2\<0\>\/RR1 (  \
 N_SEL2\<2\>_XI2\<0\>\/XI2\<2\>\/XI2\<0\>\/XI2\<0\>\/RR1_pos WLSEL\<130\> ) \
 R_1X_LL w=1e-07 l=1e-07   res=0.149966
XXI2\<0\>\/XI2\<2\>\/XI2\<0\>\/XI2\<0\>\/RR0 (  \
 N_SEL1\<0\>_XI2\<0\>\/XI2\<2\>\/XI2\<0\>\/XI2\<0\>\/RR0_pos WLSEL\<129\> ) \
 R_1X_LL w=1e-07 l=1e-07   res=0.149966
XXI2\<0\>\/XI2\<2\>\/XI2\<0\>\/XI2\<0\>\/RI2 (  \
 N_SEL0\<0\>_XI2\<0\>\/XI2\<2\>\/XI2\<0\>\/XI2\<0\>\/RI2_pos WLSEL\<128\> ) \
 R_1X_LL w=1e-07 l=1e-07   res=0.149966
XXI2\<0\>\/XI2\<1\>\/XI2\<3\>\/XI2\<3\>\/RR2 (  \
 N_SEL3\<0\>_XI2\<0\>\/XI2\<1\>\/XI2\<3\>\/XI2\<3\>\/RR2_pos WLSEL\<127\> ) \
 R_1X_LL w=1e-07 l=1e-07   res=0.149966
XXI2\<0\>\/XI2\<1\>\/XI2\<3\>\/XI2\<3\>\/RR1 (  \
 N_SEL2\<1\>_XI2\<0\>\/XI2\<1\>\/XI2\<3\>\/XI2\<3\>\/RR1_pos WLSEL\<126\> ) \
 R_1X_LL w=1e-07 l=1e-07   res=0.149966
XXI2\<0\>\/XI2\<1\>\/XI2\<3\>\/XI2\<3\>\/RR0 (  \
 N_SEL1\<3\>_XI2\<0\>\/XI2\<1\>\/XI2\<3\>\/XI2\<3\>\/RR0_pos WLSEL\<125\> ) \
 R_1X_LL w=1e-07 l=1e-07   res=0.149966
XXI2\<0\>\/XI2\<1\>\/XI2\<3\>\/XI2\<3\>\/RI2 (  \
 N_SEL0\<3\>_XI2\<0\>\/XI2\<1\>\/XI2\<3\>\/XI2\<3\>\/RI2_pos WLSEL\<124\> ) \
 R_1X_LL w=1e-07 l=1e-07   res=0.149966
XXI2\<0\>\/XI2\<1\>\/XI2\<3\>\/XI2\<2\>\/RR2 (  \
 N_SEL3\<0\>_XI2\<0\>\/XI2\<1\>\/XI2\<3\>\/XI2\<2\>\/RR2_pos WLSEL\<123\> ) \
 R_1X_LL w=1e-07 l=1e-07   res=0.149966
XXI2\<0\>\/XI2\<1\>\/XI2\<3\>\/XI2\<2\>\/RR1 (  \
 N_SEL2\<1\>_XI2\<0\>\/XI2\<1\>\/XI2\<3\>\/XI2\<2\>\/RR1_pos WLSEL\<122\> ) \
 R_1X_LL w=1e-07 l=1e-07   res=0.149966
XXI2\<0\>\/XI2\<1\>\/XI2\<3\>\/XI2\<2\>\/RR0 (  \
 N_SEL1\<3\>_XI2\<0\>\/XI2\<1\>\/XI2\<3\>\/XI2\<2\>\/RR0_pos WLSEL\<121\> ) \
 R_1X_LL w=1e-07 l=1e-07   res=0.149966
XXI2\<0\>\/XI2\<1\>\/XI2\<3\>\/XI2\<2\>\/RI2 (  \
 N_SEL0\<2\>_XI2\<0\>\/XI2\<1\>\/XI2\<3\>\/XI2\<2\>\/RI2_pos WLSEL\<120\> ) \
 R_1X_LL w=1e-07 l=1e-07   res=0.149966
XXI2\<0\>\/XI2\<1\>\/XI2\<3\>\/XI2\<1\>\/RR2 (  \
 N_SEL3\<0\>_XI2\<0\>\/XI2\<1\>\/XI2\<3\>\/XI2\<1\>\/RR2_pos WLSEL\<119\> ) \
 R_1X_LL w=1e-07 l=1e-07   res=0.149966
XXI2\<0\>\/XI2\<1\>\/XI2\<3\>\/XI2\<1\>\/RR1 (  \
 N_SEL2\<1\>_XI2\<0\>\/XI2\<1\>\/XI2\<3\>\/XI2\<1\>\/RR1_pos WLSEL\<118\> ) \
 R_1X_LL w=1e-07 l=1e-07   res=0.149966
XXI2\<0\>\/XI2\<1\>\/XI2\<3\>\/XI2\<1\>\/RR0 (  \
 N_SEL1\<3\>_XI2\<0\>\/XI2\<1\>\/XI2\<3\>\/XI2\<1\>\/RR0_pos WLSEL\<117\> ) \
 R_1X_LL w=1e-07 l=1e-07   res=0.149966
XXI2\<0\>\/XI2\<1\>\/XI2\<3\>\/XI2\<1\>\/RI2 (  \
 N_SEL0\<1\>_XI2\<0\>\/XI2\<1\>\/XI2\<3\>\/XI2\<1\>\/RI2_pos WLSEL\<116\> ) \
 R_1X_LL w=1e-07 l=1e-07   res=0.149966
XXI2\<0\>\/XI2\<1\>\/XI2\<3\>\/XI2\<0\>\/RR2 (  \
 N_SEL3\<0\>_XI2\<0\>\/XI2\<1\>\/XI2\<3\>\/XI2\<0\>\/RR2_pos WLSEL\<115\> ) \
 R_1X_LL w=1e-07 l=1e-07   res=0.149966
XXI2\<0\>\/XI2\<1\>\/XI2\<3\>\/XI2\<0\>\/RR1 (  \
 N_SEL2\<1\>_XI2\<0\>\/XI2\<1\>\/XI2\<3\>\/XI2\<0\>\/RR1_pos WLSEL\<114\> ) \
 R_1X_LL w=1e-07 l=1e-07   res=0.149966
XXI2\<0\>\/XI2\<1\>\/XI2\<3\>\/XI2\<0\>\/RR0 (  \
 N_SEL1\<3\>_XI2\<0\>\/XI2\<1\>\/XI2\<3\>\/XI2\<0\>\/RR0_pos WLSEL\<113\> ) \
 R_1X_LL w=1e-07 l=1e-07   res=0.149966
XXI2\<0\>\/XI2\<1\>\/XI2\<3\>\/XI2\<0\>\/RI2 (  \
 N_SEL0\<0\>_XI2\<0\>\/XI2\<1\>\/XI2\<3\>\/XI2\<0\>\/RI2_pos WLSEL\<112\> ) \
 R_1X_LL w=1e-07 l=1e-07   res=0.149966
XXI2\<0\>\/XI2\<1\>\/XI2\<2\>\/XI2\<3\>\/RR2 (  \
 N_SEL3\<0\>_XI2\<0\>\/XI2\<1\>\/XI2\<2\>\/XI2\<3\>\/RR2_pos WLSEL\<111\> ) \
 R_1X_LL w=1e-07 l=1e-07   res=0.149966
XXI2\<0\>\/XI2\<1\>\/XI2\<2\>\/XI2\<3\>\/RR1 (  \
 N_SEL2\<1\>_XI2\<0\>\/XI2\<1\>\/XI2\<2\>\/XI2\<3\>\/RR1_pos WLSEL\<110\> ) \
 R_1X_LL w=1e-07 l=1e-07   res=0.149966
XXI2\<0\>\/XI2\<1\>\/XI2\<2\>\/XI2\<3\>\/RR0 (  \
 N_SEL1\<2\>_XI2\<0\>\/XI2\<1\>\/XI2\<2\>\/XI2\<3\>\/RR0_pos WLSEL\<109\> ) \
 R_1X_LL w=1e-07 l=1e-07   res=0.149966
XXI2\<0\>\/XI2\<1\>\/XI2\<2\>\/XI2\<3\>\/RI2 (  \
 N_SEL0\<3\>_XI2\<0\>\/XI2\<1\>\/XI2\<2\>\/XI2\<3\>\/RI2_pos WLSEL\<108\> ) \
 R_1X_LL w=1e-07 l=1e-07   res=0.149966
XXI2\<0\>\/XI2\<1\>\/XI2\<2\>\/XI2\<2\>\/RR2 (  \
 N_SEL3\<0\>_XI2\<0\>\/XI2\<1\>\/XI2\<2\>\/XI2\<2\>\/RR2_pos WLSEL\<107\> ) \
 R_1X_LL w=1e-07 l=1e-07   res=0.149966
XXI2\<0\>\/XI2\<1\>\/XI2\<2\>\/XI2\<2\>\/RR1 (  \
 N_SEL2\<1\>_XI2\<0\>\/XI2\<1\>\/XI2\<2\>\/XI2\<2\>\/RR1_pos WLSEL\<106\> ) \
 R_1X_LL w=1e-07 l=1e-07   res=0.149966
XXI2\<0\>\/XI2\<1\>\/XI2\<2\>\/XI2\<2\>\/RR0 (  \
 N_SEL1\<2\>_XI2\<0\>\/XI2\<1\>\/XI2\<2\>\/XI2\<2\>\/RR0_pos WLSEL\<105\> ) \
 R_1X_LL w=1e-07 l=1e-07   res=0.149966
XXI2\<0\>\/XI2\<1\>\/XI2\<2\>\/XI2\<2\>\/RI2 (  \
 N_SEL0\<2\>_XI2\<0\>\/XI2\<1\>\/XI2\<2\>\/XI2\<2\>\/RI2_pos WLSEL\<104\> ) \
 R_1X_LL w=1e-07 l=1e-07   res=0.149966
XXI2\<0\>\/XI2\<1\>\/XI2\<2\>\/XI2\<1\>\/RR2 (  \
 N_SEL3\<0\>_XI2\<0\>\/XI2\<1\>\/XI2\<2\>\/XI2\<1\>\/RR2_pos WLSEL\<103\> ) \
 R_1X_LL w=1e-07 l=1e-07   res=0.149966
XXI2\<0\>\/XI2\<1\>\/XI2\<2\>\/XI2\<1\>\/RR1 (  \
 N_SEL2\<1\>_XI2\<0\>\/XI2\<1\>\/XI2\<2\>\/XI2\<1\>\/RR1_pos WLSEL\<102\> ) \
 R_1X_LL w=1e-07 l=1e-07   res=0.149966
XXI2\<0\>\/XI2\<1\>\/XI2\<2\>\/XI2\<1\>\/RR0 (  \
 N_SEL1\<2\>_XI2\<0\>\/XI2\<1\>\/XI2\<2\>\/XI2\<1\>\/RR0_pos WLSEL\<101\> ) \
 R_1X_LL w=1e-07 l=1e-07   res=0.149966
XXI2\<0\>\/XI2\<1\>\/XI2\<2\>\/XI2\<1\>\/RI2 (  \
 N_SEL0\<1\>_XI2\<0\>\/XI2\<1\>\/XI2\<2\>\/XI2\<1\>\/RI2_pos WLSEL\<100\> ) \
 R_1X_LL w=1e-07 l=1e-07   res=0.149966
XXI2\<0\>\/XI2\<1\>\/XI2\<2\>\/XI2\<0\>\/RR2 (  \
 N_SEL3\<0\>_XI2\<0\>\/XI2\<1\>\/XI2\<2\>\/XI2\<0\>\/RR2_pos WLSEL\<99\> ) \
 R_1X_LL w=1e-07 l=1e-07   res=0.149966
XXI2\<0\>\/XI2\<1\>\/XI2\<2\>\/XI2\<0\>\/RR1 (  \
 N_SEL2\<1\>_XI2\<0\>\/XI2\<1\>\/XI2\<2\>\/XI2\<0\>\/RR1_pos WLSEL\<98\> ) \
 R_1X_LL w=1e-07 l=1e-07   res=0.149966
XXI2\<0\>\/XI2\<1\>\/XI2\<2\>\/XI2\<0\>\/RR0 (  \
 N_SEL1\<2\>_XI2\<0\>\/XI2\<1\>\/XI2\<2\>\/XI2\<0\>\/RR0_pos WLSEL\<97\> ) \
 R_1X_LL w=1e-07 l=1e-07   res=0.149966
XXI2\<0\>\/XI2\<1\>\/XI2\<2\>\/XI2\<0\>\/RI2 (  \
 N_SEL0\<0\>_XI2\<0\>\/XI2\<1\>\/XI2\<2\>\/XI2\<0\>\/RI2_pos WLSEL\<96\> ) \
 R_1X_LL w=1e-07 l=1e-07   res=0.149966
XXI2\<0\>\/XI2\<1\>\/XI2\<1\>\/XI2\<3\>\/RR2 (  \
 N_SEL3\<0\>_XI2\<0\>\/XI2\<1\>\/XI2\<1\>\/XI2\<3\>\/RR2_pos WLSEL\<95\> ) \
 R_1X_LL w=1e-07 l=1e-07   res=0.149966
XXI2\<0\>\/XI2\<1\>\/XI2\<1\>\/XI2\<3\>\/RR1 (  \
 N_SEL2\<1\>_XI2\<0\>\/XI2\<1\>\/XI2\<1\>\/XI2\<3\>\/RR1_pos WLSEL\<94\> ) \
 R_1X_LL w=1e-07 l=1e-07   res=0.149966
XXI2\<0\>\/XI2\<1\>\/XI2\<1\>\/XI2\<3\>\/RR0 (  \
 N_SEL1\<1\>_XI2\<0\>\/XI2\<1\>\/XI2\<1\>\/XI2\<3\>\/RR0_pos WLSEL\<93\> ) \
 R_1X_LL w=1e-07 l=1e-07   res=0.149966
XXI2\<0\>\/XI2\<1\>\/XI2\<1\>\/XI2\<3\>\/RI2 (  \
 N_SEL0\<3\>_XI2\<0\>\/XI2\<1\>\/XI2\<1\>\/XI2\<3\>\/RI2_pos WLSEL\<92\> ) \
 R_1X_LL w=1e-07 l=1e-07   res=0.149966
XXI2\<0\>\/XI2\<1\>\/XI2\<1\>\/XI2\<2\>\/RR2 (  \
 N_SEL3\<0\>_XI2\<0\>\/XI2\<1\>\/XI2\<1\>\/XI2\<2\>\/RR2_pos WLSEL\<91\> ) \
 R_1X_LL w=1e-07 l=1e-07   res=0.149966
XXI2\<0\>\/XI2\<1\>\/XI2\<1\>\/XI2\<2\>\/RR1 (  \
 N_SEL2\<1\>_XI2\<0\>\/XI2\<1\>\/XI2\<1\>\/XI2\<2\>\/RR1_pos WLSEL\<90\> ) \
 R_1X_LL w=1e-07 l=1e-07   res=0.149966
XXI2\<0\>\/XI2\<1\>\/XI2\<1\>\/XI2\<2\>\/RR0 (  \
 N_SEL1\<1\>_XI2\<0\>\/XI2\<1\>\/XI2\<1\>\/XI2\<2\>\/RR0_pos WLSEL\<89\> ) \
 R_1X_LL w=1e-07 l=1e-07   res=0.149966
XXI2\<0\>\/XI2\<1\>\/XI2\<1\>\/XI2\<2\>\/RI2 (  \
 N_SEL0\<2\>_XI2\<0\>\/XI2\<1\>\/XI2\<1\>\/XI2\<2\>\/RI2_pos WLSEL\<88\> ) \
 R_1X_LL w=1e-07 l=1e-07   res=0.149966
XXI2\<0\>\/XI2\<1\>\/XI2\<1\>\/XI2\<1\>\/RR2 (  \
 N_SEL3\<0\>_XI2\<0\>\/XI2\<1\>\/XI2\<1\>\/XI2\<1\>\/RR2_pos WLSEL\<87\> ) \
 R_1X_LL w=1e-07 l=1e-07   res=0.149966
XXI2\<0\>\/XI2\<1\>\/XI2\<1\>\/XI2\<1\>\/RR1 (  \
 N_SEL2\<1\>_XI2\<0\>\/XI2\<1\>\/XI2\<1\>\/XI2\<1\>\/RR1_pos WLSEL\<86\> ) \
 R_1X_LL w=1e-07 l=1e-07   res=0.149966
XXI2\<0\>\/XI2\<1\>\/XI2\<1\>\/XI2\<1\>\/RR0 (  \
 N_SEL1\<1\>_XI2\<0\>\/XI2\<1\>\/XI2\<1\>\/XI2\<1\>\/RR0_pos WLSEL\<85\> ) \
 R_1X_LL w=1e-07 l=1e-07   res=0.149966
XXI2\<0\>\/XI2\<1\>\/XI2\<1\>\/XI2\<1\>\/RI2 (  \
 N_SEL0\<1\>_XI2\<0\>\/XI2\<1\>\/XI2\<1\>\/XI2\<1\>\/RI2_pos WLSEL\<84\> ) \
 R_1X_LL w=1e-07 l=1e-07   res=0.149966
XXI2\<0\>\/XI2\<1\>\/XI2\<1\>\/XI2\<0\>\/RR2 (  \
 N_SEL3\<0\>_XI2\<0\>\/XI2\<1\>\/XI2\<1\>\/XI2\<0\>\/RR2_pos WLSEL\<83\> ) \
 R_1X_LL w=1e-07 l=1e-07   res=0.149966
XXI2\<0\>\/XI2\<1\>\/XI2\<1\>\/XI2\<0\>\/RR1 (  \
 N_SEL2\<1\>_XI2\<0\>\/XI2\<1\>\/XI2\<1\>\/XI2\<0\>\/RR1_pos WLSEL\<82\> ) \
 R_1X_LL w=1e-07 l=1e-07   res=0.149966
XXI2\<0\>\/XI2\<1\>\/XI2\<1\>\/XI2\<0\>\/RR0 (  \
 N_SEL1\<1\>_XI2\<0\>\/XI2\<1\>\/XI2\<1\>\/XI2\<0\>\/RR0_pos WLSEL\<81\> ) \
 R_1X_LL w=1e-07 l=1e-07   res=0.149966
XXI2\<0\>\/XI2\<1\>\/XI2\<1\>\/XI2\<0\>\/RI2 (  \
 N_SEL0\<0\>_XI2\<0\>\/XI2\<1\>\/XI2\<1\>\/XI2\<0\>\/RI2_pos WLSEL\<80\> ) \
 R_1X_LL w=1e-07 l=1e-07   res=0.149966
XXI2\<0\>\/XI2\<1\>\/XI2\<0\>\/XI2\<3\>\/RR2 (  \
 N_SEL3\<0\>_XI2\<0\>\/XI2\<1\>\/XI2\<0\>\/XI2\<3\>\/RR2_pos WLSEL\<79\> ) \
 R_1X_LL w=1e-07 l=1e-07   res=0.149966
XXI2\<0\>\/XI2\<1\>\/XI2\<0\>\/XI2\<3\>\/RR1 (  \
 N_SEL2\<1\>_XI2\<0\>\/XI2\<1\>\/XI2\<0\>\/XI2\<3\>\/RR1_pos WLSEL\<78\> ) \
 R_1X_LL w=1e-07 l=1e-07   res=0.149966
XXI2\<0\>\/XI2\<1\>\/XI2\<0\>\/XI2\<3\>\/RR0 (  \
 N_SEL1\<0\>_XI2\<0\>\/XI2\<1\>\/XI2\<0\>\/XI2\<3\>\/RR0_pos WLSEL\<77\> ) \
 R_1X_LL w=1e-07 l=1e-07   res=0.149966
XXI2\<0\>\/XI2\<1\>\/XI2\<0\>\/XI2\<3\>\/RI2 (  \
 N_SEL0\<3\>_XI2\<0\>\/XI2\<1\>\/XI2\<0\>\/XI2\<3\>\/RI2_pos WLSEL\<76\> ) \
 R_1X_LL w=1e-07 l=1e-07   res=0.149966
XXI2\<0\>\/XI2\<1\>\/XI2\<0\>\/XI2\<2\>\/RR2 (  \
 N_SEL3\<0\>_XI2\<0\>\/XI2\<1\>\/XI2\<0\>\/XI2\<2\>\/RR2_pos WLSEL\<75\> ) \
 R_1X_LL w=1e-07 l=1e-07   res=0.149966
XXI2\<0\>\/XI2\<1\>\/XI2\<0\>\/XI2\<2\>\/RR1 (  \
 N_SEL2\<1\>_XI2\<0\>\/XI2\<1\>\/XI2\<0\>\/XI2\<2\>\/RR1_pos WLSEL\<74\> ) \
 R_1X_LL w=1e-07 l=1e-07   res=0.149966
XXI2\<0\>\/XI2\<1\>\/XI2\<0\>\/XI2\<2\>\/RR0 (  \
 N_SEL1\<0\>_XI2\<0\>\/XI2\<1\>\/XI2\<0\>\/XI2\<2\>\/RR0_pos WLSEL\<73\> ) \
 R_1X_LL w=1e-07 l=1e-07   res=0.149966
XXI2\<0\>\/XI2\<1\>\/XI2\<0\>\/XI2\<2\>\/RI2 (  \
 N_SEL0\<2\>_XI2\<0\>\/XI2\<1\>\/XI2\<0\>\/XI2\<2\>\/RI2_pos WLSEL\<72\> ) \
 R_1X_LL w=1e-07 l=1e-07   res=0.149966
XXI2\<0\>\/XI2\<1\>\/XI2\<0\>\/XI2\<1\>\/RR2 (  \
 N_SEL3\<0\>_XI2\<0\>\/XI2\<1\>\/XI2\<0\>\/XI2\<1\>\/RR2_pos WLSEL\<71\> ) \
 R_1X_LL w=1e-07 l=1e-07   res=0.149966
XXI2\<0\>\/XI2\<1\>\/XI2\<0\>\/XI2\<1\>\/RR1 (  \
 N_SEL2\<1\>_XI2\<0\>\/XI2\<1\>\/XI2\<0\>\/XI2\<1\>\/RR1_pos WLSEL\<70\> ) \
 R_1X_LL w=1e-07 l=1e-07   res=0.149966
XXI2\<0\>\/XI2\<1\>\/XI2\<0\>\/XI2\<1\>\/RR0 (  \
 N_SEL1\<0\>_XI2\<0\>\/XI2\<1\>\/XI2\<0\>\/XI2\<1\>\/RR0_pos WLSEL\<69\> ) \
 R_1X_LL w=1e-07 l=1e-07   res=0.149966
XXI2\<0\>\/XI2\<1\>\/XI2\<0\>\/XI2\<1\>\/RI2 (  \
 N_SEL0\<1\>_XI2\<0\>\/XI2\<1\>\/XI2\<0\>\/XI2\<1\>\/RI2_pos WLSEL\<68\> ) \
 R_1X_LL w=1e-07 l=1e-07   res=0.149966
XXI2\<0\>\/XI2\<1\>\/XI2\<0\>\/XI2\<0\>\/RR2 (  \
 N_SEL3\<0\>_XI2\<0\>\/XI2\<1\>\/XI2\<0\>\/XI2\<0\>\/RR2_pos WLSEL\<67\> ) \
 R_1X_LL w=1e-07 l=1e-07   res=0.149966
XXI2\<0\>\/XI2\<1\>\/XI2\<0\>\/XI2\<0\>\/RR1 (  \
 N_SEL2\<1\>_XI2\<0\>\/XI2\<1\>\/XI2\<0\>\/XI2\<0\>\/RR1_pos WLSEL\<66\> ) \
 R_1X_LL w=1e-07 l=1e-07   res=0.149966
XXI2\<0\>\/XI2\<1\>\/XI2\<0\>\/XI2\<0\>\/RR0 (  \
 N_SEL1\<0\>_XI2\<0\>\/XI2\<1\>\/XI2\<0\>\/XI2\<0\>\/RR0_pos WLSEL\<65\> ) \
 R_1X_LL w=1e-07 l=1e-07   res=0.149966
XXI2\<0\>\/XI2\<1\>\/XI2\<0\>\/XI2\<0\>\/RI2 (  \
 N_SEL0\<0\>_XI2\<0\>\/XI2\<1\>\/XI2\<0\>\/XI2\<0\>\/RI2_pos WLSEL\<64\> ) \
 R_1X_LL w=1e-07 l=1e-07   res=0.149966
XXI2\<0\>\/XI2\<0\>\/XI2\<3\>\/XI2\<3\>\/RR2 (  \
 N_SEL3\<0\>_XI2\<0\>\/XI2\<0\>\/XI2\<3\>\/XI2\<3\>\/RR2_pos WLSEL\<63\> ) \
 R_1X_LL w=1e-07 l=1e-07   res=0.149966
XXI2\<0\>\/XI2\<0\>\/XI2\<3\>\/XI2\<3\>\/RR1 (  \
 N_SEL2\<0\>_XI2\<0\>\/XI2\<0\>\/XI2\<3\>\/XI2\<3\>\/RR1_pos WLSEL\<62\> ) \
 R_1X_LL w=1e-07 l=1e-07   res=0.149966
XXI2\<0\>\/XI2\<0\>\/XI2\<3\>\/XI2\<3\>\/RR0 (  \
 N_SEL1\<3\>_XI2\<0\>\/XI2\<0\>\/XI2\<3\>\/XI2\<3\>\/RR0_pos WLSEL\<61\> ) \
 R_1X_LL w=1e-07 l=1e-07   res=0.149966
XXI2\<0\>\/XI2\<0\>\/XI2\<3\>\/XI2\<3\>\/RI2 (  \
 N_SEL0\<3\>_XI2\<0\>\/XI2\<0\>\/XI2\<3\>\/XI2\<3\>\/RI2_pos WLSEL\<60\> ) \
 R_1X_LL w=1e-07 l=1e-07   res=0.149966
XXI2\<0\>\/XI2\<0\>\/XI2\<3\>\/XI2\<2\>\/RR2 (  \
 N_SEL3\<0\>_XI2\<0\>\/XI2\<0\>\/XI2\<3\>\/XI2\<2\>\/RR2_pos WLSEL\<59\> ) \
 R_1X_LL w=1e-07 l=1e-07   res=0.149966
XXI2\<0\>\/XI2\<0\>\/XI2\<3\>\/XI2\<2\>\/RR1 (  \
 N_SEL2\<0\>_XI2\<0\>\/XI2\<0\>\/XI2\<3\>\/XI2\<2\>\/RR1_pos WLSEL\<58\> ) \
 R_1X_LL w=1e-07 l=1e-07   res=0.149966
XXI2\<0\>\/XI2\<0\>\/XI2\<3\>\/XI2\<2\>\/RR0 (  \
 N_SEL1\<3\>_XI2\<0\>\/XI2\<0\>\/XI2\<3\>\/XI2\<2\>\/RR0_pos WLSEL\<57\> ) \
 R_1X_LL w=1e-07 l=1e-07   res=0.149966
XXI2\<0\>\/XI2\<0\>\/XI2\<3\>\/XI2\<2\>\/RI2 (  \
 N_SEL0\<2\>_XI2\<0\>\/XI2\<0\>\/XI2\<3\>\/XI2\<2\>\/RI2_pos WLSEL\<56\> ) \
 R_1X_LL w=1e-07 l=1e-07   res=0.149966
XXI2\<0\>\/XI2\<0\>\/XI2\<3\>\/XI2\<1\>\/RR2 (  \
 N_SEL3\<0\>_XI2\<0\>\/XI2\<0\>\/XI2\<3\>\/XI2\<1\>\/RR2_pos WLSEL\<55\> ) \
 R_1X_LL w=1e-07 l=1e-07   res=0.149966
XXI2\<0\>\/XI2\<0\>\/XI2\<3\>\/XI2\<1\>\/RR1 (  \
 N_SEL2\<0\>_XI2\<0\>\/XI2\<0\>\/XI2\<3\>\/XI2\<1\>\/RR1_pos WLSEL\<54\> ) \
 R_1X_LL w=1e-07 l=1e-07   res=0.149966
XXI2\<0\>\/XI2\<0\>\/XI2\<3\>\/XI2\<1\>\/RR0 (  \
 N_SEL1\<3\>_XI2\<0\>\/XI2\<0\>\/XI2\<3\>\/XI2\<1\>\/RR0_pos WLSEL\<53\> ) \
 R_1X_LL w=1e-07 l=1e-07   res=0.149966
XXI2\<0\>\/XI2\<0\>\/XI2\<3\>\/XI2\<1\>\/RI2 (  \
 N_SEL0\<1\>_XI2\<0\>\/XI2\<0\>\/XI2\<3\>\/XI2\<1\>\/RI2_pos WLSEL\<52\> ) \
 R_1X_LL w=1e-07 l=1e-07   res=0.149966
XXI2\<0\>\/XI2\<0\>\/XI2\<3\>\/XI2\<0\>\/RR2 (  \
 N_SEL3\<0\>_XI2\<0\>\/XI2\<0\>\/XI2\<3\>\/XI2\<0\>\/RR2_pos WLSEL\<51\> ) \
 R_1X_LL w=1e-07 l=1e-07   res=0.149966
XXI2\<0\>\/XI2\<0\>\/XI2\<3\>\/XI2\<0\>\/RR1 (  \
 N_SEL2\<0\>_XI2\<0\>\/XI2\<0\>\/XI2\<3\>\/XI2\<0\>\/RR1_pos WLSEL\<50\> ) \
 R_1X_LL w=1e-07 l=1e-07   res=0.149966
XXI2\<0\>\/XI2\<0\>\/XI2\<3\>\/XI2\<0\>\/RR0 (  \
 N_SEL1\<3\>_XI2\<0\>\/XI2\<0\>\/XI2\<3\>\/XI2\<0\>\/RR0_pos WLSEL\<49\> ) \
 R_1X_LL w=1e-07 l=1e-07   res=0.149966
XXI2\<0\>\/XI2\<0\>\/XI2\<3\>\/XI2\<0\>\/RI2 (  \
 N_SEL0\<0\>_XI2\<0\>\/XI2\<0\>\/XI2\<3\>\/XI2\<0\>\/RI2_pos WLSEL\<48\> ) \
 R_1X_LL w=1e-07 l=1e-07   res=0.149966
XXI2\<0\>\/XI2\<0\>\/XI2\<2\>\/XI2\<3\>\/RR2 (  \
 N_SEL3\<0\>_XI2\<0\>\/XI2\<0\>\/XI2\<2\>\/XI2\<3\>\/RR2_pos WLSEL\<47\> ) \
 R_1X_LL w=1e-07 l=1e-07   res=0.149966
XXI2\<0\>\/XI2\<0\>\/XI2\<2\>\/XI2\<3\>\/RR1 (  \
 N_SEL2\<0\>_XI2\<0\>\/XI2\<0\>\/XI2\<2\>\/XI2\<3\>\/RR1_pos WLSEL\<46\> ) \
 R_1X_LL w=1e-07 l=1e-07   res=0.149966
XXI2\<0\>\/XI2\<0\>\/XI2\<2\>\/XI2\<3\>\/RR0 (  \
 N_SEL1\<2\>_XI2\<0\>\/XI2\<0\>\/XI2\<2\>\/XI2\<3\>\/RR0_pos WLSEL\<45\> ) \
 R_1X_LL w=1e-07 l=1e-07   res=0.149966
XXI2\<0\>\/XI2\<0\>\/XI2\<2\>\/XI2\<3\>\/RI2 (  \
 N_SEL0\<3\>_XI2\<0\>\/XI2\<0\>\/XI2\<2\>\/XI2\<3\>\/RI2_pos WLSEL\<44\> ) \
 R_1X_LL w=1e-07 l=1e-07   res=0.149966
XXI2\<0\>\/XI2\<0\>\/XI2\<2\>\/XI2\<2\>\/RR2 (  \
 N_SEL3\<0\>_XI2\<0\>\/XI2\<0\>\/XI2\<2\>\/XI2\<2\>\/RR2_pos WLSEL\<43\> ) \
 R_1X_LL w=1e-07 l=1e-07   res=0.149966
XXI2\<0\>\/XI2\<0\>\/XI2\<2\>\/XI2\<2\>\/RR1 (  \
 N_SEL2\<0\>_XI2\<0\>\/XI2\<0\>\/XI2\<2\>\/XI2\<2\>\/RR1_pos WLSEL\<42\> ) \
 R_1X_LL w=1e-07 l=1e-07   res=0.149966
XXI2\<0\>\/XI2\<0\>\/XI2\<2\>\/XI2\<2\>\/RR0 (  \
 N_SEL1\<2\>_XI2\<0\>\/XI2\<0\>\/XI2\<2\>\/XI2\<2\>\/RR0_pos WLSEL\<41\> ) \
 R_1X_LL w=1e-07 l=1e-07   res=0.149966
XXI2\<0\>\/XI2\<0\>\/XI2\<2\>\/XI2\<2\>\/RI2 (  \
 N_SEL0\<2\>_XI2\<0\>\/XI2\<0\>\/XI2\<2\>\/XI2\<2\>\/RI2_pos WLSEL\<40\> ) \
 R_1X_LL w=1e-07 l=1e-07   res=0.149966
XXI2\<0\>\/XI2\<0\>\/XI2\<2\>\/XI2\<1\>\/RR2 (  \
 N_SEL3\<0\>_XI2\<0\>\/XI2\<0\>\/XI2\<2\>\/XI2\<1\>\/RR2_pos WLSEL\<39\> ) \
 R_1X_LL w=1e-07 l=1e-07   res=0.149966
XXI2\<0\>\/XI2\<0\>\/XI2\<2\>\/XI2\<1\>\/RR1 (  \
 N_SEL2\<0\>_XI2\<0\>\/XI2\<0\>\/XI2\<2\>\/XI2\<1\>\/RR1_pos WLSEL\<38\> ) \
 R_1X_LL w=1e-07 l=1e-07   res=0.149966
XXI2\<0\>\/XI2\<0\>\/XI2\<2\>\/XI2\<1\>\/RR0 (  \
 N_SEL1\<2\>_XI2\<0\>\/XI2\<0\>\/XI2\<2\>\/XI2\<1\>\/RR0_pos WLSEL\<37\> ) \
 R_1X_LL w=1e-07 l=1e-07   res=0.149966
XXI2\<0\>\/XI2\<0\>\/XI2\<2\>\/XI2\<1\>\/RI2 (  \
 N_SEL0\<1\>_XI2\<0\>\/XI2\<0\>\/XI2\<2\>\/XI2\<1\>\/RI2_pos WLSEL\<36\> ) \
 R_1X_LL w=1e-07 l=1e-07   res=0.149966
XXI2\<0\>\/XI2\<0\>\/XI2\<2\>\/XI2\<0\>\/RR2 (  \
 N_SEL3\<0\>_XI2\<0\>\/XI2\<0\>\/XI2\<2\>\/XI2\<0\>\/RR2_pos WLSEL\<35\> ) \
 R_1X_LL w=1e-07 l=1e-07   res=0.149966
XXI2\<0\>\/XI2\<0\>\/XI2\<2\>\/XI2\<0\>\/RR1 (  \
 N_SEL2\<0\>_XI2\<0\>\/XI2\<0\>\/XI2\<2\>\/XI2\<0\>\/RR1_pos WLSEL\<34\> ) \
 R_1X_LL w=1e-07 l=1e-07   res=0.149966
XXI2\<0\>\/XI2\<0\>\/XI2\<2\>\/XI2\<0\>\/RR0 (  \
 N_SEL1\<2\>_XI2\<0\>\/XI2\<0\>\/XI2\<2\>\/XI2\<0\>\/RR0_pos WLSEL\<33\> ) \
 R_1X_LL w=1e-07 l=1e-07   res=0.149966
XXI2\<0\>\/XI2\<0\>\/XI2\<2\>\/XI2\<0\>\/RI2 (  \
 N_SEL0\<0\>_XI2\<0\>\/XI2\<0\>\/XI2\<2\>\/XI2\<0\>\/RI2_pos WLSEL\<32\> ) \
 R_1X_LL w=1e-07 l=1e-07   res=0.149966
XXI2\<0\>\/XI2\<0\>\/XI2\<1\>\/XI2\<3\>\/RR2 (  \
 N_SEL3\<0\>_XI2\<0\>\/XI2\<0\>\/XI2\<1\>\/XI2\<3\>\/RR2_pos WLSEL\<31\> ) \
 R_1X_LL w=1e-07 l=1e-07   res=0.149966
XXI2\<0\>\/XI2\<0\>\/XI2\<1\>\/XI2\<3\>\/RR1 (  \
 N_SEL2\<0\>_XI2\<0\>\/XI2\<0\>\/XI2\<1\>\/XI2\<3\>\/RR1_pos WLSEL\<30\> ) \
 R_1X_LL w=1e-07 l=1e-07   res=0.149966
XXI2\<0\>\/XI2\<0\>\/XI2\<1\>\/XI2\<3\>\/RR0 (  \
 N_SEL1\<1\>_XI2\<0\>\/XI2\<0\>\/XI2\<1\>\/XI2\<3\>\/RR0_pos WLSEL\<29\> ) \
 R_1X_LL w=1e-07 l=1e-07   res=0.149966
XXI2\<0\>\/XI2\<0\>\/XI2\<1\>\/XI2\<3\>\/RI2 (  \
 N_SEL0\<3\>_XI2\<0\>\/XI2\<0\>\/XI2\<1\>\/XI2\<3\>\/RI2_pos WLSEL\<28\> ) \
 R_1X_LL w=1e-07 l=1e-07   res=0.149966
XXI2\<0\>\/XI2\<0\>\/XI2\<1\>\/XI2\<2\>\/RR2 (  \
 N_SEL3\<0\>_XI2\<0\>\/XI2\<0\>\/XI2\<1\>\/XI2\<2\>\/RR2_pos WLSEL\<27\> ) \
 R_1X_LL w=1e-07 l=1e-07   res=0.149966
XXI2\<0\>\/XI2\<0\>\/XI2\<1\>\/XI2\<2\>\/RR1 (  \
 N_SEL2\<0\>_XI2\<0\>\/XI2\<0\>\/XI2\<1\>\/XI2\<2\>\/RR1_pos WLSEL\<26\> ) \
 R_1X_LL w=1e-07 l=1e-07   res=0.149966
XXI2\<0\>\/XI2\<0\>\/XI2\<1\>\/XI2\<2\>\/RR0 (  \
 N_SEL1\<1\>_XI2\<0\>\/XI2\<0\>\/XI2\<1\>\/XI2\<2\>\/RR0_pos WLSEL\<25\> ) \
 R_1X_LL w=1e-07 l=1e-07   res=0.149966
XXI2\<0\>\/XI2\<0\>\/XI2\<1\>\/XI2\<2\>\/RI2 (  \
 N_SEL0\<2\>_XI2\<0\>\/XI2\<0\>\/XI2\<1\>\/XI2\<2\>\/RI2_pos WLSEL\<24\> ) \
 R_1X_LL w=1e-07 l=1e-07   res=0.149966
XXI2\<0\>\/XI2\<0\>\/XI2\<1\>\/XI2\<1\>\/RR2 (  \
 N_SEL3\<0\>_XI2\<0\>\/XI2\<0\>\/XI2\<1\>\/XI2\<1\>\/RR2_pos WLSEL\<23\> ) \
 R_1X_LL w=1e-07 l=1e-07   res=0.149966
XXI2\<0\>\/XI2\<0\>\/XI2\<1\>\/XI2\<1\>\/RR1 (  \
 N_SEL2\<0\>_XI2\<0\>\/XI2\<0\>\/XI2\<1\>\/XI2\<1\>\/RR1_pos WLSEL\<22\> ) \
 R_1X_LL w=1e-07 l=1e-07   res=0.149966
XXI2\<0\>\/XI2\<0\>\/XI2\<1\>\/XI2\<1\>\/RR0 (  \
 N_SEL1\<1\>_XI2\<0\>\/XI2\<0\>\/XI2\<1\>\/XI2\<1\>\/RR0_pos WLSEL\<21\> ) \
 R_1X_LL w=1e-07 l=1e-07   res=0.149966
XXI2\<0\>\/XI2\<0\>\/XI2\<1\>\/XI2\<1\>\/RI2 (  \
 N_SEL0\<1\>_XI2\<0\>\/XI2\<0\>\/XI2\<1\>\/XI2\<1\>\/RI2_pos WLSEL\<20\> ) \
 R_1X_LL w=1e-07 l=1e-07   res=0.149966
XXI2\<0\>\/XI2\<0\>\/XI2\<1\>\/XI2\<0\>\/RR2 (  \
 N_SEL3\<0\>_XI2\<0\>\/XI2\<0\>\/XI2\<1\>\/XI2\<0\>\/RR2_pos WLSEL\<19\> ) \
 R_1X_LL w=1e-07 l=1e-07   res=0.149966
XXI2\<0\>\/XI2\<0\>\/XI2\<1\>\/XI2\<0\>\/RR1 (  \
 N_SEL2\<0\>_XI2\<0\>\/XI2\<0\>\/XI2\<1\>\/XI2\<0\>\/RR1_pos WLSEL\<18\> ) \
 R_1X_LL w=1e-07 l=1e-07   res=0.149966
XXI2\<0\>\/XI2\<0\>\/XI2\<1\>\/XI2\<0\>\/RR0 (  \
 N_SEL1\<1\>_XI2\<0\>\/XI2\<0\>\/XI2\<1\>\/XI2\<0\>\/RR0_pos WLSEL\<17\> ) \
 R_1X_LL w=1e-07 l=1e-07   res=0.149966
XXI2\<0\>\/XI2\<0\>\/XI2\<1\>\/XI2\<0\>\/RI2 (  \
 N_SEL0\<0\>_XI2\<0\>\/XI2\<0\>\/XI2\<1\>\/XI2\<0\>\/RI2_pos WLSEL\<16\> ) \
 R_1X_LL w=1e-07 l=1e-07   res=0.149966
XXI2\<0\>\/XI2\<0\>\/XI2\<0\>\/XI2\<3\>\/RR2 (  \
 N_SEL3\<0\>_XI2\<0\>\/XI2\<0\>\/XI2\<0\>\/XI2\<3\>\/RR2_pos WLSEL\<15\> ) \
 R_1X_LL w=1e-07 l=1e-07   res=0.149966
XXI2\<0\>\/XI2\<0\>\/XI2\<0\>\/XI2\<3\>\/RR1 (  \
 N_SEL2\<0\>_XI2\<0\>\/XI2\<0\>\/XI2\<0\>\/XI2\<3\>\/RR1_pos WLSEL\<14\> ) \
 R_1X_LL w=1e-07 l=1e-07   res=0.149966
XXI2\<0\>\/XI2\<0\>\/XI2\<0\>\/XI2\<3\>\/RR0 (  \
 N_SEL1\<0\>_XI2\<0\>\/XI2\<0\>\/XI2\<0\>\/XI2\<3\>\/RR0_pos WLSEL\<13\> ) \
 R_1X_LL w=1e-07 l=1e-07   res=0.149966
XXI2\<0\>\/XI2\<0\>\/XI2\<0\>\/XI2\<3\>\/RI2 (  \
 N_SEL0\<3\>_XI2\<0\>\/XI2\<0\>\/XI2\<0\>\/XI2\<3\>\/RI2_pos WLSEL\<12\> ) \
 R_1X_LL w=1e-07 l=1e-07   res=0.149966
XXI2\<0\>\/XI2\<0\>\/XI2\<0\>\/XI2\<2\>\/RR2 (  \
 N_SEL3\<0\>_XI2\<0\>\/XI2\<0\>\/XI2\<0\>\/XI2\<2\>\/RR2_pos WLSEL\<11\> ) \
 R_1X_LL w=1e-07 l=1e-07   res=0.149966
XXI2\<0\>\/XI2\<0\>\/XI2\<0\>\/XI2\<2\>\/RR1 (  \
 N_SEL2\<0\>_XI2\<0\>\/XI2\<0\>\/XI2\<0\>\/XI2\<2\>\/RR1_pos WLSEL\<10\> ) \
 R_1X_LL w=1e-07 l=1e-07   res=0.149966
XXI2\<0\>\/XI2\<0\>\/XI2\<0\>\/XI2\<2\>\/RR0 (  \
 N_SEL1\<0\>_XI2\<0\>\/XI2\<0\>\/XI2\<0\>\/XI2\<2\>\/RR0_pos WLSEL\<9\> ) \
 R_1X_LL w=1e-07 l=1e-07   res=0.149966
XXI2\<0\>\/XI2\<0\>\/XI2\<0\>\/XI2\<2\>\/RI2 (  \
 N_SEL0\<2\>_XI2\<0\>\/XI2\<0\>\/XI2\<0\>\/XI2\<2\>\/RI2_pos WLSEL\<8\> ) \
 R_1X_LL w=1e-07 l=1e-07   res=0.149966
XXI2\<0\>\/XI2\<0\>\/XI2\<0\>\/XI2\<1\>\/RR2 (  \
 N_SEL3\<0\>_XI2\<0\>\/XI2\<0\>\/XI2\<0\>\/XI2\<1\>\/RR2_pos WLSEL\<7\> ) \
 R_1X_LL w=1e-07 l=1e-07   res=0.149966
XXI2\<0\>\/XI2\<0\>\/XI2\<0\>\/XI2\<1\>\/RR1 (  \
 N_SEL2\<0\>_XI2\<0\>\/XI2\<0\>\/XI2\<0\>\/XI2\<1\>\/RR1_pos WLSEL\<6\> ) \
 R_1X_LL w=1e-07 l=1e-07   res=0.149966
XXI2\<0\>\/XI2\<0\>\/XI2\<0\>\/XI2\<1\>\/RR0 (  \
 N_SEL1\<0\>_XI2\<0\>\/XI2\<0\>\/XI2\<0\>\/XI2\<1\>\/RR0_pos WLSEL\<5\> ) \
 R_1X_LL w=1e-07 l=1e-07   res=0.149966
XXI2\<0\>\/XI2\<0\>\/XI2\<0\>\/XI2\<1\>\/RI2 (  \
 N_SEL0\<1\>_XI2\<0\>\/XI2\<0\>\/XI2\<0\>\/XI2\<1\>\/RI2_pos WLSEL\<4\> ) \
 R_1X_LL w=1e-07 l=1e-07   res=0.149966
XXI2\<0\>\/XI2\<0\>\/XI2\<0\>\/XI2\<0\>\/RR2 (  \
 N_SEL3\<0\>_XI2\<0\>\/XI2\<0\>\/XI2\<0\>\/XI2\<0\>\/RR2_pos WLSEL\<3\> ) \
 R_1X_LL w=1e-07 l=1e-07   res=0.149966
XXI2\<0\>\/XI2\<0\>\/XI2\<0\>\/XI2\<0\>\/RR1 (  \
 N_SEL2\<0\>_XI2\<0\>\/XI2\<0\>\/XI2\<0\>\/XI2\<0\>\/RR1_pos WLSEL\<2\> ) \
 R_1X_LL w=1e-07 l=1e-07   res=0.149966
XXI2\<0\>\/XI2\<0\>\/XI2\<0\>\/XI2\<0\>\/RR0 (  \
 N_SEL1\<0\>_XI2\<0\>\/XI2\<0\>\/XI2\<0\>\/XI2\<0\>\/RR0_pos WLSEL\<1\> ) \
 R_1X_LL w=1e-07 l=1e-07   res=0.149966
XXI2\<0\>\/XI2\<0\>\/XI2\<0\>\/XI2\<0\>\/RI2 (  \
 N_SEL0\<0\>_XI2\<0\>\/XI2\<0\>\/XI2\<0\>\/XI2\<0\>\/RI2_pos WLSEL\<0\> ) \
 R_1X_LL w=1e-07 l=1e-07   res=0.149966
//
include "/home/edauser0/ayigit/RowDecoder_Project/CDS_VISIO/project_pex/Post_L4_256t4_Text/spectreText/spectre.scs.POST_L4_256T4_EX.pxi"
//
ends POST_L4_256T4_TEXT
//
//
