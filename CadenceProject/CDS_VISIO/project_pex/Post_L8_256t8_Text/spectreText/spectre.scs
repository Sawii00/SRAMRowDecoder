// File: /home/edauser0/ayigit/RowDecoder_Project/CDS_VISIO/project_pex/Post_L8_256t8_Text/spectreText/spectre.scs
// Created: Tue Dec 21 11:41:04 2021
// Program "Calibre xRC"
// Version "v2020.1_17.9"
//
simulator lang=spectre
include "/home/edauser0/ayigit/RowDecoder_Project/CDS_VISIO/project_pex/Post_L8_256t8_Text/spectreText/spectre.scs.pex"
subckt Post_L8_256t8_Text (  SEL7\<1\> SEL0\<0\> SEL1\<1\> SEL2\<1\> SEL3\<0\> \
 SEL4\<1\> SEL5\<1\> SEL6\<1\> SEL0\<1\> SEL1\<0\> SEL2\<0\> SEL3\<1\> \
 WLSEL\<1967\> WLSEL\<1968\> WLSEL\<1969\> WLSEL\<1970\> WLSEL\<1971\> \
 WLSEL\<1972\> WLSEL\<1973\> WLSEL\<1974\> WLSEL\<1975\> WLSEL\<1976\> \
 WLSEL\<1977\> WLSEL\<1978\> WLSEL\<1979\> WLSEL\<1980\> WLSEL\<1981\> \
 WLSEL\<1982\> WLSEL\<1983\> WLSEL\<1984\> WLSEL\<1985\> WLSEL\<1986\> \
 WLSEL\<1987\> WLSEL\<1988\> WLSEL\<1989\> WLSEL\<1990\> WLSEL\<1991\> \
 WLSEL\<1992\> WLSEL\<1993\> WLSEL\<1994\> WLSEL\<1995\> WLSEL\<1996\> \
 WLSEL\<1997\> WLSEL\<1998\> WLSEL\<1999\> WLSEL\<2000\> WLSEL\<2001\> \
 WLSEL\<2002\> WLSEL\<2003\> WLSEL\<2004\> WLSEL\<2005\> WLSEL\<2006\> \
 WLSEL\<2007\> WLSEL\<2008\> WLSEL\<2009\> WLSEL\<2010\> WLSEL\<2011\> \
 WLSEL\<2012\> WLSEL\<2013\> WLSEL\<2014\> WLSEL\<2015\> WLSEL\<2016\> \
 WLSEL\<2017\> WLSEL\<2018\> WLSEL\<2019\> WLSEL\<2020\> WLSEL\<2021\> \
 WLSEL\<2022\> WLSEL\<2023\> WLSEL\<2024\> WLSEL\<2025\> WLSEL\<2026\> \
 WLSEL\<2027\> WLSEL\<2028\> WLSEL\<2029\> WLSEL\<2030\> WLSEL\<2031\> \
 WLSEL\<2032\> WLSEL\<2033\> WLSEL\<2034\> WLSEL\<2035\> WLSEL\<2036\> \
 WLSEL\<2037\> WLSEL\<2038\> WLSEL\<2039\> WLSEL\<2040\> WLSEL\<2041\> \
 WLSEL\<2042\> WLSEL\<2043\> WLSEL\<2044\> WLSEL\<2045\> WLSEL\<2046\> \
 WLSEL\<2047\> SEL6\<0\> WLSEL\<1455\> WLSEL\<1456\> WLSEL\<1457\> \
 WLSEL\<1458\> WLSEL\<1459\> WLSEL\<1460\> WLSEL\<1461\> WLSEL\<1462\> \
 WLSEL\<1463\> WLSEL\<1464\> WLSEL\<1465\> WLSEL\<1466\> WLSEL\<1467\> \
 WLSEL\<1468\> WLSEL\<1469\> WLSEL\<1470\> WLSEL\<1471\> WLSEL\<1472\> \
 WLSEL\<1473\> WLSEL\<1474\> WLSEL\<1475\> WLSEL\<1476\> WLSEL\<1477\> \
 WLSEL\<1478\> WLSEL\<1479\> WLSEL\<1480\> WLSEL\<1481\> WLSEL\<1482\> \
 WLSEL\<1483\> WLSEL\<1484\> WLSEL\<1485\> WLSEL\<1486\> WLSEL\<1487\> \
 WLSEL\<1488\> WLSEL\<1489\> WLSEL\<1490\> WLSEL\<1491\> WLSEL\<1492\> \
 WLSEL\<1493\> WLSEL\<1494\> WLSEL\<1495\> WLSEL\<1496\> WLSEL\<1497\> \
 WLSEL\<1498\> WLSEL\<1499\> WLSEL\<1500\> WLSEL\<1501\> WLSEL\<1502\> \
 WLSEL\<1503\> WLSEL\<1504\> WLSEL\<1505\> WLSEL\<1506\> WLSEL\<1507\> \
 WLSEL\<1508\> WLSEL\<1509\> WLSEL\<1510\> WLSEL\<1511\> WLSEL\<1512\> \
 WLSEL\<1513\> WLSEL\<1514\> WLSEL\<1515\> WLSEL\<1516\> WLSEL\<1517\> \
 WLSEL\<1518\> WLSEL\<1519\> WLSEL\<1520\> WLSEL\<1521\> WLSEL\<1522\> \
 WLSEL\<1523\> WLSEL\<1524\> WLSEL\<1525\> WLSEL\<1526\> WLSEL\<1527\> \
 WLSEL\<1528\> WLSEL\<1529\> WLSEL\<1530\> WLSEL\<1531\> WLSEL\<1532\> \
 WLSEL\<1533\> WLSEL\<1534\> WLSEL\<1535\> SEL7\<0\> WLSEL\<943\> WLSEL\<944\> \
 WLSEL\<945\> WLSEL\<946\> WLSEL\<947\> WLSEL\<948\> WLSEL\<949\> WLSEL\<950\> \
 WLSEL\<951\> WLSEL\<952\> WLSEL\<953\> WLSEL\<954\> WLSEL\<955\> WLSEL\<956\> \
 WLSEL\<957\> WLSEL\<958\> WLSEL\<959\> WLSEL\<960\> WLSEL\<961\> WLSEL\<962\> \
 WLSEL\<963\> WLSEL\<964\> WLSEL\<965\> WLSEL\<966\> WLSEL\<967\> WLSEL\<968\> \
 WLSEL\<969\> WLSEL\<970\> WLSEL\<971\> WLSEL\<972\> WLSEL\<973\> WLSEL\<974\> \
 WLSEL\<975\> WLSEL\<976\> WLSEL\<977\> WLSEL\<978\> WLSEL\<979\> WLSEL\<980\> \
 WLSEL\<981\> WLSEL\<982\> WLSEL\<983\> WLSEL\<984\> WLSEL\<985\> WLSEL\<986\> \
 WLSEL\<987\> WLSEL\<988\> WLSEL\<989\> WLSEL\<990\> WLSEL\<991\> WLSEL\<992\> \
 WLSEL\<993\> WLSEL\<994\> WLSEL\<995\> WLSEL\<996\> WLSEL\<997\> WLSEL\<998\> \
 WLSEL\<999\> WLSEL\<1000\> WLSEL\<1001\> WLSEL\<1002\> WLSEL\<1003\> \
 WLSEL\<1004\> WLSEL\<1005\> WLSEL\<1006\> WLSEL\<1007\> WLSEL\<1008\> \
 WLSEL\<1009\> WLSEL\<1010\> WLSEL\<1011\> WLSEL\<1012\> WLSEL\<1013\> \
 WLSEL\<1014\> WLSEL\<1015\> WLSEL\<1016\> WLSEL\<1017\> WLSEL\<1018\> \
 WLSEL\<1019\> WLSEL\<1020\> WLSEL\<1021\> WLSEL\<1022\> WLSEL\<1023\> \
 WLSEL\<431\> WLSEL\<432\> WLSEL\<433\> WLSEL\<434\> WLSEL\<435\> WLSEL\<436\> \
 WLSEL\<437\> WLSEL\<438\> WLSEL\<439\> WLSEL\<440\> WLSEL\<441\> WLSEL\<442\> \
 WLSEL\<443\> WLSEL\<444\> WLSEL\<445\> WLSEL\<446\> WLSEL\<447\> WLSEL\<448\> \
 WLSEL\<449\> WLSEL\<450\> WLSEL\<451\> WLSEL\<452\> WLSEL\<453\> WLSEL\<454\> \
 WLSEL\<455\> WLSEL\<456\> WLSEL\<457\> WLSEL\<458\> WLSEL\<459\> WLSEL\<460\> \
 WLSEL\<461\> WLSEL\<462\> WLSEL\<463\> WLSEL\<464\> WLSEL\<465\> WLSEL\<466\> \
 WLSEL\<467\> WLSEL\<468\> WLSEL\<469\> WLSEL\<470\> WLSEL\<471\> WLSEL\<472\> \
 WLSEL\<473\> WLSEL\<474\> WLSEL\<475\> WLSEL\<476\> WLSEL\<477\> WLSEL\<478\> \
 WLSEL\<479\> WLSEL\<480\> WLSEL\<481\> WLSEL\<482\> WLSEL\<483\> WLSEL\<484\> \
 WLSEL\<485\> WLSEL\<486\> WLSEL\<487\> WLSEL\<488\> WLSEL\<489\> WLSEL\<490\> \
 WLSEL\<491\> WLSEL\<492\> WLSEL\<493\> WLSEL\<494\> WLSEL\<495\> WLSEL\<496\> \
 WLSEL\<497\> WLSEL\<498\> WLSEL\<499\> WLSEL\<500\> WLSEL\<501\> WLSEL\<502\> \
 WLSEL\<503\> WLSEL\<504\> WLSEL\<505\> WLSEL\<506\> WLSEL\<507\> WLSEL\<508\> \
 WLSEL\<509\> WLSEL\<510\> WLSEL\<511\> SEL4\<0\> WLSEL\<1887\> WLSEL\<1888\> \
 WLSEL\<1889\> WLSEL\<1890\> WLSEL\<1891\> WLSEL\<1892\> WLSEL\<1893\> \
 WLSEL\<1894\> WLSEL\<1895\> WLSEL\<1896\> WLSEL\<1897\> WLSEL\<1898\> \
 WLSEL\<1899\> WLSEL\<1900\> WLSEL\<1901\> WLSEL\<1902\> WLSEL\<1903\> \
 WLSEL\<1904\> WLSEL\<1905\> WLSEL\<1906\> WLSEL\<1907\> WLSEL\<1908\> \
 WLSEL\<1909\> WLSEL\<1910\> WLSEL\<1911\> WLSEL\<1912\> WLSEL\<1913\> \
 WLSEL\<1914\> WLSEL\<1915\> WLSEL\<1916\> WLSEL\<1917\> WLSEL\<1918\> \
 WLSEL\<1919\> WLSEL\<1920\> WLSEL\<1921\> WLSEL\<1922\> WLSEL\<1923\> \
 WLSEL\<1924\> WLSEL\<1925\> WLSEL\<1926\> WLSEL\<1927\> WLSEL\<1928\> \
 WLSEL\<1929\> WLSEL\<1930\> WLSEL\<1931\> WLSEL\<1932\> WLSEL\<1933\> \
 WLSEL\<1934\> WLSEL\<1935\> WLSEL\<1936\> WLSEL\<1937\> WLSEL\<1938\> \
 WLSEL\<1939\> WLSEL\<1940\> WLSEL\<1941\> WLSEL\<1942\> WLSEL\<1943\> \
 WLSEL\<1944\> WLSEL\<1945\> WLSEL\<1946\> WLSEL\<1947\> WLSEL\<1948\> \
 WLSEL\<1949\> WLSEL\<1950\> WLSEL\<1951\> WLSEL\<1952\> WLSEL\<1953\> \
 WLSEL\<1954\> WLSEL\<1955\> WLSEL\<1956\> WLSEL\<1957\> WLSEL\<1958\> \
 WLSEL\<1959\> WLSEL\<1960\> WLSEL\<1961\> WLSEL\<1962\> WLSEL\<1963\> \
 WLSEL\<1964\> WLSEL\<1965\> WLSEL\<1966\> WLSEL\<1375\> WLSEL\<1376\> \
 WLSEL\<1377\> WLSEL\<1378\> WLSEL\<1379\> WLSEL\<1380\> WLSEL\<1381\> \
 WLSEL\<1382\> WLSEL\<1383\> WLSEL\<1384\> WLSEL\<1385\> WLSEL\<1386\> \
 WLSEL\<1387\> WLSEL\<1388\> WLSEL\<1389\> WLSEL\<1390\> WLSEL\<1391\> \
 WLSEL\<1392\> WLSEL\<1393\> WLSEL\<1394\> WLSEL\<1395\> WLSEL\<1396\> \
 WLSEL\<1397\> WLSEL\<1398\> WLSEL\<1399\> WLSEL\<1400\> WLSEL\<1401\> \
 WLSEL\<1402\> WLSEL\<1403\> WLSEL\<1404\> WLSEL\<1405\> WLSEL\<1406\> \
 WLSEL\<1407\> WLSEL\<1408\> WLSEL\<1409\> WLSEL\<1410\> WLSEL\<1411\> \
 WLSEL\<1412\> WLSEL\<1413\> WLSEL\<1414\> WLSEL\<1415\> WLSEL\<1416\> \
 WLSEL\<1417\> WLSEL\<1418\> WLSEL\<1419\> WLSEL\<1420\> WLSEL\<1421\> \
 WLSEL\<1422\> WLSEL\<1423\> WLSEL\<1424\> WLSEL\<1425\> WLSEL\<1426\> \
 WLSEL\<1427\> WLSEL\<1428\> WLSEL\<1429\> WLSEL\<1430\> WLSEL\<1431\> \
 WLSEL\<1432\> WLSEL\<1433\> WLSEL\<1434\> WLSEL\<1435\> WLSEL\<1436\> \
 WLSEL\<1437\> WLSEL\<1438\> WLSEL\<1439\> WLSEL\<1440\> WLSEL\<1441\> \
 WLSEL\<1442\> WLSEL\<1443\> WLSEL\<1444\> WLSEL\<1445\> WLSEL\<1446\> \
 WLSEL\<1447\> WLSEL\<1448\> WLSEL\<1449\> WLSEL\<1450\> WLSEL\<1451\> \
 WLSEL\<1452\> WLSEL\<1453\> WLSEL\<1454\> WLSEL\<863\> WLSEL\<864\> \
 WLSEL\<865\> WLSEL\<866\> WLSEL\<867\> WLSEL\<868\> WLSEL\<869\> WLSEL\<870\> \
 WLSEL\<871\> WLSEL\<872\> WLSEL\<873\> WLSEL\<874\> WLSEL\<875\> WLSEL\<876\> \
 WLSEL\<877\> WLSEL\<878\> WLSEL\<879\> WLSEL\<880\> WLSEL\<881\> WLSEL\<882\> \
 WLSEL\<883\> WLSEL\<884\> WLSEL\<885\> WLSEL\<886\> WLSEL\<887\> WLSEL\<888\> \
 WLSEL\<889\> WLSEL\<890\> WLSEL\<891\> WLSEL\<892\> WLSEL\<893\> WLSEL\<894\> \
 WLSEL\<895\> WLSEL\<896\> WLSEL\<897\> WLSEL\<898\> WLSEL\<899\> WLSEL\<900\> \
 WLSEL\<901\> WLSEL\<902\> WLSEL\<903\> WLSEL\<904\> WLSEL\<905\> WLSEL\<906\> \
 WLSEL\<907\> WLSEL\<908\> WLSEL\<909\> WLSEL\<910\> WLSEL\<911\> WLSEL\<912\> \
 WLSEL\<913\> WLSEL\<914\> WLSEL\<915\> WLSEL\<916\> WLSEL\<917\> WLSEL\<918\> \
 WLSEL\<919\> WLSEL\<920\> WLSEL\<921\> WLSEL\<922\> WLSEL\<923\> WLSEL\<924\> \
 WLSEL\<925\> WLSEL\<926\> WLSEL\<927\> WLSEL\<928\> WLSEL\<929\> WLSEL\<930\> \
 WLSEL\<931\> WLSEL\<932\> WLSEL\<933\> WLSEL\<934\> WLSEL\<935\> WLSEL\<936\> \
 WLSEL\<937\> WLSEL\<938\> WLSEL\<939\> WLSEL\<940\> WLSEL\<941\> WLSEL\<942\> \
 WLSEL\<351\> WLSEL\<352\> WLSEL\<353\> WLSEL\<354\> WLSEL\<355\> WLSEL\<356\> \
 WLSEL\<357\> WLSEL\<358\> WLSEL\<359\> WLSEL\<360\> WLSEL\<361\> WLSEL\<362\> \
 WLSEL\<363\> WLSEL\<364\> WLSEL\<365\> WLSEL\<366\> WLSEL\<367\> WLSEL\<368\> \
 WLSEL\<369\> WLSEL\<370\> WLSEL\<371\> WLSEL\<372\> WLSEL\<373\> WLSEL\<374\> \
 WLSEL\<375\> WLSEL\<376\> WLSEL\<377\> WLSEL\<378\> WLSEL\<379\> WLSEL\<380\> \
 WLSEL\<381\> WLSEL\<382\> WLSEL\<383\> WLSEL\<384\> WLSEL\<385\> WLSEL\<386\> \
 WLSEL\<387\> WLSEL\<388\> WLSEL\<389\> WLSEL\<390\> WLSEL\<391\> WLSEL\<392\> \
 WLSEL\<393\> WLSEL\<394\> WLSEL\<395\> WLSEL\<396\> WLSEL\<397\> WLSEL\<398\> \
 WLSEL\<399\> WLSEL\<400\> WLSEL\<401\> WLSEL\<402\> WLSEL\<403\> WLSEL\<404\> \
 WLSEL\<405\> WLSEL\<406\> WLSEL\<407\> WLSEL\<408\> WLSEL\<409\> WLSEL\<410\> \
 WLSEL\<411\> WLSEL\<412\> WLSEL\<413\> WLSEL\<414\> WLSEL\<415\> WLSEL\<416\> \
 WLSEL\<417\> WLSEL\<418\> WLSEL\<419\> WLSEL\<420\> WLSEL\<421\> WLSEL\<422\> \
 WLSEL\<423\> WLSEL\<424\> WLSEL\<425\> WLSEL\<426\> WLSEL\<427\> WLSEL\<428\> \
 WLSEL\<429\> WLSEL\<430\> WLSEL\<1806\> WLSEL\<1807\> WLSEL\<1808\> \
 WLSEL\<1809\> WLSEL\<1810\> WLSEL\<1811\> WLSEL\<1812\> WLSEL\<1813\> \
 WLSEL\<1814\> WLSEL\<1815\> WLSEL\<1816\> WLSEL\<1817\> WLSEL\<1818\> \
 WLSEL\<1819\> WLSEL\<1820\> WLSEL\<1821\> WLSEL\<1822\> WLSEL\<1823\> \
 WLSEL\<1824\> WLSEL\<1825\> WLSEL\<1826\> WLSEL\<1827\> WLSEL\<1828\> \
 WLSEL\<1829\> WLSEL\<1830\> WLSEL\<1831\> WLSEL\<1832\> WLSEL\<1833\> \
 WLSEL\<1834\> WLSEL\<1835\> WLSEL\<1836\> WLSEL\<1837\> WLSEL\<1838\> \
 WLSEL\<1839\> WLSEL\<1840\> WLSEL\<1841\> WLSEL\<1842\> WLSEL\<1843\> \
 WLSEL\<1844\> WLSEL\<1845\> WLSEL\<1846\> WLSEL\<1847\> WLSEL\<1848\> \
 WLSEL\<1849\> WLSEL\<1850\> WLSEL\<1851\> WLSEL\<1852\> WLSEL\<1853\> \
 WLSEL\<1854\> WLSEL\<1855\> WLSEL\<1856\> WLSEL\<1857\> WLSEL\<1858\> \
 WLSEL\<1859\> WLSEL\<1860\> WLSEL\<1861\> WLSEL\<1862\> WLSEL\<1863\> \
 WLSEL\<1864\> WLSEL\<1865\> WLSEL\<1866\> WLSEL\<1867\> WLSEL\<1868\> \
 WLSEL\<1869\> WLSEL\<1870\> WLSEL\<1871\> WLSEL\<1872\> WLSEL\<1873\> \
 WLSEL\<1874\> WLSEL\<1875\> WLSEL\<1876\> WLSEL\<1877\> WLSEL\<1878\> \
 WLSEL\<1879\> WLSEL\<1880\> WLSEL\<1881\> WLSEL\<1882\> WLSEL\<1883\> \
 WLSEL\<1884\> WLSEL\<1885\> WLSEL\<1886\> WLSEL\<1294\> WLSEL\<1295\> \
 WLSEL\<1296\> WLSEL\<1297\> WLSEL\<1298\> WLSEL\<1299\> WLSEL\<1300\> \
 WLSEL\<1301\> WLSEL\<1302\> WLSEL\<1303\> WLSEL\<1304\> WLSEL\<1305\> \
 WLSEL\<1306\> WLSEL\<1307\> WLSEL\<1308\> WLSEL\<1309\> WLSEL\<1310\> \
 WLSEL\<1311\> WLSEL\<1312\> WLSEL\<1313\> WLSEL\<1314\> WLSEL\<1315\> \
 WLSEL\<1316\> WLSEL\<1317\> WLSEL\<1318\> WLSEL\<1319\> WLSEL\<1320\> \
 WLSEL\<1321\> WLSEL\<1322\> WLSEL\<1323\> WLSEL\<1324\> WLSEL\<1325\> \
 WLSEL\<1326\> WLSEL\<1327\> WLSEL\<1328\> WLSEL\<1329\> WLSEL\<1330\> \
 WLSEL\<1331\> WLSEL\<1332\> WLSEL\<1333\> WLSEL\<1334\> WLSEL\<1335\> \
 WLSEL\<1336\> WLSEL\<1337\> WLSEL\<1338\> WLSEL\<1339\> WLSEL\<1340\> \
 WLSEL\<1341\> WLSEL\<1342\> WLSEL\<1343\> WLSEL\<1344\> WLSEL\<1345\> \
 WLSEL\<1346\> WLSEL\<1347\> WLSEL\<1348\> WLSEL\<1349\> WLSEL\<1350\> \
 WLSEL\<1351\> WLSEL\<1352\> WLSEL\<1353\> WLSEL\<1354\> WLSEL\<1355\> \
 WLSEL\<1356\> WLSEL\<1357\> WLSEL\<1358\> WLSEL\<1359\> WLSEL\<1360\> \
 WLSEL\<1361\> WLSEL\<1362\> WLSEL\<1363\> WLSEL\<1364\> WLSEL\<1365\> \
 WLSEL\<1366\> WLSEL\<1367\> WLSEL\<1368\> WLSEL\<1369\> WLSEL\<1370\> \
 WLSEL\<1371\> WLSEL\<1372\> WLSEL\<1373\> WLSEL\<1374\> WLSEL\<782\> \
 WLSEL\<783\> WLSEL\<784\> WLSEL\<785\> WLSEL\<786\> WLSEL\<787\> WLSEL\<788\> \
 WLSEL\<789\> WLSEL\<790\> WLSEL\<791\> WLSEL\<792\> WLSEL\<793\> WLSEL\<794\> \
 WLSEL\<795\> WLSEL\<796\> WLSEL\<797\> WLSEL\<798\> WLSEL\<799\> WLSEL\<800\> \
 WLSEL\<801\> WLSEL\<802\> WLSEL\<803\> WLSEL\<804\> WLSEL\<805\> WLSEL\<806\> \
 WLSEL\<807\> WLSEL\<808\> WLSEL\<809\> WLSEL\<810\> WLSEL\<811\> WLSEL\<812\> \
 WLSEL\<813\> WLSEL\<814\> WLSEL\<815\> WLSEL\<816\> WLSEL\<817\> WLSEL\<818\> \
 WLSEL\<819\> WLSEL\<820\> WLSEL\<821\> WLSEL\<822\> WLSEL\<823\> WLSEL\<824\> \
 WLSEL\<825\> WLSEL\<826\> WLSEL\<827\> WLSEL\<828\> WLSEL\<829\> WLSEL\<830\> \
 WLSEL\<831\> WLSEL\<832\> WLSEL\<833\> WLSEL\<834\> WLSEL\<835\> WLSEL\<836\> \
 WLSEL\<837\> WLSEL\<838\> WLSEL\<839\> WLSEL\<840\> WLSEL\<841\> WLSEL\<842\> \
 WLSEL\<843\> WLSEL\<844\> WLSEL\<845\> WLSEL\<846\> WLSEL\<847\> WLSEL\<848\> \
 WLSEL\<849\> WLSEL\<850\> WLSEL\<851\> WLSEL\<852\> WLSEL\<853\> WLSEL\<854\> \
 WLSEL\<855\> WLSEL\<856\> WLSEL\<857\> WLSEL\<858\> WLSEL\<859\> WLSEL\<860\> \
 WLSEL\<861\> WLSEL\<862\> WLSEL\<270\> WLSEL\<271\> WLSEL\<272\> WLSEL\<273\> \
 WLSEL\<274\> WLSEL\<275\> WLSEL\<276\> WLSEL\<277\> WLSEL\<278\> WLSEL\<279\> \
 WLSEL\<280\> WLSEL\<281\> WLSEL\<282\> WLSEL\<283\> WLSEL\<284\> WLSEL\<285\> \
 WLSEL\<286\> WLSEL\<287\> WLSEL\<288\> WLSEL\<289\> WLSEL\<290\> WLSEL\<291\> \
 WLSEL\<292\> WLSEL\<293\> WLSEL\<294\> WLSEL\<295\> WLSEL\<296\> WLSEL\<297\> \
 WLSEL\<298\> WLSEL\<299\> WLSEL\<300\> WLSEL\<301\> WLSEL\<302\> WLSEL\<303\> \
 WLSEL\<304\> WLSEL\<305\> WLSEL\<306\> WLSEL\<307\> WLSEL\<308\> WLSEL\<309\> \
 WLSEL\<310\> WLSEL\<311\> WLSEL\<312\> WLSEL\<313\> WLSEL\<314\> WLSEL\<315\> \
 WLSEL\<316\> WLSEL\<317\> WLSEL\<318\> WLSEL\<319\> WLSEL\<320\> WLSEL\<321\> \
 WLSEL\<322\> WLSEL\<323\> WLSEL\<324\> WLSEL\<325\> WLSEL\<326\> WLSEL\<327\> \
 WLSEL\<328\> WLSEL\<329\> WLSEL\<330\> WLSEL\<331\> WLSEL\<332\> WLSEL\<333\> \
 WLSEL\<334\> WLSEL\<335\> WLSEL\<336\> WLSEL\<337\> WLSEL\<338\> WLSEL\<339\> \
 WLSEL\<340\> WLSEL\<341\> WLSEL\<342\> WLSEL\<343\> WLSEL\<344\> WLSEL\<345\> \
 WLSEL\<346\> WLSEL\<347\> WLSEL\<348\> WLSEL\<349\> WLSEL\<350\> SEL5\<0\> \
 WLSEL\<1726\> WLSEL\<1727\> WLSEL\<1728\> WLSEL\<1729\> WLSEL\<1730\> \
 WLSEL\<1731\> WLSEL\<1732\> WLSEL\<1733\> WLSEL\<1734\> WLSEL\<1735\> \
 WLSEL\<1736\> WLSEL\<1737\> WLSEL\<1738\> WLSEL\<1739\> WLSEL\<1740\> \
 WLSEL\<1741\> WLSEL\<1742\> WLSEL\<1743\> WLSEL\<1744\> WLSEL\<1745\> \
 WLSEL\<1746\> WLSEL\<1747\> WLSEL\<1748\> WLSEL\<1749\> WLSEL\<1750\> \
 WLSEL\<1751\> WLSEL\<1752\> WLSEL\<1753\> WLSEL\<1754\> WLSEL\<1755\> \
 WLSEL\<1756\> WLSEL\<1757\> WLSEL\<1758\> WLSEL\<1759\> WLSEL\<1760\> \
 WLSEL\<1761\> WLSEL\<1762\> WLSEL\<1763\> WLSEL\<1764\> WLSEL\<1765\> \
 WLSEL\<1766\> WLSEL\<1767\> WLSEL\<1768\> WLSEL\<1769\> WLSEL\<1770\> \
 WLSEL\<1771\> WLSEL\<1772\> WLSEL\<1773\> WLSEL\<1774\> WLSEL\<1775\> \
 WLSEL\<1776\> WLSEL\<1777\> WLSEL\<1778\> WLSEL\<1779\> WLSEL\<1780\> \
 WLSEL\<1781\> WLSEL\<1782\> WLSEL\<1783\> WLSEL\<1784\> WLSEL\<1785\> \
 WLSEL\<1786\> WLSEL\<1787\> WLSEL\<1788\> WLSEL\<1789\> WLSEL\<1790\> \
 WLSEL\<1791\> WLSEL\<1792\> WLSEL\<1793\> WLSEL\<1794\> WLSEL\<1795\> \
 WLSEL\<1796\> WLSEL\<1797\> WLSEL\<1798\> WLSEL\<1799\> WLSEL\<1800\> \
 WLSEL\<1801\> WLSEL\<1802\> WLSEL\<1803\> WLSEL\<1804\> WLSEL\<1805\> \
 WLSEL\<1214\> WLSEL\<1215\> WLSEL\<1216\> WLSEL\<1217\> WLSEL\<1218\> \
 WLSEL\<1219\> WLSEL\<1220\> WLSEL\<1221\> WLSEL\<1222\> WLSEL\<1223\> \
 WLSEL\<1224\> WLSEL\<1225\> WLSEL\<1226\> WLSEL\<1227\> WLSEL\<1228\> \
 WLSEL\<1229\> WLSEL\<1230\> WLSEL\<1231\> WLSEL\<1232\> WLSEL\<1233\> \
 WLSEL\<1234\> WLSEL\<1235\> WLSEL\<1236\> WLSEL\<1237\> WLSEL\<1238\> \
 WLSEL\<1239\> WLSEL\<1240\> WLSEL\<1241\> WLSEL\<1242\> WLSEL\<1243\> \
 WLSEL\<1244\> WLSEL\<1245\> WLSEL\<1246\> WLSEL\<1247\> WLSEL\<1248\> \
 WLSEL\<1249\> WLSEL\<1250\> WLSEL\<1251\> WLSEL\<1252\> WLSEL\<1253\> \
 WLSEL\<1254\> WLSEL\<1255\> WLSEL\<1256\> WLSEL\<1257\> WLSEL\<1258\> \
 WLSEL\<1259\> WLSEL\<1260\> WLSEL\<1261\> WLSEL\<1262\> WLSEL\<1263\> \
 WLSEL\<1264\> WLSEL\<1265\> WLSEL\<1266\> WLSEL\<1267\> WLSEL\<1268\> \
 WLSEL\<1269\> WLSEL\<1270\> WLSEL\<1271\> WLSEL\<1272\> WLSEL\<1273\> \
 WLSEL\<1274\> WLSEL\<1275\> WLSEL\<1276\> WLSEL\<1277\> WLSEL\<1278\> \
 WLSEL\<1279\> WLSEL\<1280\> WLSEL\<1281\> WLSEL\<1282\> WLSEL\<1283\> \
 WLSEL\<1284\> WLSEL\<1285\> WLSEL\<1286\> WLSEL\<1287\> WLSEL\<1288\> \
 WLSEL\<1289\> WLSEL\<1290\> WLSEL\<1291\> WLSEL\<1292\> WLSEL\<1293\> \
 WLSEL\<702\> WLSEL\<703\> WLSEL\<704\> WLSEL\<705\> WLSEL\<706\> WLSEL\<707\> \
 WLSEL\<708\> WLSEL\<709\> WLSEL\<710\> WLSEL\<711\> WLSEL\<712\> WLSEL\<713\> \
 WLSEL\<714\> WLSEL\<715\> WLSEL\<716\> WLSEL\<717\> WLSEL\<718\> WLSEL\<719\> \
 WLSEL\<720\> WLSEL\<721\> WLSEL\<722\> WLSEL\<723\> WLSEL\<724\> WLSEL\<725\> \
 WLSEL\<726\> WLSEL\<727\> WLSEL\<728\> WLSEL\<729\> WLSEL\<730\> WLSEL\<731\> \
 WLSEL\<732\> WLSEL\<733\> WLSEL\<734\> WLSEL\<735\> WLSEL\<736\> WLSEL\<737\> \
 WLSEL\<738\> WLSEL\<739\> WLSEL\<740\> WLSEL\<741\> WLSEL\<742\> WLSEL\<743\> \
 WLSEL\<744\> WLSEL\<745\> WLSEL\<746\> WLSEL\<747\> WLSEL\<748\> WLSEL\<749\> \
 WLSEL\<750\> WLSEL\<751\> WLSEL\<752\> WLSEL\<753\> WLSEL\<754\> WLSEL\<755\> \
 WLSEL\<756\> WLSEL\<757\> WLSEL\<758\> WLSEL\<759\> WLSEL\<760\> WLSEL\<761\> \
 WLSEL\<762\> WLSEL\<763\> WLSEL\<764\> WLSEL\<765\> WLSEL\<766\> WLSEL\<767\> \
 WLSEL\<768\> WLSEL\<769\> WLSEL\<770\> WLSEL\<771\> WLSEL\<772\> WLSEL\<773\> \
 WLSEL\<774\> WLSEL\<775\> WLSEL\<776\> WLSEL\<777\> WLSEL\<778\> WLSEL\<779\> \
 WLSEL\<780\> WLSEL\<781\> WLSEL\<190\> WLSEL\<191\> WLSEL\<192\> WLSEL\<193\> \
 WLSEL\<194\> WLSEL\<195\> WLSEL\<196\> WLSEL\<197\> WLSEL\<198\> WLSEL\<199\> \
 WLSEL\<200\> WLSEL\<201\> WLSEL\<202\> WLSEL\<203\> WLSEL\<204\> WLSEL\<205\> \
 WLSEL\<206\> WLSEL\<207\> WLSEL\<208\> WLSEL\<209\> WLSEL\<210\> WLSEL\<211\> \
 WLSEL\<212\> WLSEL\<213\> WLSEL\<214\> WLSEL\<215\> WLSEL\<216\> WLSEL\<217\> \
 WLSEL\<218\> WLSEL\<219\> WLSEL\<220\> WLSEL\<221\> WLSEL\<222\> WLSEL\<223\> \
 WLSEL\<224\> WLSEL\<225\> WLSEL\<226\> WLSEL\<227\> WLSEL\<228\> WLSEL\<229\> \
 WLSEL\<230\> WLSEL\<231\> WLSEL\<232\> WLSEL\<233\> WLSEL\<234\> WLSEL\<235\> \
 WLSEL\<236\> WLSEL\<237\> WLSEL\<238\> WLSEL\<239\> WLSEL\<240\> WLSEL\<241\> \
 WLSEL\<242\> WLSEL\<243\> WLSEL\<244\> WLSEL\<245\> WLSEL\<246\> WLSEL\<247\> \
 WLSEL\<248\> WLSEL\<249\> WLSEL\<250\> WLSEL\<251\> WLSEL\<252\> WLSEL\<253\> \
 WLSEL\<254\> WLSEL\<255\> WLSEL\<256\> WLSEL\<257\> WLSEL\<258\> WLSEL\<259\> \
 WLSEL\<260\> WLSEL\<261\> WLSEL\<262\> WLSEL\<263\> WLSEL\<264\> WLSEL\<265\> \
 WLSEL\<266\> WLSEL\<267\> WLSEL\<268\> WLSEL\<269\> WLSEL\<1645\> \
 WLSEL\<1646\> WLSEL\<1647\> WLSEL\<1648\> WLSEL\<1649\> WLSEL\<1650\> \
 WLSEL\<1651\> WLSEL\<1652\> WLSEL\<1653\> WLSEL\<1654\> WLSEL\<1655\> \
 WLSEL\<1656\> WLSEL\<1657\> WLSEL\<1658\> WLSEL\<1659\> WLSEL\<1660\> \
 WLSEL\<1661\> WLSEL\<1662\> WLSEL\<1663\> WLSEL\<1664\> WLSEL\<1665\> \
 WLSEL\<1666\> WLSEL\<1667\> WLSEL\<1668\> WLSEL\<1669\> WLSEL\<1670\> \
 WLSEL\<1671\> WLSEL\<1672\> WLSEL\<1673\> WLSEL\<1674\> WLSEL\<1675\> \
 WLSEL\<1676\> WLSEL\<1677\> WLSEL\<1678\> WLSEL\<1679\> WLSEL\<1680\> \
 WLSEL\<1681\> WLSEL\<1682\> WLSEL\<1683\> WLSEL\<1684\> WLSEL\<1685\> \
 WLSEL\<1686\> WLSEL\<1687\> WLSEL\<1688\> WLSEL\<1689\> WLSEL\<1690\> \
 WLSEL\<1691\> WLSEL\<1692\> WLSEL\<1693\> WLSEL\<1694\> WLSEL\<1695\> \
 WLSEL\<1696\> WLSEL\<1697\> WLSEL\<1698\> WLSEL\<1699\> WLSEL\<1700\> \
 WLSEL\<1701\> WLSEL\<1702\> WLSEL\<1703\> WLSEL\<1704\> WLSEL\<1705\> \
 WLSEL\<1706\> WLSEL\<1707\> WLSEL\<1708\> WLSEL\<1709\> WLSEL\<1710\> \
 WLSEL\<1711\> WLSEL\<1712\> WLSEL\<1713\> WLSEL\<1714\> WLSEL\<1715\> \
 WLSEL\<1716\> WLSEL\<1717\> WLSEL\<1718\> WLSEL\<1719\> WLSEL\<1720\> \
 WLSEL\<1721\> WLSEL\<1722\> WLSEL\<1723\> WLSEL\<1724\> WLSEL\<1725\> \
 WLSEL\<1133\> WLSEL\<1134\> WLSEL\<1135\> WLSEL\<1136\> WLSEL\<1137\> \
 WLSEL\<1138\> WLSEL\<1139\> WLSEL\<1140\> WLSEL\<1141\> WLSEL\<1142\> \
 WLSEL\<1143\> WLSEL\<1144\> WLSEL\<1145\> WLSEL\<1146\> WLSEL\<1147\> \
 WLSEL\<1148\> WLSEL\<1149\> WLSEL\<1150\> WLSEL\<1151\> WLSEL\<1152\> \
 WLSEL\<1153\> WLSEL\<1154\> WLSEL\<1155\> WLSEL\<1156\> WLSEL\<1157\> \
 WLSEL\<1158\> WLSEL\<1159\> WLSEL\<1160\> WLSEL\<1161\> WLSEL\<1162\> \
 WLSEL\<1163\> WLSEL\<1164\> WLSEL\<1165\> WLSEL\<1166\> WLSEL\<1167\> \
 WLSEL\<1168\> WLSEL\<1169\> WLSEL\<1170\> WLSEL\<1171\> WLSEL\<1172\> \
 WLSEL\<1173\> WLSEL\<1174\> WLSEL\<1175\> WLSEL\<1176\> WLSEL\<1177\> \
 WLSEL\<1178\> WLSEL\<1179\> WLSEL\<1180\> WLSEL\<1181\> WLSEL\<1182\> \
 WLSEL\<1183\> WLSEL\<1184\> WLSEL\<1185\> WLSEL\<1186\> WLSEL\<1187\> \
 WLSEL\<1188\> WLSEL\<1189\> WLSEL\<1190\> WLSEL\<1191\> WLSEL\<1192\> \
 WLSEL\<1193\> WLSEL\<1194\> WLSEL\<1195\> WLSEL\<1196\> WLSEL\<1197\> \
 WLSEL\<1198\> WLSEL\<1199\> WLSEL\<1200\> WLSEL\<1201\> WLSEL\<1202\> \
 WLSEL\<1203\> WLSEL\<1204\> WLSEL\<1205\> WLSEL\<1206\> WLSEL\<1207\> \
 WLSEL\<1208\> WLSEL\<1209\> WLSEL\<1210\> WLSEL\<1211\> WLSEL\<1212\> \
 WLSEL\<1213\> WLSEL\<621\> WLSEL\<622\> WLSEL\<623\> WLSEL\<624\> \
 WLSEL\<625\> WLSEL\<626\> WLSEL\<627\> WLSEL\<628\> WLSEL\<629\> WLSEL\<630\> \
 WLSEL\<631\> WLSEL\<632\> WLSEL\<633\> WLSEL\<634\> WLSEL\<635\> WLSEL\<636\> \
 WLSEL\<637\> WLSEL\<638\> WLSEL\<639\> WLSEL\<640\> WLSEL\<641\> WLSEL\<642\> \
 WLSEL\<643\> WLSEL\<644\> WLSEL\<645\> WLSEL\<646\> WLSEL\<647\> WLSEL\<648\> \
 WLSEL\<649\> WLSEL\<650\> WLSEL\<651\> WLSEL\<652\> WLSEL\<653\> WLSEL\<654\> \
 WLSEL\<655\> WLSEL\<656\> WLSEL\<657\> WLSEL\<658\> WLSEL\<659\> WLSEL\<660\> \
 WLSEL\<661\> WLSEL\<662\> WLSEL\<663\> WLSEL\<664\> WLSEL\<665\> WLSEL\<666\> \
 WLSEL\<667\> WLSEL\<668\> WLSEL\<669\> WLSEL\<670\> WLSEL\<671\> WLSEL\<672\> \
 WLSEL\<673\> WLSEL\<674\> WLSEL\<675\> WLSEL\<676\> WLSEL\<677\> WLSEL\<678\> \
 WLSEL\<679\> WLSEL\<680\> WLSEL\<681\> WLSEL\<682\> WLSEL\<683\> WLSEL\<684\> \
 WLSEL\<685\> WLSEL\<686\> WLSEL\<687\> WLSEL\<688\> WLSEL\<689\> WLSEL\<690\> \
 WLSEL\<691\> WLSEL\<692\> WLSEL\<693\> WLSEL\<694\> WLSEL\<695\> WLSEL\<696\> \
 WLSEL\<697\> WLSEL\<698\> WLSEL\<699\> WLSEL\<700\> WLSEL\<701\> WLSEL\<109\> \
 WLSEL\<110\> WLSEL\<111\> WLSEL\<112\> WLSEL\<113\> WLSEL\<114\> WLSEL\<115\> \
 WLSEL\<116\> WLSEL\<117\> WLSEL\<118\> WLSEL\<119\> WLSEL\<120\> WLSEL\<121\> \
 WLSEL\<122\> WLSEL\<123\> WLSEL\<124\> WLSEL\<125\> WLSEL\<126\> WLSEL\<127\> \
 WLSEL\<128\> WLSEL\<129\> WLSEL\<130\> WLSEL\<131\> WLSEL\<132\> WLSEL\<133\> \
 WLSEL\<134\> WLSEL\<135\> WLSEL\<136\> WLSEL\<137\> WLSEL\<138\> WLSEL\<139\> \
 WLSEL\<140\> WLSEL\<141\> WLSEL\<142\> WLSEL\<143\> WLSEL\<144\> WLSEL\<145\> \
 WLSEL\<146\> WLSEL\<147\> WLSEL\<148\> WLSEL\<149\> WLSEL\<150\> WLSEL\<151\> \
 WLSEL\<152\> WLSEL\<153\> WLSEL\<154\> WLSEL\<155\> WLSEL\<156\> WLSEL\<157\> \
 WLSEL\<158\> WLSEL\<159\> WLSEL\<160\> WLSEL\<161\> WLSEL\<162\> WLSEL\<163\> \
 WLSEL\<164\> WLSEL\<165\> WLSEL\<166\> WLSEL\<167\> WLSEL\<168\> WLSEL\<169\> \
 WLSEL\<170\> WLSEL\<171\> WLSEL\<172\> WLSEL\<173\> WLSEL\<174\> WLSEL\<175\> \
 WLSEL\<176\> WLSEL\<177\> WLSEL\<178\> WLSEL\<179\> WLSEL\<180\> WLSEL\<181\> \
 WLSEL\<182\> WLSEL\<183\> WLSEL\<184\> WLSEL\<185\> WLSEL\<186\> WLSEL\<187\> \
 WLSEL\<188\> WLSEL\<189\> WLSEL\<1565\> WLSEL\<1566\> WLSEL\<1567\> \
 WLSEL\<1568\> WLSEL\<1569\> WLSEL\<1570\> WLSEL\<1571\> WLSEL\<1572\> \
 WLSEL\<1573\> WLSEL\<1574\> WLSEL\<1575\> WLSEL\<1576\> WLSEL\<1577\> \
 WLSEL\<1578\> WLSEL\<1579\> WLSEL\<1580\> WLSEL\<1581\> WLSEL\<1582\> \
 WLSEL\<1583\> WLSEL\<1584\> WLSEL\<1585\> WLSEL\<1586\> WLSEL\<1587\> \
 WLSEL\<1588\> WLSEL\<1589\> WLSEL\<1590\> WLSEL\<1591\> WLSEL\<1592\> \
 WLSEL\<1593\> WLSEL\<1594\> WLSEL\<1595\> WLSEL\<1596\> WLSEL\<1597\> \
 WLSEL\<1598\> WLSEL\<1599\> WLSEL\<1600\> WLSEL\<1601\> WLSEL\<1602\> \
 WLSEL\<1603\> WLSEL\<1604\> WLSEL\<1605\> WLSEL\<1606\> WLSEL\<1607\> \
 WLSEL\<1608\> WLSEL\<1609\> WLSEL\<1610\> WLSEL\<1611\> WLSEL\<1612\> \
 WLSEL\<1613\> WLSEL\<1614\> WLSEL\<1615\> WLSEL\<1616\> WLSEL\<1617\> \
 WLSEL\<1618\> WLSEL\<1619\> WLSEL\<1620\> WLSEL\<1621\> WLSEL\<1622\> \
 WLSEL\<1623\> WLSEL\<1624\> WLSEL\<1625\> WLSEL\<1626\> WLSEL\<1627\> \
 WLSEL\<1628\> WLSEL\<1629\> WLSEL\<1630\> WLSEL\<1631\> WLSEL\<1632\> \
 WLSEL\<1633\> WLSEL\<1634\> WLSEL\<1635\> WLSEL\<1636\> WLSEL\<1637\> \
 WLSEL\<1638\> WLSEL\<1639\> WLSEL\<1640\> WLSEL\<1641\> WLSEL\<1642\> \
 WLSEL\<1643\> WLSEL\<1644\> WLSEL\<1053\> WLSEL\<1054\> WLSEL\<1055\> \
 WLSEL\<1056\> WLSEL\<1057\> WLSEL\<1058\> WLSEL\<1059\> WLSEL\<1060\> \
 WLSEL\<1061\> WLSEL\<1062\> WLSEL\<1063\> WLSEL\<1064\> WLSEL\<1065\> \
 WLSEL\<1066\> WLSEL\<1067\> WLSEL\<1068\> WLSEL\<1069\> WLSEL\<1070\> \
 WLSEL\<1071\> WLSEL\<1072\> WLSEL\<1073\> WLSEL\<1074\> WLSEL\<1075\> \
 WLSEL\<1076\> WLSEL\<1077\> WLSEL\<1078\> WLSEL\<1079\> WLSEL\<1080\> \
 WLSEL\<1081\> WLSEL\<1082\> WLSEL\<1083\> WLSEL\<1084\> WLSEL\<1085\> \
 WLSEL\<1086\> WLSEL\<1087\> WLSEL\<1088\> WLSEL\<1089\> WLSEL\<1090\> \
 WLSEL\<1091\> WLSEL\<1092\> WLSEL\<1093\> WLSEL\<1094\> WLSEL\<1095\> \
 WLSEL\<1096\> WLSEL\<1097\> WLSEL\<1098\> WLSEL\<1099\> WLSEL\<1100\> \
 WLSEL\<1101\> WLSEL\<1102\> WLSEL\<1103\> WLSEL\<1104\> WLSEL\<1105\> \
 WLSEL\<1106\> WLSEL\<1107\> WLSEL\<1108\> WLSEL\<1109\> WLSEL\<1110\> \
 WLSEL\<1111\> WLSEL\<1112\> WLSEL\<1113\> WLSEL\<1114\> WLSEL\<1115\> \
 WLSEL\<1116\> WLSEL\<1117\> WLSEL\<1118\> WLSEL\<1119\> WLSEL\<1120\> \
 WLSEL\<1121\> WLSEL\<1122\> WLSEL\<1123\> WLSEL\<1124\> WLSEL\<1125\> \
 WLSEL\<1126\> WLSEL\<1127\> WLSEL\<1128\> WLSEL\<1129\> WLSEL\<1130\> \
 WLSEL\<1131\> WLSEL\<1132\> WLSEL\<541\> WLSEL\<542\> WLSEL\<543\> \
 WLSEL\<544\> WLSEL\<545\> WLSEL\<546\> WLSEL\<547\> WLSEL\<548\> WLSEL\<549\> \
 WLSEL\<550\> WLSEL\<551\> WLSEL\<552\> WLSEL\<553\> WLSEL\<554\> WLSEL\<555\> \
 WLSEL\<556\> WLSEL\<557\> WLSEL\<558\> WLSEL\<559\> WLSEL\<560\> WLSEL\<561\> \
 WLSEL\<562\> WLSEL\<563\> WLSEL\<564\> WLSEL\<565\> WLSEL\<566\> WLSEL\<567\> \
 WLSEL\<568\> WLSEL\<569\> WLSEL\<570\> WLSEL\<571\> WLSEL\<572\> WLSEL\<573\> \
 WLSEL\<574\> WLSEL\<575\> WLSEL\<576\> WLSEL\<577\> WLSEL\<578\> WLSEL\<579\> \
 WLSEL\<580\> WLSEL\<581\> WLSEL\<582\> WLSEL\<583\> WLSEL\<584\> WLSEL\<585\> \
 WLSEL\<586\> WLSEL\<587\> WLSEL\<588\> WLSEL\<589\> WLSEL\<590\> WLSEL\<591\> \
 WLSEL\<592\> WLSEL\<593\> WLSEL\<594\> WLSEL\<595\> WLSEL\<596\> WLSEL\<597\> \
 WLSEL\<598\> WLSEL\<599\> WLSEL\<600\> WLSEL\<601\> WLSEL\<602\> WLSEL\<603\> \
 WLSEL\<604\> WLSEL\<605\> WLSEL\<606\> WLSEL\<607\> WLSEL\<608\> WLSEL\<609\> \
 WLSEL\<610\> WLSEL\<611\> WLSEL\<612\> WLSEL\<613\> WLSEL\<614\> WLSEL\<615\> \
 WLSEL\<616\> WLSEL\<617\> WLSEL\<618\> WLSEL\<619\> WLSEL\<620\> WLSEL\<29\> \
 WLSEL\<30\> WLSEL\<31\> WLSEL\<32\> WLSEL\<33\> WLSEL\<34\> WLSEL\<35\> \
 WLSEL\<36\> WLSEL\<37\> WLSEL\<38\> WLSEL\<39\> WLSEL\<40\> WLSEL\<41\> \
 WLSEL\<42\> WLSEL\<43\> WLSEL\<44\> WLSEL\<45\> WLSEL\<46\> WLSEL\<47\> \
 WLSEL\<48\> WLSEL\<49\> WLSEL\<50\> WLSEL\<51\> WLSEL\<52\> WLSEL\<53\> \
 WLSEL\<54\> WLSEL\<55\> WLSEL\<56\> WLSEL\<57\> WLSEL\<58\> WLSEL\<59\> \
 WLSEL\<60\> WLSEL\<61\> WLSEL\<62\> WLSEL\<63\> WLSEL\<64\> WLSEL\<65\> \
 WLSEL\<66\> WLSEL\<67\> WLSEL\<68\> WLSEL\<69\> WLSEL\<70\> WLSEL\<71\> \
 WLSEL\<72\> WLSEL\<73\> WLSEL\<74\> WLSEL\<75\> WLSEL\<76\> WLSEL\<77\> \
 WLSEL\<78\> WLSEL\<79\> WLSEL\<80\> WLSEL\<81\> WLSEL\<82\> WLSEL\<83\> \
 WLSEL\<84\> WLSEL\<85\> WLSEL\<86\> WLSEL\<87\> WLSEL\<88\> WLSEL\<89\> \
 WLSEL\<90\> WLSEL\<91\> WLSEL\<92\> WLSEL\<93\> WLSEL\<94\> WLSEL\<95\> \
 WLSEL\<96\> WLSEL\<97\> WLSEL\<98\> WLSEL\<99\> WLSEL\<100\> WLSEL\<101\> \
 WLSEL\<102\> WLSEL\<103\> WLSEL\<104\> WLSEL\<105\> WLSEL\<106\> WLSEL\<107\> \
 WLSEL\<108\> WLSEL\<1536\> WLSEL\<1537\> WLSEL\<1538\> WLSEL\<1539\> \
 WLSEL\<1540\> WLSEL\<1541\> WLSEL\<1542\> WLSEL\<1543\> WLSEL\<1544\> \
 WLSEL\<1545\> WLSEL\<1546\> WLSEL\<1547\> WLSEL\<1548\> WLSEL\<1549\> \
 WLSEL\<1550\> WLSEL\<1551\> WLSEL\<1552\> WLSEL\<1553\> WLSEL\<1554\> \
 WLSEL\<1555\> WLSEL\<1556\> WLSEL\<1557\> WLSEL\<1558\> WLSEL\<1559\> \
 WLSEL\<1560\> WLSEL\<1561\> WLSEL\<1562\> WLSEL\<1563\> WLSEL\<1564\> \
 WLSEL\<1024\> WLSEL\<1025\> WLSEL\<1026\> WLSEL\<1027\> WLSEL\<1028\> \
 WLSEL\<1029\> WLSEL\<1030\> WLSEL\<1031\> WLSEL\<1032\> WLSEL\<1033\> \
 WLSEL\<1034\> WLSEL\<1035\> WLSEL\<1036\> WLSEL\<1037\> WLSEL\<1038\> \
 WLSEL\<1039\> WLSEL\<1040\> WLSEL\<1041\> WLSEL\<1042\> WLSEL\<1043\> \
 WLSEL\<1044\> WLSEL\<1045\> WLSEL\<1046\> WLSEL\<1047\> WLSEL\<1048\> \
 WLSEL\<1049\> WLSEL\<1050\> WLSEL\<1051\> WLSEL\<1052\> WLSEL\<512\> \
 WLSEL\<513\> WLSEL\<514\> WLSEL\<515\> WLSEL\<516\> WLSEL\<517\> WLSEL\<518\> \
 WLSEL\<519\> WLSEL\<520\> WLSEL\<521\> WLSEL\<522\> WLSEL\<523\> WLSEL\<524\> \
 WLSEL\<525\> WLSEL\<526\> WLSEL\<527\> WLSEL\<528\> WLSEL\<529\> WLSEL\<530\> \
 WLSEL\<531\> WLSEL\<532\> WLSEL\<533\> WLSEL\<534\> WLSEL\<535\> WLSEL\<536\> \
 WLSEL\<537\> WLSEL\<538\> WLSEL\<539\> WLSEL\<540\> WLSEL\<0\> WLSEL\<1\> \
 WLSEL\<2\> WLSEL\<3\> WLSEL\<4\> WLSEL\<5\> WLSEL\<6\> WLSEL\<7\> WLSEL\<8\> \
 WLSEL\<9\> WLSEL\<10\> WLSEL\<11\> WLSEL\<12\> WLSEL\<13\> WLSEL\<14\> \
 WLSEL\<15\> WLSEL\<16\> WLSEL\<17\> WLSEL\<18\> WLSEL\<19\> WLSEL\<20\> \
 WLSEL\<21\> WLSEL\<22\> WLSEL\<23\> WLSEL\<24\> WLSEL\<25\> WLSEL\<26\> \
 WLSEL\<27\> WLSEL\<28\> )
//
// WLSEL<28>	WLSEL<28>
// WLSEL<27>	WLSEL<27>
// WLSEL<26>	WLSEL<26>
// WLSEL<25>	WLSEL<25>
// WLSEL<24>	WLSEL<24>
// WLSEL<23>	WLSEL<23>
// WLSEL<22>	WLSEL<22>
// WLSEL<21>	WLSEL<21>
// WLSEL<20>	WLSEL<20>
// WLSEL<19>	WLSEL<19>
// WLSEL<18>	WLSEL<18>
// WLSEL<17>	WLSEL<17>
// WLSEL<16>	WLSEL<16>
// WLSEL<15>	WLSEL<15>
// WLSEL<14>	WLSEL<14>
// WLSEL<13>	WLSEL<13>
// WLSEL<12>	WLSEL<12>
// WLSEL<11>	WLSEL<11>
// WLSEL<10>	WLSEL<10>
// WLSEL<9>	WLSEL<9>
// WLSEL<8>	WLSEL<8>
// WLSEL<7>	WLSEL<7>
// WLSEL<6>	WLSEL<6>
// WLSEL<5>	WLSEL<5>
// WLSEL<4>	WLSEL<4>
// WLSEL<3>	WLSEL<3>
// WLSEL<2>	WLSEL<2>
// WLSEL<1>	WLSEL<1>
// WLSEL<0>	WLSEL<0>
// WLSEL<540>	WLSEL<540>
// WLSEL<539>	WLSEL<539>
// WLSEL<538>	WLSEL<538>
// WLSEL<537>	WLSEL<537>
// WLSEL<536>	WLSEL<536>
// WLSEL<535>	WLSEL<535>
// WLSEL<534>	WLSEL<534>
// WLSEL<533>	WLSEL<533>
// WLSEL<532>	WLSEL<532>
// WLSEL<531>	WLSEL<531>
// WLSEL<530>	WLSEL<530>
// WLSEL<529>	WLSEL<529>
// WLSEL<528>	WLSEL<528>
// WLSEL<527>	WLSEL<527>
// WLSEL<526>	WLSEL<526>
// WLSEL<525>	WLSEL<525>
// WLSEL<524>	WLSEL<524>
// WLSEL<523>	WLSEL<523>
// WLSEL<522>	WLSEL<522>
// WLSEL<521>	WLSEL<521>
// WLSEL<520>	WLSEL<520>
// WLSEL<519>	WLSEL<519>
// WLSEL<518>	WLSEL<518>
// WLSEL<517>	WLSEL<517>
// WLSEL<516>	WLSEL<516>
// WLSEL<515>	WLSEL<515>
// WLSEL<514>	WLSEL<514>
// WLSEL<513>	WLSEL<513>
// WLSEL<512>	WLSEL<512>
// WLSEL<1052>	WLSEL<1052>
// WLSEL<1051>	WLSEL<1051>
// WLSEL<1050>	WLSEL<1050>
// WLSEL<1049>	WLSEL<1049>
// WLSEL<1048>	WLSEL<1048>
// WLSEL<1047>	WLSEL<1047>
// WLSEL<1046>	WLSEL<1046>
// WLSEL<1045>	WLSEL<1045>
// WLSEL<1044>	WLSEL<1044>
// WLSEL<1043>	WLSEL<1043>
// WLSEL<1042>	WLSEL<1042>
// WLSEL<1041>	WLSEL<1041>
// WLSEL<1040>	WLSEL<1040>
// WLSEL<1039>	WLSEL<1039>
// WLSEL<1038>	WLSEL<1038>
// WLSEL<1037>	WLSEL<1037>
// WLSEL<1036>	WLSEL<1036>
// WLSEL<1035>	WLSEL<1035>
// WLSEL<1034>	WLSEL<1034>
// WLSEL<1033>	WLSEL<1033>
// WLSEL<1032>	WLSEL<1032>
// WLSEL<1031>	WLSEL<1031>
// WLSEL<1030>	WLSEL<1030>
// WLSEL<1029>	WLSEL<1029>
// WLSEL<1028>	WLSEL<1028>
// WLSEL<1027>	WLSEL<1027>
// WLSEL<1026>	WLSEL<1026>
// WLSEL<1025>	WLSEL<1025>
// WLSEL<1024>	WLSEL<1024>
// WLSEL<1564>	WLSEL<1564>
// WLSEL<1563>	WLSEL<1563>
// WLSEL<1562>	WLSEL<1562>
// WLSEL<1561>	WLSEL<1561>
// WLSEL<1560>	WLSEL<1560>
// WLSEL<1559>	WLSEL<1559>
// WLSEL<1558>	WLSEL<1558>
// WLSEL<1557>	WLSEL<1557>
// WLSEL<1556>	WLSEL<1556>
// WLSEL<1555>	WLSEL<1555>
// WLSEL<1554>	WLSEL<1554>
// WLSEL<1553>	WLSEL<1553>
// WLSEL<1552>	WLSEL<1552>
// WLSEL<1551>	WLSEL<1551>
// WLSEL<1550>	WLSEL<1550>
// WLSEL<1549>	WLSEL<1549>
// WLSEL<1548>	WLSEL<1548>
// WLSEL<1547>	WLSEL<1547>
// WLSEL<1546>	WLSEL<1546>
// WLSEL<1545>	WLSEL<1545>
// WLSEL<1544>	WLSEL<1544>
// WLSEL<1543>	WLSEL<1543>
// WLSEL<1542>	WLSEL<1542>
// WLSEL<1541>	WLSEL<1541>
// WLSEL<1540>	WLSEL<1540>
// WLSEL<1539>	WLSEL<1539>
// WLSEL<1538>	WLSEL<1538>
// WLSEL<1537>	WLSEL<1537>
// WLSEL<1536>	WLSEL<1536>
// WLSEL<108>	WLSEL<108>
// WLSEL<107>	WLSEL<107>
// WLSEL<106>	WLSEL<106>
// WLSEL<105>	WLSEL<105>
// WLSEL<104>	WLSEL<104>
// WLSEL<103>	WLSEL<103>
// WLSEL<102>	WLSEL<102>
// WLSEL<101>	WLSEL<101>
// WLSEL<100>	WLSEL<100>
// WLSEL<99>	WLSEL<99>
// WLSEL<98>	WLSEL<98>
// WLSEL<97>	WLSEL<97>
// WLSEL<96>	WLSEL<96>
// WLSEL<95>	WLSEL<95>
// WLSEL<94>	WLSEL<94>
// WLSEL<93>	WLSEL<93>
// WLSEL<92>	WLSEL<92>
// WLSEL<91>	WLSEL<91>
// WLSEL<90>	WLSEL<90>
// WLSEL<89>	WLSEL<89>
// WLSEL<88>	WLSEL<88>
// WLSEL<87>	WLSEL<87>
// WLSEL<86>	WLSEL<86>
// WLSEL<85>	WLSEL<85>
// WLSEL<84>	WLSEL<84>
// WLSEL<83>	WLSEL<83>
// WLSEL<82>	WLSEL<82>
// WLSEL<81>	WLSEL<81>
// WLSEL<80>	WLSEL<80>
// WLSEL<79>	WLSEL<79>
// WLSEL<78>	WLSEL<78>
// WLSEL<77>	WLSEL<77>
// WLSEL<76>	WLSEL<76>
// WLSEL<75>	WLSEL<75>
// WLSEL<74>	WLSEL<74>
// WLSEL<73>	WLSEL<73>
// WLSEL<72>	WLSEL<72>
// WLSEL<71>	WLSEL<71>
// WLSEL<70>	WLSEL<70>
// WLSEL<69>	WLSEL<69>
// WLSEL<68>	WLSEL<68>
// WLSEL<67>	WLSEL<67>
// WLSEL<66>	WLSEL<66>
// WLSEL<65>	WLSEL<65>
// WLSEL<64>	WLSEL<64>
// WLSEL<63>	WLSEL<63>
// WLSEL<62>	WLSEL<62>
// WLSEL<61>	WLSEL<61>
// WLSEL<60>	WLSEL<60>
// WLSEL<59>	WLSEL<59>
// WLSEL<58>	WLSEL<58>
// WLSEL<57>	WLSEL<57>
// WLSEL<56>	WLSEL<56>
// WLSEL<55>	WLSEL<55>
// WLSEL<54>	WLSEL<54>
// WLSEL<53>	WLSEL<53>
// WLSEL<52>	WLSEL<52>
// WLSEL<51>	WLSEL<51>
// WLSEL<50>	WLSEL<50>
// WLSEL<49>	WLSEL<49>
// WLSEL<48>	WLSEL<48>
// WLSEL<47>	WLSEL<47>
// WLSEL<46>	WLSEL<46>
// WLSEL<45>	WLSEL<45>
// WLSEL<44>	WLSEL<44>
// WLSEL<43>	WLSEL<43>
// WLSEL<42>	WLSEL<42>
// WLSEL<41>	WLSEL<41>
// WLSEL<40>	WLSEL<40>
// WLSEL<39>	WLSEL<39>
// WLSEL<38>	WLSEL<38>
// WLSEL<37>	WLSEL<37>
// WLSEL<36>	WLSEL<36>
// WLSEL<35>	WLSEL<35>
// WLSEL<34>	WLSEL<34>
// WLSEL<33>	WLSEL<33>
// WLSEL<32>	WLSEL<32>
// WLSEL<31>	WLSEL<31>
// WLSEL<30>	WLSEL<30>
// WLSEL<29>	WLSEL<29>
// WLSEL<620>	WLSEL<620>
// WLSEL<619>	WLSEL<619>
// WLSEL<618>	WLSEL<618>
// WLSEL<617>	WLSEL<617>
// WLSEL<616>	WLSEL<616>
// WLSEL<615>	WLSEL<615>
// WLSEL<614>	WLSEL<614>
// WLSEL<613>	WLSEL<613>
// WLSEL<612>	WLSEL<612>
// WLSEL<611>	WLSEL<611>
// WLSEL<610>	WLSEL<610>
// WLSEL<609>	WLSEL<609>
// WLSEL<608>	WLSEL<608>
// WLSEL<607>	WLSEL<607>
// WLSEL<606>	WLSEL<606>
// WLSEL<605>	WLSEL<605>
// WLSEL<604>	WLSEL<604>
// WLSEL<603>	WLSEL<603>
// WLSEL<602>	WLSEL<602>
// WLSEL<601>	WLSEL<601>
// WLSEL<600>	WLSEL<600>
// WLSEL<599>	WLSEL<599>
// WLSEL<598>	WLSEL<598>
// WLSEL<597>	WLSEL<597>
// WLSEL<596>	WLSEL<596>
// WLSEL<595>	WLSEL<595>
// WLSEL<594>	WLSEL<594>
// WLSEL<593>	WLSEL<593>
// WLSEL<592>	WLSEL<592>
// WLSEL<591>	WLSEL<591>
// WLSEL<590>	WLSEL<590>
// WLSEL<589>	WLSEL<589>
// WLSEL<588>	WLSEL<588>
// WLSEL<587>	WLSEL<587>
// WLSEL<586>	WLSEL<586>
// WLSEL<585>	WLSEL<585>
// WLSEL<584>	WLSEL<584>
// WLSEL<583>	WLSEL<583>
// WLSEL<582>	WLSEL<582>
// WLSEL<581>	WLSEL<581>
// WLSEL<580>	WLSEL<580>
// WLSEL<579>	WLSEL<579>
// WLSEL<578>	WLSEL<578>
// WLSEL<577>	WLSEL<577>
// WLSEL<576>	WLSEL<576>
// WLSEL<575>	WLSEL<575>
// WLSEL<574>	WLSEL<574>
// WLSEL<573>	WLSEL<573>
// WLSEL<572>	WLSEL<572>
// WLSEL<571>	WLSEL<571>
// WLSEL<570>	WLSEL<570>
// WLSEL<569>	WLSEL<569>
// WLSEL<568>	WLSEL<568>
// WLSEL<567>	WLSEL<567>
// WLSEL<566>	WLSEL<566>
// WLSEL<565>	WLSEL<565>
// WLSEL<564>	WLSEL<564>
// WLSEL<563>	WLSEL<563>
// WLSEL<562>	WLSEL<562>
// WLSEL<561>	WLSEL<561>
// WLSEL<560>	WLSEL<560>
// WLSEL<559>	WLSEL<559>
// WLSEL<558>	WLSEL<558>
// WLSEL<557>	WLSEL<557>
// WLSEL<556>	WLSEL<556>
// WLSEL<555>	WLSEL<555>
// WLSEL<554>	WLSEL<554>
// WLSEL<553>	WLSEL<553>
// WLSEL<552>	WLSEL<552>
// WLSEL<551>	WLSEL<551>
// WLSEL<550>	WLSEL<550>
// WLSEL<549>	WLSEL<549>
// WLSEL<548>	WLSEL<548>
// WLSEL<547>	WLSEL<547>
// WLSEL<546>	WLSEL<546>
// WLSEL<545>	WLSEL<545>
// WLSEL<544>	WLSEL<544>
// WLSEL<543>	WLSEL<543>
// WLSEL<542>	WLSEL<542>
// WLSEL<541>	WLSEL<541>
// WLSEL<1132>	WLSEL<1132>
// WLSEL<1131>	WLSEL<1131>
// WLSEL<1130>	WLSEL<1130>
// WLSEL<1129>	WLSEL<1129>
// WLSEL<1128>	WLSEL<1128>
// WLSEL<1127>	WLSEL<1127>
// WLSEL<1126>	WLSEL<1126>
// WLSEL<1125>	WLSEL<1125>
// WLSEL<1124>	WLSEL<1124>
// WLSEL<1123>	WLSEL<1123>
// WLSEL<1122>	WLSEL<1122>
// WLSEL<1121>	WLSEL<1121>
// WLSEL<1120>	WLSEL<1120>
// WLSEL<1119>	WLSEL<1119>
// WLSEL<1118>	WLSEL<1118>
// WLSEL<1117>	WLSEL<1117>
// WLSEL<1116>	WLSEL<1116>
// WLSEL<1115>	WLSEL<1115>
// WLSEL<1114>	WLSEL<1114>
// WLSEL<1113>	WLSEL<1113>
// WLSEL<1112>	WLSEL<1112>
// WLSEL<1111>	WLSEL<1111>
// WLSEL<1110>	WLSEL<1110>
// WLSEL<1109>	WLSEL<1109>
// WLSEL<1108>	WLSEL<1108>
// WLSEL<1107>	WLSEL<1107>
// WLSEL<1106>	WLSEL<1106>
// WLSEL<1105>	WLSEL<1105>
// WLSEL<1104>	WLSEL<1104>
// WLSEL<1103>	WLSEL<1103>
// WLSEL<1102>	WLSEL<1102>
// WLSEL<1101>	WLSEL<1101>
// WLSEL<1100>	WLSEL<1100>
// WLSEL<1099>	WLSEL<1099>
// WLSEL<1098>	WLSEL<1098>
// WLSEL<1097>	WLSEL<1097>
// WLSEL<1096>	WLSEL<1096>
// WLSEL<1095>	WLSEL<1095>
// WLSEL<1094>	WLSEL<1094>
// WLSEL<1093>	WLSEL<1093>
// WLSEL<1092>	WLSEL<1092>
// WLSEL<1091>	WLSEL<1091>
// WLSEL<1090>	WLSEL<1090>
// WLSEL<1089>	WLSEL<1089>
// WLSEL<1088>	WLSEL<1088>
// WLSEL<1087>	WLSEL<1087>
// WLSEL<1086>	WLSEL<1086>
// WLSEL<1085>	WLSEL<1085>
// WLSEL<1084>	WLSEL<1084>
// WLSEL<1083>	WLSEL<1083>
// WLSEL<1082>	WLSEL<1082>
// WLSEL<1081>	WLSEL<1081>
// WLSEL<1080>	WLSEL<1080>
// WLSEL<1079>	WLSEL<1079>
// WLSEL<1078>	WLSEL<1078>
// WLSEL<1077>	WLSEL<1077>
// WLSEL<1076>	WLSEL<1076>
// WLSEL<1075>	WLSEL<1075>
// WLSEL<1074>	WLSEL<1074>
// WLSEL<1073>	WLSEL<1073>
// WLSEL<1072>	WLSEL<1072>
// WLSEL<1071>	WLSEL<1071>
// WLSEL<1070>	WLSEL<1070>
// WLSEL<1069>	WLSEL<1069>
// WLSEL<1068>	WLSEL<1068>
// WLSEL<1067>	WLSEL<1067>
// WLSEL<1066>	WLSEL<1066>
// WLSEL<1065>	WLSEL<1065>
// WLSEL<1064>	WLSEL<1064>
// WLSEL<1063>	WLSEL<1063>
// WLSEL<1062>	WLSEL<1062>
// WLSEL<1061>	WLSEL<1061>
// WLSEL<1060>	WLSEL<1060>
// WLSEL<1059>	WLSEL<1059>
// WLSEL<1058>	WLSEL<1058>
// WLSEL<1057>	WLSEL<1057>
// WLSEL<1056>	WLSEL<1056>
// WLSEL<1055>	WLSEL<1055>
// WLSEL<1054>	WLSEL<1054>
// WLSEL<1053>	WLSEL<1053>
// WLSEL<1644>	WLSEL<1644>
// WLSEL<1643>	WLSEL<1643>
// WLSEL<1642>	WLSEL<1642>
// WLSEL<1641>	WLSEL<1641>
// WLSEL<1640>	WLSEL<1640>
// WLSEL<1639>	WLSEL<1639>
// WLSEL<1638>	WLSEL<1638>
// WLSEL<1637>	WLSEL<1637>
// WLSEL<1636>	WLSEL<1636>
// WLSEL<1635>	WLSEL<1635>
// WLSEL<1634>	WLSEL<1634>
// WLSEL<1633>	WLSEL<1633>
// WLSEL<1632>	WLSEL<1632>
// WLSEL<1631>	WLSEL<1631>
// WLSEL<1630>	WLSEL<1630>
// WLSEL<1629>	WLSEL<1629>
// WLSEL<1628>	WLSEL<1628>
// WLSEL<1627>	WLSEL<1627>
// WLSEL<1626>	WLSEL<1626>
// WLSEL<1625>	WLSEL<1625>
// WLSEL<1624>	WLSEL<1624>
// WLSEL<1623>	WLSEL<1623>
// WLSEL<1622>	WLSEL<1622>
// WLSEL<1621>	WLSEL<1621>
// WLSEL<1620>	WLSEL<1620>
// WLSEL<1619>	WLSEL<1619>
// WLSEL<1618>	WLSEL<1618>
// WLSEL<1617>	WLSEL<1617>
// WLSEL<1616>	WLSEL<1616>
// WLSEL<1615>	WLSEL<1615>
// WLSEL<1614>	WLSEL<1614>
// WLSEL<1613>	WLSEL<1613>
// WLSEL<1612>	WLSEL<1612>
// WLSEL<1611>	WLSEL<1611>
// WLSEL<1610>	WLSEL<1610>
// WLSEL<1609>	WLSEL<1609>
// WLSEL<1608>	WLSEL<1608>
// WLSEL<1607>	WLSEL<1607>
// WLSEL<1606>	WLSEL<1606>
// WLSEL<1605>	WLSEL<1605>
// WLSEL<1604>	WLSEL<1604>
// WLSEL<1603>	WLSEL<1603>
// WLSEL<1602>	WLSEL<1602>
// WLSEL<1601>	WLSEL<1601>
// WLSEL<1600>	WLSEL<1600>
// WLSEL<1599>	WLSEL<1599>
// WLSEL<1598>	WLSEL<1598>
// WLSEL<1597>	WLSEL<1597>
// WLSEL<1596>	WLSEL<1596>
// WLSEL<1595>	WLSEL<1595>
// WLSEL<1594>	WLSEL<1594>
// WLSEL<1593>	WLSEL<1593>
// WLSEL<1592>	WLSEL<1592>
// WLSEL<1591>	WLSEL<1591>
// WLSEL<1590>	WLSEL<1590>
// WLSEL<1589>	WLSEL<1589>
// WLSEL<1588>	WLSEL<1588>
// WLSEL<1587>	WLSEL<1587>
// WLSEL<1586>	WLSEL<1586>
// WLSEL<1585>	WLSEL<1585>
// WLSEL<1584>	WLSEL<1584>
// WLSEL<1583>	WLSEL<1583>
// WLSEL<1582>	WLSEL<1582>
// WLSEL<1581>	WLSEL<1581>
// WLSEL<1580>	WLSEL<1580>
// WLSEL<1579>	WLSEL<1579>
// WLSEL<1578>	WLSEL<1578>
// WLSEL<1577>	WLSEL<1577>
// WLSEL<1576>	WLSEL<1576>
// WLSEL<1575>	WLSEL<1575>
// WLSEL<1574>	WLSEL<1574>
// WLSEL<1573>	WLSEL<1573>
// WLSEL<1572>	WLSEL<1572>
// WLSEL<1571>	WLSEL<1571>
// WLSEL<1570>	WLSEL<1570>
// WLSEL<1569>	WLSEL<1569>
// WLSEL<1568>	WLSEL<1568>
// WLSEL<1567>	WLSEL<1567>
// WLSEL<1566>	WLSEL<1566>
// WLSEL<1565>	WLSEL<1565>
// WLSEL<189>	WLSEL<189>
// WLSEL<188>	WLSEL<188>
// WLSEL<187>	WLSEL<187>
// WLSEL<186>	WLSEL<186>
// WLSEL<185>	WLSEL<185>
// WLSEL<184>	WLSEL<184>
// WLSEL<183>	WLSEL<183>
// WLSEL<182>	WLSEL<182>
// WLSEL<181>	WLSEL<181>
// WLSEL<180>	WLSEL<180>
// WLSEL<179>	WLSEL<179>
// WLSEL<178>	WLSEL<178>
// WLSEL<177>	WLSEL<177>
// WLSEL<176>	WLSEL<176>
// WLSEL<175>	WLSEL<175>
// WLSEL<174>	WLSEL<174>
// WLSEL<173>	WLSEL<173>
// WLSEL<172>	WLSEL<172>
// WLSEL<171>	WLSEL<171>
// WLSEL<170>	WLSEL<170>
// WLSEL<169>	WLSEL<169>
// WLSEL<168>	WLSEL<168>
// WLSEL<167>	WLSEL<167>
// WLSEL<166>	WLSEL<166>
// WLSEL<165>	WLSEL<165>
// WLSEL<164>	WLSEL<164>
// WLSEL<163>	WLSEL<163>
// WLSEL<162>	WLSEL<162>
// WLSEL<161>	WLSEL<161>
// WLSEL<160>	WLSEL<160>
// WLSEL<159>	WLSEL<159>
// WLSEL<158>	WLSEL<158>
// WLSEL<157>	WLSEL<157>
// WLSEL<156>	WLSEL<156>
// WLSEL<155>	WLSEL<155>
// WLSEL<154>	WLSEL<154>
// WLSEL<153>	WLSEL<153>
// WLSEL<152>	WLSEL<152>
// WLSEL<151>	WLSEL<151>
// WLSEL<150>	WLSEL<150>
// WLSEL<149>	WLSEL<149>
// WLSEL<148>	WLSEL<148>
// WLSEL<147>	WLSEL<147>
// WLSEL<146>	WLSEL<146>
// WLSEL<145>	WLSEL<145>
// WLSEL<144>	WLSEL<144>
// WLSEL<143>	WLSEL<143>
// WLSEL<142>	WLSEL<142>
// WLSEL<141>	WLSEL<141>
// WLSEL<140>	WLSEL<140>
// WLSEL<139>	WLSEL<139>
// WLSEL<138>	WLSEL<138>
// WLSEL<137>	WLSEL<137>
// WLSEL<136>	WLSEL<136>
// WLSEL<135>	WLSEL<135>
// WLSEL<134>	WLSEL<134>
// WLSEL<133>	WLSEL<133>
// WLSEL<132>	WLSEL<132>
// WLSEL<131>	WLSEL<131>
// WLSEL<130>	WLSEL<130>
// WLSEL<129>	WLSEL<129>
// WLSEL<128>	WLSEL<128>
// WLSEL<127>	WLSEL<127>
// WLSEL<126>	WLSEL<126>
// WLSEL<125>	WLSEL<125>
// WLSEL<124>	WLSEL<124>
// WLSEL<123>	WLSEL<123>
// WLSEL<122>	WLSEL<122>
// WLSEL<121>	WLSEL<121>
// WLSEL<120>	WLSEL<120>
// WLSEL<119>	WLSEL<119>
// WLSEL<118>	WLSEL<118>
// WLSEL<117>	WLSEL<117>
// WLSEL<116>	WLSEL<116>
// WLSEL<115>	WLSEL<115>
// WLSEL<114>	WLSEL<114>
// WLSEL<113>	WLSEL<113>
// WLSEL<112>	WLSEL<112>
// WLSEL<111>	WLSEL<111>
// WLSEL<110>	WLSEL<110>
// WLSEL<109>	WLSEL<109>
// WLSEL<701>	WLSEL<701>
// WLSEL<700>	WLSEL<700>
// WLSEL<699>	WLSEL<699>
// WLSEL<698>	WLSEL<698>
// WLSEL<697>	WLSEL<697>
// WLSEL<696>	WLSEL<696>
// WLSEL<695>	WLSEL<695>
// WLSEL<694>	WLSEL<694>
// WLSEL<693>	WLSEL<693>
// WLSEL<692>	WLSEL<692>
// WLSEL<691>	WLSEL<691>
// WLSEL<690>	WLSEL<690>
// WLSEL<689>	WLSEL<689>
// WLSEL<688>	WLSEL<688>
// WLSEL<687>	WLSEL<687>
// WLSEL<686>	WLSEL<686>
// WLSEL<685>	WLSEL<685>
// WLSEL<684>	WLSEL<684>
// WLSEL<683>	WLSEL<683>
// WLSEL<682>	WLSEL<682>
// WLSEL<681>	WLSEL<681>
// WLSEL<680>	WLSEL<680>
// WLSEL<679>	WLSEL<679>
// WLSEL<678>	WLSEL<678>
// WLSEL<677>	WLSEL<677>
// WLSEL<676>	WLSEL<676>
// WLSEL<675>	WLSEL<675>
// WLSEL<674>	WLSEL<674>
// WLSEL<673>	WLSEL<673>
// WLSEL<672>	WLSEL<672>
// WLSEL<671>	WLSEL<671>
// WLSEL<670>	WLSEL<670>
// WLSEL<669>	WLSEL<669>
// WLSEL<668>	WLSEL<668>
// WLSEL<667>	WLSEL<667>
// WLSEL<666>	WLSEL<666>
// WLSEL<665>	WLSEL<665>
// WLSEL<664>	WLSEL<664>
// WLSEL<663>	WLSEL<663>
// WLSEL<662>	WLSEL<662>
// WLSEL<661>	WLSEL<661>
// WLSEL<660>	WLSEL<660>
// WLSEL<659>	WLSEL<659>
// WLSEL<658>	WLSEL<658>
// WLSEL<657>	WLSEL<657>
// WLSEL<656>	WLSEL<656>
// WLSEL<655>	WLSEL<655>
// WLSEL<654>	WLSEL<654>
// WLSEL<653>	WLSEL<653>
// WLSEL<652>	WLSEL<652>
// WLSEL<651>	WLSEL<651>
// WLSEL<650>	WLSEL<650>
// WLSEL<649>	WLSEL<649>
// WLSEL<648>	WLSEL<648>
// WLSEL<647>	WLSEL<647>
// WLSEL<646>	WLSEL<646>
// WLSEL<645>	WLSEL<645>
// WLSEL<644>	WLSEL<644>
// WLSEL<643>	WLSEL<643>
// WLSEL<642>	WLSEL<642>
// WLSEL<641>	WLSEL<641>
// WLSEL<640>	WLSEL<640>
// WLSEL<639>	WLSEL<639>
// WLSEL<638>	WLSEL<638>
// WLSEL<637>	WLSEL<637>
// WLSEL<636>	WLSEL<636>
// WLSEL<635>	WLSEL<635>
// WLSEL<634>	WLSEL<634>
// WLSEL<633>	WLSEL<633>
// WLSEL<632>	WLSEL<632>
// WLSEL<631>	WLSEL<631>
// WLSEL<630>	WLSEL<630>
// WLSEL<629>	WLSEL<629>
// WLSEL<628>	WLSEL<628>
// WLSEL<627>	WLSEL<627>
// WLSEL<626>	WLSEL<626>
// WLSEL<625>	WLSEL<625>
// WLSEL<624>	WLSEL<624>
// WLSEL<623>	WLSEL<623>
// WLSEL<622>	WLSEL<622>
// WLSEL<621>	WLSEL<621>
// WLSEL<1213>	WLSEL<1213>
// WLSEL<1212>	WLSEL<1212>
// WLSEL<1211>	WLSEL<1211>
// WLSEL<1210>	WLSEL<1210>
// WLSEL<1209>	WLSEL<1209>
// WLSEL<1208>	WLSEL<1208>
// WLSEL<1207>	WLSEL<1207>
// WLSEL<1206>	WLSEL<1206>
// WLSEL<1205>	WLSEL<1205>
// WLSEL<1204>	WLSEL<1204>
// WLSEL<1203>	WLSEL<1203>
// WLSEL<1202>	WLSEL<1202>
// WLSEL<1201>	WLSEL<1201>
// WLSEL<1200>	WLSEL<1200>
// WLSEL<1199>	WLSEL<1199>
// WLSEL<1198>	WLSEL<1198>
// WLSEL<1197>	WLSEL<1197>
// WLSEL<1196>	WLSEL<1196>
// WLSEL<1195>	WLSEL<1195>
// WLSEL<1194>	WLSEL<1194>
// WLSEL<1193>	WLSEL<1193>
// WLSEL<1192>	WLSEL<1192>
// WLSEL<1191>	WLSEL<1191>
// WLSEL<1190>	WLSEL<1190>
// WLSEL<1189>	WLSEL<1189>
// WLSEL<1188>	WLSEL<1188>
// WLSEL<1187>	WLSEL<1187>
// WLSEL<1186>	WLSEL<1186>
// WLSEL<1185>	WLSEL<1185>
// WLSEL<1184>	WLSEL<1184>
// WLSEL<1183>	WLSEL<1183>
// WLSEL<1182>	WLSEL<1182>
// WLSEL<1181>	WLSEL<1181>
// WLSEL<1180>	WLSEL<1180>
// WLSEL<1179>	WLSEL<1179>
// WLSEL<1178>	WLSEL<1178>
// WLSEL<1177>	WLSEL<1177>
// WLSEL<1176>	WLSEL<1176>
// WLSEL<1175>	WLSEL<1175>
// WLSEL<1174>	WLSEL<1174>
// WLSEL<1173>	WLSEL<1173>
// WLSEL<1172>	WLSEL<1172>
// WLSEL<1171>	WLSEL<1171>
// WLSEL<1170>	WLSEL<1170>
// WLSEL<1169>	WLSEL<1169>
// WLSEL<1168>	WLSEL<1168>
// WLSEL<1167>	WLSEL<1167>
// WLSEL<1166>	WLSEL<1166>
// WLSEL<1165>	WLSEL<1165>
// WLSEL<1164>	WLSEL<1164>
// WLSEL<1163>	WLSEL<1163>
// WLSEL<1162>	WLSEL<1162>
// WLSEL<1161>	WLSEL<1161>
// WLSEL<1160>	WLSEL<1160>
// WLSEL<1159>	WLSEL<1159>
// WLSEL<1158>	WLSEL<1158>
// WLSEL<1157>	WLSEL<1157>
// WLSEL<1156>	WLSEL<1156>
// WLSEL<1155>	WLSEL<1155>
// WLSEL<1154>	WLSEL<1154>
// WLSEL<1153>	WLSEL<1153>
// WLSEL<1152>	WLSEL<1152>
// WLSEL<1151>	WLSEL<1151>
// WLSEL<1150>	WLSEL<1150>
// WLSEL<1149>	WLSEL<1149>
// WLSEL<1148>	WLSEL<1148>
// WLSEL<1147>	WLSEL<1147>
// WLSEL<1146>	WLSEL<1146>
// WLSEL<1145>	WLSEL<1145>
// WLSEL<1144>	WLSEL<1144>
// WLSEL<1143>	WLSEL<1143>
// WLSEL<1142>	WLSEL<1142>
// WLSEL<1141>	WLSEL<1141>
// WLSEL<1140>	WLSEL<1140>
// WLSEL<1139>	WLSEL<1139>
// WLSEL<1138>	WLSEL<1138>
// WLSEL<1137>	WLSEL<1137>
// WLSEL<1136>	WLSEL<1136>
// WLSEL<1135>	WLSEL<1135>
// WLSEL<1134>	WLSEL<1134>
// WLSEL<1133>	WLSEL<1133>
// WLSEL<1725>	WLSEL<1725>
// WLSEL<1724>	WLSEL<1724>
// WLSEL<1723>	WLSEL<1723>
// WLSEL<1722>	WLSEL<1722>
// WLSEL<1721>	WLSEL<1721>
// WLSEL<1720>	WLSEL<1720>
// WLSEL<1719>	WLSEL<1719>
// WLSEL<1718>	WLSEL<1718>
// WLSEL<1717>	WLSEL<1717>
// WLSEL<1716>	WLSEL<1716>
// WLSEL<1715>	WLSEL<1715>
// WLSEL<1714>	WLSEL<1714>
// WLSEL<1713>	WLSEL<1713>
// WLSEL<1712>	WLSEL<1712>
// WLSEL<1711>	WLSEL<1711>
// WLSEL<1710>	WLSEL<1710>
// WLSEL<1709>	WLSEL<1709>
// WLSEL<1708>	WLSEL<1708>
// WLSEL<1707>	WLSEL<1707>
// WLSEL<1706>	WLSEL<1706>
// WLSEL<1705>	WLSEL<1705>
// WLSEL<1704>	WLSEL<1704>
// WLSEL<1703>	WLSEL<1703>
// WLSEL<1702>	WLSEL<1702>
// WLSEL<1701>	WLSEL<1701>
// WLSEL<1700>	WLSEL<1700>
// WLSEL<1699>	WLSEL<1699>
// WLSEL<1698>	WLSEL<1698>
// WLSEL<1697>	WLSEL<1697>
// WLSEL<1696>	WLSEL<1696>
// WLSEL<1695>	WLSEL<1695>
// WLSEL<1694>	WLSEL<1694>
// WLSEL<1693>	WLSEL<1693>
// WLSEL<1692>	WLSEL<1692>
// WLSEL<1691>	WLSEL<1691>
// WLSEL<1690>	WLSEL<1690>
// WLSEL<1689>	WLSEL<1689>
// WLSEL<1688>	WLSEL<1688>
// WLSEL<1687>	WLSEL<1687>
// WLSEL<1686>	WLSEL<1686>
// WLSEL<1685>	WLSEL<1685>
// WLSEL<1684>	WLSEL<1684>
// WLSEL<1683>	WLSEL<1683>
// WLSEL<1682>	WLSEL<1682>
// WLSEL<1681>	WLSEL<1681>
// WLSEL<1680>	WLSEL<1680>
// WLSEL<1679>	WLSEL<1679>
// WLSEL<1678>	WLSEL<1678>
// WLSEL<1677>	WLSEL<1677>
// WLSEL<1676>	WLSEL<1676>
// WLSEL<1675>	WLSEL<1675>
// WLSEL<1674>	WLSEL<1674>
// WLSEL<1673>	WLSEL<1673>
// WLSEL<1672>	WLSEL<1672>
// WLSEL<1671>	WLSEL<1671>
// WLSEL<1670>	WLSEL<1670>
// WLSEL<1669>	WLSEL<1669>
// WLSEL<1668>	WLSEL<1668>
// WLSEL<1667>	WLSEL<1667>
// WLSEL<1666>	WLSEL<1666>
// WLSEL<1665>	WLSEL<1665>
// WLSEL<1664>	WLSEL<1664>
// WLSEL<1663>	WLSEL<1663>
// WLSEL<1662>	WLSEL<1662>
// WLSEL<1661>	WLSEL<1661>
// WLSEL<1660>	WLSEL<1660>
// WLSEL<1659>	WLSEL<1659>
// WLSEL<1658>	WLSEL<1658>
// WLSEL<1657>	WLSEL<1657>
// WLSEL<1656>	WLSEL<1656>
// WLSEL<1655>	WLSEL<1655>
// WLSEL<1654>	WLSEL<1654>
// WLSEL<1653>	WLSEL<1653>
// WLSEL<1652>	WLSEL<1652>
// WLSEL<1651>	WLSEL<1651>
// WLSEL<1650>	WLSEL<1650>
// WLSEL<1649>	WLSEL<1649>
// WLSEL<1648>	WLSEL<1648>
// WLSEL<1647>	WLSEL<1647>
// WLSEL<1646>	WLSEL<1646>
// WLSEL<1645>	WLSEL<1645>
// WLSEL<269>	WLSEL<269>
// WLSEL<268>	WLSEL<268>
// WLSEL<267>	WLSEL<267>
// WLSEL<266>	WLSEL<266>
// WLSEL<265>	WLSEL<265>
// WLSEL<264>	WLSEL<264>
// WLSEL<263>	WLSEL<263>
// WLSEL<262>	WLSEL<262>
// WLSEL<261>	WLSEL<261>
// WLSEL<260>	WLSEL<260>
// WLSEL<259>	WLSEL<259>
// WLSEL<258>	WLSEL<258>
// WLSEL<257>	WLSEL<257>
// WLSEL<256>	WLSEL<256>
// WLSEL<255>	WLSEL<255>
// WLSEL<254>	WLSEL<254>
// WLSEL<253>	WLSEL<253>
// WLSEL<252>	WLSEL<252>
// WLSEL<251>	WLSEL<251>
// WLSEL<250>	WLSEL<250>
// WLSEL<249>	WLSEL<249>
// WLSEL<248>	WLSEL<248>
// WLSEL<247>	WLSEL<247>
// WLSEL<246>	WLSEL<246>
// WLSEL<245>	WLSEL<245>
// WLSEL<244>	WLSEL<244>
// WLSEL<243>	WLSEL<243>
// WLSEL<242>	WLSEL<242>
// WLSEL<241>	WLSEL<241>
// WLSEL<240>	WLSEL<240>
// WLSEL<239>	WLSEL<239>
// WLSEL<238>	WLSEL<238>
// WLSEL<237>	WLSEL<237>
// WLSEL<236>	WLSEL<236>
// WLSEL<235>	WLSEL<235>
// WLSEL<234>	WLSEL<234>
// WLSEL<233>	WLSEL<233>
// WLSEL<232>	WLSEL<232>
// WLSEL<231>	WLSEL<231>
// WLSEL<230>	WLSEL<230>
// WLSEL<229>	WLSEL<229>
// WLSEL<228>	WLSEL<228>
// WLSEL<227>	WLSEL<227>
// WLSEL<226>	WLSEL<226>
// WLSEL<225>	WLSEL<225>
// WLSEL<224>	WLSEL<224>
// WLSEL<223>	WLSEL<223>
// WLSEL<222>	WLSEL<222>
// WLSEL<221>	WLSEL<221>
// WLSEL<220>	WLSEL<220>
// WLSEL<219>	WLSEL<219>
// WLSEL<218>	WLSEL<218>
// WLSEL<217>	WLSEL<217>
// WLSEL<216>	WLSEL<216>
// WLSEL<215>	WLSEL<215>
// WLSEL<214>	WLSEL<214>
// WLSEL<213>	WLSEL<213>
// WLSEL<212>	WLSEL<212>
// WLSEL<211>	WLSEL<211>
// WLSEL<210>	WLSEL<210>
// WLSEL<209>	WLSEL<209>
// WLSEL<208>	WLSEL<208>
// WLSEL<207>	WLSEL<207>
// WLSEL<206>	WLSEL<206>
// WLSEL<205>	WLSEL<205>
// WLSEL<204>	WLSEL<204>
// WLSEL<203>	WLSEL<203>
// WLSEL<202>	WLSEL<202>
// WLSEL<201>	WLSEL<201>
// WLSEL<200>	WLSEL<200>
// WLSEL<199>	WLSEL<199>
// WLSEL<198>	WLSEL<198>
// WLSEL<197>	WLSEL<197>
// WLSEL<196>	WLSEL<196>
// WLSEL<195>	WLSEL<195>
// WLSEL<194>	WLSEL<194>
// WLSEL<193>	WLSEL<193>
// WLSEL<192>	WLSEL<192>
// WLSEL<191>	WLSEL<191>
// WLSEL<190>	WLSEL<190>
// WLSEL<781>	WLSEL<781>
// WLSEL<780>	WLSEL<780>
// WLSEL<779>	WLSEL<779>
// WLSEL<778>	WLSEL<778>
// WLSEL<777>	WLSEL<777>
// WLSEL<776>	WLSEL<776>
// WLSEL<775>	WLSEL<775>
// WLSEL<774>	WLSEL<774>
// WLSEL<773>	WLSEL<773>
// WLSEL<772>	WLSEL<772>
// WLSEL<771>	WLSEL<771>
// WLSEL<770>	WLSEL<770>
// WLSEL<769>	WLSEL<769>
// WLSEL<768>	WLSEL<768>
// WLSEL<767>	WLSEL<767>
// WLSEL<766>	WLSEL<766>
// WLSEL<765>	WLSEL<765>
// WLSEL<764>	WLSEL<764>
// WLSEL<763>	WLSEL<763>
// WLSEL<762>	WLSEL<762>
// WLSEL<761>	WLSEL<761>
// WLSEL<760>	WLSEL<760>
// WLSEL<759>	WLSEL<759>
// WLSEL<758>	WLSEL<758>
// WLSEL<757>	WLSEL<757>
// WLSEL<756>	WLSEL<756>
// WLSEL<755>	WLSEL<755>
// WLSEL<754>	WLSEL<754>
// WLSEL<753>	WLSEL<753>
// WLSEL<752>	WLSEL<752>
// WLSEL<751>	WLSEL<751>
// WLSEL<750>	WLSEL<750>
// WLSEL<749>	WLSEL<749>
// WLSEL<748>	WLSEL<748>
// WLSEL<747>	WLSEL<747>
// WLSEL<746>	WLSEL<746>
// WLSEL<745>	WLSEL<745>
// WLSEL<744>	WLSEL<744>
// WLSEL<743>	WLSEL<743>
// WLSEL<742>	WLSEL<742>
// WLSEL<741>	WLSEL<741>
// WLSEL<740>	WLSEL<740>
// WLSEL<739>	WLSEL<739>
// WLSEL<738>	WLSEL<738>
// WLSEL<737>	WLSEL<737>
// WLSEL<736>	WLSEL<736>
// WLSEL<735>	WLSEL<735>
// WLSEL<734>	WLSEL<734>
// WLSEL<733>	WLSEL<733>
// WLSEL<732>	WLSEL<732>
// WLSEL<731>	WLSEL<731>
// WLSEL<730>	WLSEL<730>
// WLSEL<729>	WLSEL<729>
// WLSEL<728>	WLSEL<728>
// WLSEL<727>	WLSEL<727>
// WLSEL<726>	WLSEL<726>
// WLSEL<725>	WLSEL<725>
// WLSEL<724>	WLSEL<724>
// WLSEL<723>	WLSEL<723>
// WLSEL<722>	WLSEL<722>
// WLSEL<721>	WLSEL<721>
// WLSEL<720>	WLSEL<720>
// WLSEL<719>	WLSEL<719>
// WLSEL<718>	WLSEL<718>
// WLSEL<717>	WLSEL<717>
// WLSEL<716>	WLSEL<716>
// WLSEL<715>	WLSEL<715>
// WLSEL<714>	WLSEL<714>
// WLSEL<713>	WLSEL<713>
// WLSEL<712>	WLSEL<712>
// WLSEL<711>	WLSEL<711>
// WLSEL<710>	WLSEL<710>
// WLSEL<709>	WLSEL<709>
// WLSEL<708>	WLSEL<708>
// WLSEL<707>	WLSEL<707>
// WLSEL<706>	WLSEL<706>
// WLSEL<705>	WLSEL<705>
// WLSEL<704>	WLSEL<704>
// WLSEL<703>	WLSEL<703>
// WLSEL<702>	WLSEL<702>
// WLSEL<1293>	WLSEL<1293>
// WLSEL<1292>	WLSEL<1292>
// WLSEL<1291>	WLSEL<1291>
// WLSEL<1290>	WLSEL<1290>
// WLSEL<1289>	WLSEL<1289>
// WLSEL<1288>	WLSEL<1288>
// WLSEL<1287>	WLSEL<1287>
// WLSEL<1286>	WLSEL<1286>
// WLSEL<1285>	WLSEL<1285>
// WLSEL<1284>	WLSEL<1284>
// WLSEL<1283>	WLSEL<1283>
// WLSEL<1282>	WLSEL<1282>
// WLSEL<1281>	WLSEL<1281>
// WLSEL<1280>	WLSEL<1280>
// WLSEL<1279>	WLSEL<1279>
// WLSEL<1278>	WLSEL<1278>
// WLSEL<1277>	WLSEL<1277>
// WLSEL<1276>	WLSEL<1276>
// WLSEL<1275>	WLSEL<1275>
// WLSEL<1274>	WLSEL<1274>
// WLSEL<1273>	WLSEL<1273>
// WLSEL<1272>	WLSEL<1272>
// WLSEL<1271>	WLSEL<1271>
// WLSEL<1270>	WLSEL<1270>
// WLSEL<1269>	WLSEL<1269>
// WLSEL<1268>	WLSEL<1268>
// WLSEL<1267>	WLSEL<1267>
// WLSEL<1266>	WLSEL<1266>
// WLSEL<1265>	WLSEL<1265>
// WLSEL<1264>	WLSEL<1264>
// WLSEL<1263>	WLSEL<1263>
// WLSEL<1262>	WLSEL<1262>
// WLSEL<1261>	WLSEL<1261>
// WLSEL<1260>	WLSEL<1260>
// WLSEL<1259>	WLSEL<1259>
// WLSEL<1258>	WLSEL<1258>
// WLSEL<1257>	WLSEL<1257>
// WLSEL<1256>	WLSEL<1256>
// WLSEL<1255>	WLSEL<1255>
// WLSEL<1254>	WLSEL<1254>
// WLSEL<1253>	WLSEL<1253>
// WLSEL<1252>	WLSEL<1252>
// WLSEL<1251>	WLSEL<1251>
// WLSEL<1250>	WLSEL<1250>
// WLSEL<1249>	WLSEL<1249>
// WLSEL<1248>	WLSEL<1248>
// WLSEL<1247>	WLSEL<1247>
// WLSEL<1246>	WLSEL<1246>
// WLSEL<1245>	WLSEL<1245>
// WLSEL<1244>	WLSEL<1244>
// WLSEL<1243>	WLSEL<1243>
// WLSEL<1242>	WLSEL<1242>
// WLSEL<1241>	WLSEL<1241>
// WLSEL<1240>	WLSEL<1240>
// WLSEL<1239>	WLSEL<1239>
// WLSEL<1238>	WLSEL<1238>
// WLSEL<1237>	WLSEL<1237>
// WLSEL<1236>	WLSEL<1236>
// WLSEL<1235>	WLSEL<1235>
// WLSEL<1234>	WLSEL<1234>
// WLSEL<1233>	WLSEL<1233>
// WLSEL<1232>	WLSEL<1232>
// WLSEL<1231>	WLSEL<1231>
// WLSEL<1230>	WLSEL<1230>
// WLSEL<1229>	WLSEL<1229>
// WLSEL<1228>	WLSEL<1228>
// WLSEL<1227>	WLSEL<1227>
// WLSEL<1226>	WLSEL<1226>
// WLSEL<1225>	WLSEL<1225>
// WLSEL<1224>	WLSEL<1224>
// WLSEL<1223>	WLSEL<1223>
// WLSEL<1222>	WLSEL<1222>
// WLSEL<1221>	WLSEL<1221>
// WLSEL<1220>	WLSEL<1220>
// WLSEL<1219>	WLSEL<1219>
// WLSEL<1218>	WLSEL<1218>
// WLSEL<1217>	WLSEL<1217>
// WLSEL<1216>	WLSEL<1216>
// WLSEL<1215>	WLSEL<1215>
// WLSEL<1214>	WLSEL<1214>
// WLSEL<1805>	WLSEL<1805>
// WLSEL<1804>	WLSEL<1804>
// WLSEL<1803>	WLSEL<1803>
// WLSEL<1802>	WLSEL<1802>
// WLSEL<1801>	WLSEL<1801>
// WLSEL<1800>	WLSEL<1800>
// WLSEL<1799>	WLSEL<1799>
// WLSEL<1798>	WLSEL<1798>
// WLSEL<1797>	WLSEL<1797>
// WLSEL<1796>	WLSEL<1796>
// WLSEL<1795>	WLSEL<1795>
// WLSEL<1794>	WLSEL<1794>
// WLSEL<1793>	WLSEL<1793>
// WLSEL<1792>	WLSEL<1792>
// WLSEL<1791>	WLSEL<1791>
// WLSEL<1790>	WLSEL<1790>
// WLSEL<1789>	WLSEL<1789>
// WLSEL<1788>	WLSEL<1788>
// WLSEL<1787>	WLSEL<1787>
// WLSEL<1786>	WLSEL<1786>
// WLSEL<1785>	WLSEL<1785>
// WLSEL<1784>	WLSEL<1784>
// WLSEL<1783>	WLSEL<1783>
// WLSEL<1782>	WLSEL<1782>
// WLSEL<1781>	WLSEL<1781>
// WLSEL<1780>	WLSEL<1780>
// WLSEL<1779>	WLSEL<1779>
// WLSEL<1778>	WLSEL<1778>
// WLSEL<1777>	WLSEL<1777>
// WLSEL<1776>	WLSEL<1776>
// WLSEL<1775>	WLSEL<1775>
// WLSEL<1774>	WLSEL<1774>
// WLSEL<1773>	WLSEL<1773>
// WLSEL<1772>	WLSEL<1772>
// WLSEL<1771>	WLSEL<1771>
// WLSEL<1770>	WLSEL<1770>
// WLSEL<1769>	WLSEL<1769>
// WLSEL<1768>	WLSEL<1768>
// WLSEL<1767>	WLSEL<1767>
// WLSEL<1766>	WLSEL<1766>
// WLSEL<1765>	WLSEL<1765>
// WLSEL<1764>	WLSEL<1764>
// WLSEL<1763>	WLSEL<1763>
// WLSEL<1762>	WLSEL<1762>
// WLSEL<1761>	WLSEL<1761>
// WLSEL<1760>	WLSEL<1760>
// WLSEL<1759>	WLSEL<1759>
// WLSEL<1758>	WLSEL<1758>
// WLSEL<1757>	WLSEL<1757>
// WLSEL<1756>	WLSEL<1756>
// WLSEL<1755>	WLSEL<1755>
// WLSEL<1754>	WLSEL<1754>
// WLSEL<1753>	WLSEL<1753>
// WLSEL<1752>	WLSEL<1752>
// WLSEL<1751>	WLSEL<1751>
// WLSEL<1750>	WLSEL<1750>
// WLSEL<1749>	WLSEL<1749>
// WLSEL<1748>	WLSEL<1748>
// WLSEL<1747>	WLSEL<1747>
// WLSEL<1746>	WLSEL<1746>
// WLSEL<1745>	WLSEL<1745>
// WLSEL<1744>	WLSEL<1744>
// WLSEL<1743>	WLSEL<1743>
// WLSEL<1742>	WLSEL<1742>
// WLSEL<1741>	WLSEL<1741>
// WLSEL<1740>	WLSEL<1740>
// WLSEL<1739>	WLSEL<1739>
// WLSEL<1738>	WLSEL<1738>
// WLSEL<1737>	WLSEL<1737>
// WLSEL<1736>	WLSEL<1736>
// WLSEL<1735>	WLSEL<1735>
// WLSEL<1734>	WLSEL<1734>
// WLSEL<1733>	WLSEL<1733>
// WLSEL<1732>	WLSEL<1732>
// WLSEL<1731>	WLSEL<1731>
// WLSEL<1730>	WLSEL<1730>
// WLSEL<1729>	WLSEL<1729>
// WLSEL<1728>	WLSEL<1728>
// WLSEL<1727>	WLSEL<1727>
// WLSEL<1726>	WLSEL<1726>
// SEL5<0>	SEL5<0>
// WLSEL<350>	WLSEL<350>
// WLSEL<349>	WLSEL<349>
// WLSEL<348>	WLSEL<348>
// WLSEL<347>	WLSEL<347>
// WLSEL<346>	WLSEL<346>
// WLSEL<345>	WLSEL<345>
// WLSEL<344>	WLSEL<344>
// WLSEL<343>	WLSEL<343>
// WLSEL<342>	WLSEL<342>
// WLSEL<341>	WLSEL<341>
// WLSEL<340>	WLSEL<340>
// WLSEL<339>	WLSEL<339>
// WLSEL<338>	WLSEL<338>
// WLSEL<337>	WLSEL<337>
// WLSEL<336>	WLSEL<336>
// WLSEL<335>	WLSEL<335>
// WLSEL<334>	WLSEL<334>
// WLSEL<333>	WLSEL<333>
// WLSEL<332>	WLSEL<332>
// WLSEL<331>	WLSEL<331>
// WLSEL<330>	WLSEL<330>
// WLSEL<329>	WLSEL<329>
// WLSEL<328>	WLSEL<328>
// WLSEL<327>	WLSEL<327>
// WLSEL<326>	WLSEL<326>
// WLSEL<325>	WLSEL<325>
// WLSEL<324>	WLSEL<324>
// WLSEL<323>	WLSEL<323>
// WLSEL<322>	WLSEL<322>
// WLSEL<321>	WLSEL<321>
// WLSEL<320>	WLSEL<320>
// WLSEL<319>	WLSEL<319>
// WLSEL<318>	WLSEL<318>
// WLSEL<317>	WLSEL<317>
// WLSEL<316>	WLSEL<316>
// WLSEL<315>	WLSEL<315>
// WLSEL<314>	WLSEL<314>
// WLSEL<313>	WLSEL<313>
// WLSEL<312>	WLSEL<312>
// WLSEL<311>	WLSEL<311>
// WLSEL<310>	WLSEL<310>
// WLSEL<309>	WLSEL<309>
// WLSEL<308>	WLSEL<308>
// WLSEL<307>	WLSEL<307>
// WLSEL<306>	WLSEL<306>
// WLSEL<305>	WLSEL<305>
// WLSEL<304>	WLSEL<304>
// WLSEL<303>	WLSEL<303>
// WLSEL<302>	WLSEL<302>
// WLSEL<301>	WLSEL<301>
// WLSEL<300>	WLSEL<300>
// WLSEL<299>	WLSEL<299>
// WLSEL<298>	WLSEL<298>
// WLSEL<297>	WLSEL<297>
// WLSEL<296>	WLSEL<296>
// WLSEL<295>	WLSEL<295>
// WLSEL<294>	WLSEL<294>
// WLSEL<293>	WLSEL<293>
// WLSEL<292>	WLSEL<292>
// WLSEL<291>	WLSEL<291>
// WLSEL<290>	WLSEL<290>
// WLSEL<289>	WLSEL<289>
// WLSEL<288>	WLSEL<288>
// WLSEL<287>	WLSEL<287>
// WLSEL<286>	WLSEL<286>
// WLSEL<285>	WLSEL<285>
// WLSEL<284>	WLSEL<284>
// WLSEL<283>	WLSEL<283>
// WLSEL<282>	WLSEL<282>
// WLSEL<281>	WLSEL<281>
// WLSEL<280>	WLSEL<280>
// WLSEL<279>	WLSEL<279>
// WLSEL<278>	WLSEL<278>
// WLSEL<277>	WLSEL<277>
// WLSEL<276>	WLSEL<276>
// WLSEL<275>	WLSEL<275>
// WLSEL<274>	WLSEL<274>
// WLSEL<273>	WLSEL<273>
// WLSEL<272>	WLSEL<272>
// WLSEL<271>	WLSEL<271>
// WLSEL<270>	WLSEL<270>
// WLSEL<862>	WLSEL<862>
// WLSEL<861>	WLSEL<861>
// WLSEL<860>	WLSEL<860>
// WLSEL<859>	WLSEL<859>
// WLSEL<858>	WLSEL<858>
// WLSEL<857>	WLSEL<857>
// WLSEL<856>	WLSEL<856>
// WLSEL<855>	WLSEL<855>
// WLSEL<854>	WLSEL<854>
// WLSEL<853>	WLSEL<853>
// WLSEL<852>	WLSEL<852>
// WLSEL<851>	WLSEL<851>
// WLSEL<850>	WLSEL<850>
// WLSEL<849>	WLSEL<849>
// WLSEL<848>	WLSEL<848>
// WLSEL<847>	WLSEL<847>
// WLSEL<846>	WLSEL<846>
// WLSEL<845>	WLSEL<845>
// WLSEL<844>	WLSEL<844>
// WLSEL<843>	WLSEL<843>
// WLSEL<842>	WLSEL<842>
// WLSEL<841>	WLSEL<841>
// WLSEL<840>	WLSEL<840>
// WLSEL<839>	WLSEL<839>
// WLSEL<838>	WLSEL<838>
// WLSEL<837>	WLSEL<837>
// WLSEL<836>	WLSEL<836>
// WLSEL<835>	WLSEL<835>
// WLSEL<834>	WLSEL<834>
// WLSEL<833>	WLSEL<833>
// WLSEL<832>	WLSEL<832>
// WLSEL<831>	WLSEL<831>
// WLSEL<830>	WLSEL<830>
// WLSEL<829>	WLSEL<829>
// WLSEL<828>	WLSEL<828>
// WLSEL<827>	WLSEL<827>
// WLSEL<826>	WLSEL<826>
// WLSEL<825>	WLSEL<825>
// WLSEL<824>	WLSEL<824>
// WLSEL<823>	WLSEL<823>
// WLSEL<822>	WLSEL<822>
// WLSEL<821>	WLSEL<821>
// WLSEL<820>	WLSEL<820>
// WLSEL<819>	WLSEL<819>
// WLSEL<818>	WLSEL<818>
// WLSEL<817>	WLSEL<817>
// WLSEL<816>	WLSEL<816>
// WLSEL<815>	WLSEL<815>
// WLSEL<814>	WLSEL<814>
// WLSEL<813>	WLSEL<813>
// WLSEL<812>	WLSEL<812>
// WLSEL<811>	WLSEL<811>
// WLSEL<810>	WLSEL<810>
// WLSEL<809>	WLSEL<809>
// WLSEL<808>	WLSEL<808>
// WLSEL<807>	WLSEL<807>
// WLSEL<806>	WLSEL<806>
// WLSEL<805>	WLSEL<805>
// WLSEL<804>	WLSEL<804>
// WLSEL<803>	WLSEL<803>
// WLSEL<802>	WLSEL<802>
// WLSEL<801>	WLSEL<801>
// WLSEL<800>	WLSEL<800>
// WLSEL<799>	WLSEL<799>
// WLSEL<798>	WLSEL<798>
// WLSEL<797>	WLSEL<797>
// WLSEL<796>	WLSEL<796>
// WLSEL<795>	WLSEL<795>
// WLSEL<794>	WLSEL<794>
// WLSEL<793>	WLSEL<793>
// WLSEL<792>	WLSEL<792>
// WLSEL<791>	WLSEL<791>
// WLSEL<790>	WLSEL<790>
// WLSEL<789>	WLSEL<789>
// WLSEL<788>	WLSEL<788>
// WLSEL<787>	WLSEL<787>
// WLSEL<786>	WLSEL<786>
// WLSEL<785>	WLSEL<785>
// WLSEL<784>	WLSEL<784>
// WLSEL<783>	WLSEL<783>
// WLSEL<782>	WLSEL<782>
// WLSEL<1374>	WLSEL<1374>
// WLSEL<1373>	WLSEL<1373>
// WLSEL<1372>	WLSEL<1372>
// WLSEL<1371>	WLSEL<1371>
// WLSEL<1370>	WLSEL<1370>
// WLSEL<1369>	WLSEL<1369>
// WLSEL<1368>	WLSEL<1368>
// WLSEL<1367>	WLSEL<1367>
// WLSEL<1366>	WLSEL<1366>
// WLSEL<1365>	WLSEL<1365>
// WLSEL<1364>	WLSEL<1364>
// WLSEL<1363>	WLSEL<1363>
// WLSEL<1362>	WLSEL<1362>
// WLSEL<1361>	WLSEL<1361>
// WLSEL<1360>	WLSEL<1360>
// WLSEL<1359>	WLSEL<1359>
// WLSEL<1358>	WLSEL<1358>
// WLSEL<1357>	WLSEL<1357>
// WLSEL<1356>	WLSEL<1356>
// WLSEL<1355>	WLSEL<1355>
// WLSEL<1354>	WLSEL<1354>
// WLSEL<1353>	WLSEL<1353>
// WLSEL<1352>	WLSEL<1352>
// WLSEL<1351>	WLSEL<1351>
// WLSEL<1350>	WLSEL<1350>
// WLSEL<1349>	WLSEL<1349>
// WLSEL<1348>	WLSEL<1348>
// WLSEL<1347>	WLSEL<1347>
// WLSEL<1346>	WLSEL<1346>
// WLSEL<1345>	WLSEL<1345>
// WLSEL<1344>	WLSEL<1344>
// WLSEL<1343>	WLSEL<1343>
// WLSEL<1342>	WLSEL<1342>
// WLSEL<1341>	WLSEL<1341>
// WLSEL<1340>	WLSEL<1340>
// WLSEL<1339>	WLSEL<1339>
// WLSEL<1338>	WLSEL<1338>
// WLSEL<1337>	WLSEL<1337>
// WLSEL<1336>	WLSEL<1336>
// WLSEL<1335>	WLSEL<1335>
// WLSEL<1334>	WLSEL<1334>
// WLSEL<1333>	WLSEL<1333>
// WLSEL<1332>	WLSEL<1332>
// WLSEL<1331>	WLSEL<1331>
// WLSEL<1330>	WLSEL<1330>
// WLSEL<1329>	WLSEL<1329>
// WLSEL<1328>	WLSEL<1328>
// WLSEL<1327>	WLSEL<1327>
// WLSEL<1326>	WLSEL<1326>
// WLSEL<1325>	WLSEL<1325>
// WLSEL<1324>	WLSEL<1324>
// WLSEL<1323>	WLSEL<1323>
// WLSEL<1322>	WLSEL<1322>
// WLSEL<1321>	WLSEL<1321>
// WLSEL<1320>	WLSEL<1320>
// WLSEL<1319>	WLSEL<1319>
// WLSEL<1318>	WLSEL<1318>
// WLSEL<1317>	WLSEL<1317>
// WLSEL<1316>	WLSEL<1316>
// WLSEL<1315>	WLSEL<1315>
// WLSEL<1314>	WLSEL<1314>
// WLSEL<1313>	WLSEL<1313>
// WLSEL<1312>	WLSEL<1312>
// WLSEL<1311>	WLSEL<1311>
// WLSEL<1310>	WLSEL<1310>
// WLSEL<1309>	WLSEL<1309>
// WLSEL<1308>	WLSEL<1308>
// WLSEL<1307>	WLSEL<1307>
// WLSEL<1306>	WLSEL<1306>
// WLSEL<1305>	WLSEL<1305>
// WLSEL<1304>	WLSEL<1304>
// WLSEL<1303>	WLSEL<1303>
// WLSEL<1302>	WLSEL<1302>
// WLSEL<1301>	WLSEL<1301>
// WLSEL<1300>	WLSEL<1300>
// WLSEL<1299>	WLSEL<1299>
// WLSEL<1298>	WLSEL<1298>
// WLSEL<1297>	WLSEL<1297>
// WLSEL<1296>	WLSEL<1296>
// WLSEL<1295>	WLSEL<1295>
// WLSEL<1294>	WLSEL<1294>
// WLSEL<1886>	WLSEL<1886>
// WLSEL<1885>	WLSEL<1885>
// WLSEL<1884>	WLSEL<1884>
// WLSEL<1883>	WLSEL<1883>
// WLSEL<1882>	WLSEL<1882>
// WLSEL<1881>	WLSEL<1881>
// WLSEL<1880>	WLSEL<1880>
// WLSEL<1879>	WLSEL<1879>
// WLSEL<1878>	WLSEL<1878>
// WLSEL<1877>	WLSEL<1877>
// WLSEL<1876>	WLSEL<1876>
// WLSEL<1875>	WLSEL<1875>
// WLSEL<1874>	WLSEL<1874>
// WLSEL<1873>	WLSEL<1873>
// WLSEL<1872>	WLSEL<1872>
// WLSEL<1871>	WLSEL<1871>
// WLSEL<1870>	WLSEL<1870>
// WLSEL<1869>	WLSEL<1869>
// WLSEL<1868>	WLSEL<1868>
// WLSEL<1867>	WLSEL<1867>
// WLSEL<1866>	WLSEL<1866>
// WLSEL<1865>	WLSEL<1865>
// WLSEL<1864>	WLSEL<1864>
// WLSEL<1863>	WLSEL<1863>
// WLSEL<1862>	WLSEL<1862>
// WLSEL<1861>	WLSEL<1861>
// WLSEL<1860>	WLSEL<1860>
// WLSEL<1859>	WLSEL<1859>
// WLSEL<1858>	WLSEL<1858>
// WLSEL<1857>	WLSEL<1857>
// WLSEL<1856>	WLSEL<1856>
// WLSEL<1855>	WLSEL<1855>
// WLSEL<1854>	WLSEL<1854>
// WLSEL<1853>	WLSEL<1853>
// WLSEL<1852>	WLSEL<1852>
// WLSEL<1851>	WLSEL<1851>
// WLSEL<1850>	WLSEL<1850>
// WLSEL<1849>	WLSEL<1849>
// WLSEL<1848>	WLSEL<1848>
// WLSEL<1847>	WLSEL<1847>
// WLSEL<1846>	WLSEL<1846>
// WLSEL<1845>	WLSEL<1845>
// WLSEL<1844>	WLSEL<1844>
// WLSEL<1843>	WLSEL<1843>
// WLSEL<1842>	WLSEL<1842>
// WLSEL<1841>	WLSEL<1841>
// WLSEL<1840>	WLSEL<1840>
// WLSEL<1839>	WLSEL<1839>
// WLSEL<1838>	WLSEL<1838>
// WLSEL<1837>	WLSEL<1837>
// WLSEL<1836>	WLSEL<1836>
// WLSEL<1835>	WLSEL<1835>
// WLSEL<1834>	WLSEL<1834>
// WLSEL<1833>	WLSEL<1833>
// WLSEL<1832>	WLSEL<1832>
// WLSEL<1831>	WLSEL<1831>
// WLSEL<1830>	WLSEL<1830>
// WLSEL<1829>	WLSEL<1829>
// WLSEL<1828>	WLSEL<1828>
// WLSEL<1827>	WLSEL<1827>
// WLSEL<1826>	WLSEL<1826>
// WLSEL<1825>	WLSEL<1825>
// WLSEL<1824>	WLSEL<1824>
// WLSEL<1823>	WLSEL<1823>
// WLSEL<1822>	WLSEL<1822>
// WLSEL<1821>	WLSEL<1821>
// WLSEL<1820>	WLSEL<1820>
// WLSEL<1819>	WLSEL<1819>
// WLSEL<1818>	WLSEL<1818>
// WLSEL<1817>	WLSEL<1817>
// WLSEL<1816>	WLSEL<1816>
// WLSEL<1815>	WLSEL<1815>
// WLSEL<1814>	WLSEL<1814>
// WLSEL<1813>	WLSEL<1813>
// WLSEL<1812>	WLSEL<1812>
// WLSEL<1811>	WLSEL<1811>
// WLSEL<1810>	WLSEL<1810>
// WLSEL<1809>	WLSEL<1809>
// WLSEL<1808>	WLSEL<1808>
// WLSEL<1807>	WLSEL<1807>
// WLSEL<1806>	WLSEL<1806>
// WLSEL<430>	WLSEL<430>
// WLSEL<429>	WLSEL<429>
// WLSEL<428>	WLSEL<428>
// WLSEL<427>	WLSEL<427>
// WLSEL<426>	WLSEL<426>
// WLSEL<425>	WLSEL<425>
// WLSEL<424>	WLSEL<424>
// WLSEL<423>	WLSEL<423>
// WLSEL<422>	WLSEL<422>
// WLSEL<421>	WLSEL<421>
// WLSEL<420>	WLSEL<420>
// WLSEL<419>	WLSEL<419>
// WLSEL<418>	WLSEL<418>
// WLSEL<417>	WLSEL<417>
// WLSEL<416>	WLSEL<416>
// WLSEL<415>	WLSEL<415>
// WLSEL<414>	WLSEL<414>
// WLSEL<413>	WLSEL<413>
// WLSEL<412>	WLSEL<412>
// WLSEL<411>	WLSEL<411>
// WLSEL<410>	WLSEL<410>
// WLSEL<409>	WLSEL<409>
// WLSEL<408>	WLSEL<408>
// WLSEL<407>	WLSEL<407>
// WLSEL<406>	WLSEL<406>
// WLSEL<405>	WLSEL<405>
// WLSEL<404>	WLSEL<404>
// WLSEL<403>	WLSEL<403>
// WLSEL<402>	WLSEL<402>
// WLSEL<401>	WLSEL<401>
// WLSEL<400>	WLSEL<400>
// WLSEL<399>	WLSEL<399>
// WLSEL<398>	WLSEL<398>
// WLSEL<397>	WLSEL<397>
// WLSEL<396>	WLSEL<396>
// WLSEL<395>	WLSEL<395>
// WLSEL<394>	WLSEL<394>
// WLSEL<393>	WLSEL<393>
// WLSEL<392>	WLSEL<392>
// WLSEL<391>	WLSEL<391>
// WLSEL<390>	WLSEL<390>
// WLSEL<389>	WLSEL<389>
// WLSEL<388>	WLSEL<388>
// WLSEL<387>	WLSEL<387>
// WLSEL<386>	WLSEL<386>
// WLSEL<385>	WLSEL<385>
// WLSEL<384>	WLSEL<384>
// WLSEL<383>	WLSEL<383>
// WLSEL<382>	WLSEL<382>
// WLSEL<381>	WLSEL<381>
// WLSEL<380>	WLSEL<380>
// WLSEL<379>	WLSEL<379>
// WLSEL<378>	WLSEL<378>
// WLSEL<377>	WLSEL<377>
// WLSEL<376>	WLSEL<376>
// WLSEL<375>	WLSEL<375>
// WLSEL<374>	WLSEL<374>
// WLSEL<373>	WLSEL<373>
// WLSEL<372>	WLSEL<372>
// WLSEL<371>	WLSEL<371>
// WLSEL<370>	WLSEL<370>
// WLSEL<369>	WLSEL<369>
// WLSEL<368>	WLSEL<368>
// WLSEL<367>	WLSEL<367>
// WLSEL<366>	WLSEL<366>
// WLSEL<365>	WLSEL<365>
// WLSEL<364>	WLSEL<364>
// WLSEL<363>	WLSEL<363>
// WLSEL<362>	WLSEL<362>
// WLSEL<361>	WLSEL<361>
// WLSEL<360>	WLSEL<360>
// WLSEL<359>	WLSEL<359>
// WLSEL<358>	WLSEL<358>
// WLSEL<357>	WLSEL<357>
// WLSEL<356>	WLSEL<356>
// WLSEL<355>	WLSEL<355>
// WLSEL<354>	WLSEL<354>
// WLSEL<353>	WLSEL<353>
// WLSEL<352>	WLSEL<352>
// WLSEL<351>	WLSEL<351>
// WLSEL<942>	WLSEL<942>
// WLSEL<941>	WLSEL<941>
// WLSEL<940>	WLSEL<940>
// WLSEL<939>	WLSEL<939>
// WLSEL<938>	WLSEL<938>
// WLSEL<937>	WLSEL<937>
// WLSEL<936>	WLSEL<936>
// WLSEL<935>	WLSEL<935>
// WLSEL<934>	WLSEL<934>
// WLSEL<933>	WLSEL<933>
// WLSEL<932>	WLSEL<932>
// WLSEL<931>	WLSEL<931>
// WLSEL<930>	WLSEL<930>
// WLSEL<929>	WLSEL<929>
// WLSEL<928>	WLSEL<928>
// WLSEL<927>	WLSEL<927>
// WLSEL<926>	WLSEL<926>
// WLSEL<925>	WLSEL<925>
// WLSEL<924>	WLSEL<924>
// WLSEL<923>	WLSEL<923>
// WLSEL<922>	WLSEL<922>
// WLSEL<921>	WLSEL<921>
// WLSEL<920>	WLSEL<920>
// WLSEL<919>	WLSEL<919>
// WLSEL<918>	WLSEL<918>
// WLSEL<917>	WLSEL<917>
// WLSEL<916>	WLSEL<916>
// WLSEL<915>	WLSEL<915>
// WLSEL<914>	WLSEL<914>
// WLSEL<913>	WLSEL<913>
// WLSEL<912>	WLSEL<912>
// WLSEL<911>	WLSEL<911>
// WLSEL<910>	WLSEL<910>
// WLSEL<909>	WLSEL<909>
// WLSEL<908>	WLSEL<908>
// WLSEL<907>	WLSEL<907>
// WLSEL<906>	WLSEL<906>
// WLSEL<905>	WLSEL<905>
// WLSEL<904>	WLSEL<904>
// WLSEL<903>	WLSEL<903>
// WLSEL<902>	WLSEL<902>
// WLSEL<901>	WLSEL<901>
// WLSEL<900>	WLSEL<900>
// WLSEL<899>	WLSEL<899>
// WLSEL<898>	WLSEL<898>
// WLSEL<897>	WLSEL<897>
// WLSEL<896>	WLSEL<896>
// WLSEL<895>	WLSEL<895>
// WLSEL<894>	WLSEL<894>
// WLSEL<893>	WLSEL<893>
// WLSEL<892>	WLSEL<892>
// WLSEL<891>	WLSEL<891>
// WLSEL<890>	WLSEL<890>
// WLSEL<889>	WLSEL<889>
// WLSEL<888>	WLSEL<888>
// WLSEL<887>	WLSEL<887>
// WLSEL<886>	WLSEL<886>
// WLSEL<885>	WLSEL<885>
// WLSEL<884>	WLSEL<884>
// WLSEL<883>	WLSEL<883>
// WLSEL<882>	WLSEL<882>
// WLSEL<881>	WLSEL<881>
// WLSEL<880>	WLSEL<880>
// WLSEL<879>	WLSEL<879>
// WLSEL<878>	WLSEL<878>
// WLSEL<877>	WLSEL<877>
// WLSEL<876>	WLSEL<876>
// WLSEL<875>	WLSEL<875>
// WLSEL<874>	WLSEL<874>
// WLSEL<873>	WLSEL<873>
// WLSEL<872>	WLSEL<872>
// WLSEL<871>	WLSEL<871>
// WLSEL<870>	WLSEL<870>
// WLSEL<869>	WLSEL<869>
// WLSEL<868>	WLSEL<868>
// WLSEL<867>	WLSEL<867>
// WLSEL<866>	WLSEL<866>
// WLSEL<865>	WLSEL<865>
// WLSEL<864>	WLSEL<864>
// WLSEL<863>	WLSEL<863>
// WLSEL<1454>	WLSEL<1454>
// WLSEL<1453>	WLSEL<1453>
// WLSEL<1452>	WLSEL<1452>
// WLSEL<1451>	WLSEL<1451>
// WLSEL<1450>	WLSEL<1450>
// WLSEL<1449>	WLSEL<1449>
// WLSEL<1448>	WLSEL<1448>
// WLSEL<1447>	WLSEL<1447>
// WLSEL<1446>	WLSEL<1446>
// WLSEL<1445>	WLSEL<1445>
// WLSEL<1444>	WLSEL<1444>
// WLSEL<1443>	WLSEL<1443>
// WLSEL<1442>	WLSEL<1442>
// WLSEL<1441>	WLSEL<1441>
// WLSEL<1440>	WLSEL<1440>
// WLSEL<1439>	WLSEL<1439>
// WLSEL<1438>	WLSEL<1438>
// WLSEL<1437>	WLSEL<1437>
// WLSEL<1436>	WLSEL<1436>
// WLSEL<1435>	WLSEL<1435>
// WLSEL<1434>	WLSEL<1434>
// WLSEL<1433>	WLSEL<1433>
// WLSEL<1432>	WLSEL<1432>
// WLSEL<1431>	WLSEL<1431>
// WLSEL<1430>	WLSEL<1430>
// WLSEL<1429>	WLSEL<1429>
// WLSEL<1428>	WLSEL<1428>
// WLSEL<1427>	WLSEL<1427>
// WLSEL<1426>	WLSEL<1426>
// WLSEL<1425>	WLSEL<1425>
// WLSEL<1424>	WLSEL<1424>
// WLSEL<1423>	WLSEL<1423>
// WLSEL<1422>	WLSEL<1422>
// WLSEL<1421>	WLSEL<1421>
// WLSEL<1420>	WLSEL<1420>
// WLSEL<1419>	WLSEL<1419>
// WLSEL<1418>	WLSEL<1418>
// WLSEL<1417>	WLSEL<1417>
// WLSEL<1416>	WLSEL<1416>
// WLSEL<1415>	WLSEL<1415>
// WLSEL<1414>	WLSEL<1414>
// WLSEL<1413>	WLSEL<1413>
// WLSEL<1412>	WLSEL<1412>
// WLSEL<1411>	WLSEL<1411>
// WLSEL<1410>	WLSEL<1410>
// WLSEL<1409>	WLSEL<1409>
// WLSEL<1408>	WLSEL<1408>
// WLSEL<1407>	WLSEL<1407>
// WLSEL<1406>	WLSEL<1406>
// WLSEL<1405>	WLSEL<1405>
// WLSEL<1404>	WLSEL<1404>
// WLSEL<1403>	WLSEL<1403>
// WLSEL<1402>	WLSEL<1402>
// WLSEL<1401>	WLSEL<1401>
// WLSEL<1400>	WLSEL<1400>
// WLSEL<1399>	WLSEL<1399>
// WLSEL<1398>	WLSEL<1398>
// WLSEL<1397>	WLSEL<1397>
// WLSEL<1396>	WLSEL<1396>
// WLSEL<1395>	WLSEL<1395>
// WLSEL<1394>	WLSEL<1394>
// WLSEL<1393>	WLSEL<1393>
// WLSEL<1392>	WLSEL<1392>
// WLSEL<1391>	WLSEL<1391>
// WLSEL<1390>	WLSEL<1390>
// WLSEL<1389>	WLSEL<1389>
// WLSEL<1388>	WLSEL<1388>
// WLSEL<1387>	WLSEL<1387>
// WLSEL<1386>	WLSEL<1386>
// WLSEL<1385>	WLSEL<1385>
// WLSEL<1384>	WLSEL<1384>
// WLSEL<1383>	WLSEL<1383>
// WLSEL<1382>	WLSEL<1382>
// WLSEL<1381>	WLSEL<1381>
// WLSEL<1380>	WLSEL<1380>
// WLSEL<1379>	WLSEL<1379>
// WLSEL<1378>	WLSEL<1378>
// WLSEL<1377>	WLSEL<1377>
// WLSEL<1376>	WLSEL<1376>
// WLSEL<1375>	WLSEL<1375>
// WLSEL<1966>	WLSEL<1966>
// WLSEL<1965>	WLSEL<1965>
// WLSEL<1964>	WLSEL<1964>
// WLSEL<1963>	WLSEL<1963>
// WLSEL<1962>	WLSEL<1962>
// WLSEL<1961>	WLSEL<1961>
// WLSEL<1960>	WLSEL<1960>
// WLSEL<1959>	WLSEL<1959>
// WLSEL<1958>	WLSEL<1958>
// WLSEL<1957>	WLSEL<1957>
// WLSEL<1956>	WLSEL<1956>
// WLSEL<1955>	WLSEL<1955>
// WLSEL<1954>	WLSEL<1954>
// WLSEL<1953>	WLSEL<1953>
// WLSEL<1952>	WLSEL<1952>
// WLSEL<1951>	WLSEL<1951>
// WLSEL<1950>	WLSEL<1950>
// WLSEL<1949>	WLSEL<1949>
// WLSEL<1948>	WLSEL<1948>
// WLSEL<1947>	WLSEL<1947>
// WLSEL<1946>	WLSEL<1946>
// WLSEL<1945>	WLSEL<1945>
// WLSEL<1944>	WLSEL<1944>
// WLSEL<1943>	WLSEL<1943>
// WLSEL<1942>	WLSEL<1942>
// WLSEL<1941>	WLSEL<1941>
// WLSEL<1940>	WLSEL<1940>
// WLSEL<1939>	WLSEL<1939>
// WLSEL<1938>	WLSEL<1938>
// WLSEL<1937>	WLSEL<1937>
// WLSEL<1936>	WLSEL<1936>
// WLSEL<1935>	WLSEL<1935>
// WLSEL<1934>	WLSEL<1934>
// WLSEL<1933>	WLSEL<1933>
// WLSEL<1932>	WLSEL<1932>
// WLSEL<1931>	WLSEL<1931>
// WLSEL<1930>	WLSEL<1930>
// WLSEL<1929>	WLSEL<1929>
// WLSEL<1928>	WLSEL<1928>
// WLSEL<1927>	WLSEL<1927>
// WLSEL<1926>	WLSEL<1926>
// WLSEL<1925>	WLSEL<1925>
// WLSEL<1924>	WLSEL<1924>
// WLSEL<1923>	WLSEL<1923>
// WLSEL<1922>	WLSEL<1922>
// WLSEL<1921>	WLSEL<1921>
// WLSEL<1920>	WLSEL<1920>
// WLSEL<1919>	WLSEL<1919>
// WLSEL<1918>	WLSEL<1918>
// WLSEL<1917>	WLSEL<1917>
// WLSEL<1916>	WLSEL<1916>
// WLSEL<1915>	WLSEL<1915>
// WLSEL<1914>	WLSEL<1914>
// WLSEL<1913>	WLSEL<1913>
// WLSEL<1912>	WLSEL<1912>
// WLSEL<1911>	WLSEL<1911>
// WLSEL<1910>	WLSEL<1910>
// WLSEL<1909>	WLSEL<1909>
// WLSEL<1908>	WLSEL<1908>
// WLSEL<1907>	WLSEL<1907>
// WLSEL<1906>	WLSEL<1906>
// WLSEL<1905>	WLSEL<1905>
// WLSEL<1904>	WLSEL<1904>
// WLSEL<1903>	WLSEL<1903>
// WLSEL<1902>	WLSEL<1902>
// WLSEL<1901>	WLSEL<1901>
// WLSEL<1900>	WLSEL<1900>
// WLSEL<1899>	WLSEL<1899>
// WLSEL<1898>	WLSEL<1898>
// WLSEL<1897>	WLSEL<1897>
// WLSEL<1896>	WLSEL<1896>
// WLSEL<1895>	WLSEL<1895>
// WLSEL<1894>	WLSEL<1894>
// WLSEL<1893>	WLSEL<1893>
// WLSEL<1892>	WLSEL<1892>
// WLSEL<1891>	WLSEL<1891>
// WLSEL<1890>	WLSEL<1890>
// WLSEL<1889>	WLSEL<1889>
// WLSEL<1888>	WLSEL<1888>
// WLSEL<1887>	WLSEL<1887>
// SEL4<0>	SEL4<0>
// WLSEL<511>	WLSEL<511>
// WLSEL<510>	WLSEL<510>
// WLSEL<509>	WLSEL<509>
// WLSEL<508>	WLSEL<508>
// WLSEL<507>	WLSEL<507>
// WLSEL<506>	WLSEL<506>
// WLSEL<505>	WLSEL<505>
// WLSEL<504>	WLSEL<504>
// WLSEL<503>	WLSEL<503>
// WLSEL<502>	WLSEL<502>
// WLSEL<501>	WLSEL<501>
// WLSEL<500>	WLSEL<500>
// WLSEL<499>	WLSEL<499>
// WLSEL<498>	WLSEL<498>
// WLSEL<497>	WLSEL<497>
// WLSEL<496>	WLSEL<496>
// WLSEL<495>	WLSEL<495>
// WLSEL<494>	WLSEL<494>
// WLSEL<493>	WLSEL<493>
// WLSEL<492>	WLSEL<492>
// WLSEL<491>	WLSEL<491>
// WLSEL<490>	WLSEL<490>
// WLSEL<489>	WLSEL<489>
// WLSEL<488>	WLSEL<488>
// WLSEL<487>	WLSEL<487>
// WLSEL<486>	WLSEL<486>
// WLSEL<485>	WLSEL<485>
// WLSEL<484>	WLSEL<484>
// WLSEL<483>	WLSEL<483>
// WLSEL<482>	WLSEL<482>
// WLSEL<481>	WLSEL<481>
// WLSEL<480>	WLSEL<480>
// WLSEL<479>	WLSEL<479>
// WLSEL<478>	WLSEL<478>
// WLSEL<477>	WLSEL<477>
// WLSEL<476>	WLSEL<476>
// WLSEL<475>	WLSEL<475>
// WLSEL<474>	WLSEL<474>
// WLSEL<473>	WLSEL<473>
// WLSEL<472>	WLSEL<472>
// WLSEL<471>	WLSEL<471>
// WLSEL<470>	WLSEL<470>
// WLSEL<469>	WLSEL<469>
// WLSEL<468>	WLSEL<468>
// WLSEL<467>	WLSEL<467>
// WLSEL<466>	WLSEL<466>
// WLSEL<465>	WLSEL<465>
// WLSEL<464>	WLSEL<464>
// WLSEL<463>	WLSEL<463>
// WLSEL<462>	WLSEL<462>
// WLSEL<461>	WLSEL<461>
// WLSEL<460>	WLSEL<460>
// WLSEL<459>	WLSEL<459>
// WLSEL<458>	WLSEL<458>
// WLSEL<457>	WLSEL<457>
// WLSEL<456>	WLSEL<456>
// WLSEL<455>	WLSEL<455>
// WLSEL<454>	WLSEL<454>
// WLSEL<453>	WLSEL<453>
// WLSEL<452>	WLSEL<452>
// WLSEL<451>	WLSEL<451>
// WLSEL<450>	WLSEL<450>
// WLSEL<449>	WLSEL<449>
// WLSEL<448>	WLSEL<448>
// WLSEL<447>	WLSEL<447>
// WLSEL<446>	WLSEL<446>
// WLSEL<445>	WLSEL<445>
// WLSEL<444>	WLSEL<444>
// WLSEL<443>	WLSEL<443>
// WLSEL<442>	WLSEL<442>
// WLSEL<441>	WLSEL<441>
// WLSEL<440>	WLSEL<440>
// WLSEL<439>	WLSEL<439>
// WLSEL<438>	WLSEL<438>
// WLSEL<437>	WLSEL<437>
// WLSEL<436>	WLSEL<436>
// WLSEL<435>	WLSEL<435>
// WLSEL<434>	WLSEL<434>
// WLSEL<433>	WLSEL<433>
// WLSEL<432>	WLSEL<432>
// WLSEL<431>	WLSEL<431>
// WLSEL<1023>	WLSEL<1023>
// WLSEL<1022>	WLSEL<1022>
// WLSEL<1021>	WLSEL<1021>
// WLSEL<1020>	WLSEL<1020>
// WLSEL<1019>	WLSEL<1019>
// WLSEL<1018>	WLSEL<1018>
// WLSEL<1017>	WLSEL<1017>
// WLSEL<1016>	WLSEL<1016>
// WLSEL<1015>	WLSEL<1015>
// WLSEL<1014>	WLSEL<1014>
// WLSEL<1013>	WLSEL<1013>
// WLSEL<1012>	WLSEL<1012>
// WLSEL<1011>	WLSEL<1011>
// WLSEL<1010>	WLSEL<1010>
// WLSEL<1009>	WLSEL<1009>
// WLSEL<1008>	WLSEL<1008>
// WLSEL<1007>	WLSEL<1007>
// WLSEL<1006>	WLSEL<1006>
// WLSEL<1005>	WLSEL<1005>
// WLSEL<1004>	WLSEL<1004>
// WLSEL<1003>	WLSEL<1003>
// WLSEL<1002>	WLSEL<1002>
// WLSEL<1001>	WLSEL<1001>
// WLSEL<1000>	WLSEL<1000>
// WLSEL<999>	WLSEL<999>
// WLSEL<998>	WLSEL<998>
// WLSEL<997>	WLSEL<997>
// WLSEL<996>	WLSEL<996>
// WLSEL<995>	WLSEL<995>
// WLSEL<994>	WLSEL<994>
// WLSEL<993>	WLSEL<993>
// WLSEL<992>	WLSEL<992>
// WLSEL<991>	WLSEL<991>
// WLSEL<990>	WLSEL<990>
// WLSEL<989>	WLSEL<989>
// WLSEL<988>	WLSEL<988>
// WLSEL<987>	WLSEL<987>
// WLSEL<986>	WLSEL<986>
// WLSEL<985>	WLSEL<985>
// WLSEL<984>	WLSEL<984>
// WLSEL<983>	WLSEL<983>
// WLSEL<982>	WLSEL<982>
// WLSEL<981>	WLSEL<981>
// WLSEL<980>	WLSEL<980>
// WLSEL<979>	WLSEL<979>
// WLSEL<978>	WLSEL<978>
// WLSEL<977>	WLSEL<977>
// WLSEL<976>	WLSEL<976>
// WLSEL<975>	WLSEL<975>
// WLSEL<974>	WLSEL<974>
// WLSEL<973>	WLSEL<973>
// WLSEL<972>	WLSEL<972>
// WLSEL<971>	WLSEL<971>
// WLSEL<970>	WLSEL<970>
// WLSEL<969>	WLSEL<969>
// WLSEL<968>	WLSEL<968>
// WLSEL<967>	WLSEL<967>
// WLSEL<966>	WLSEL<966>
// WLSEL<965>	WLSEL<965>
// WLSEL<964>	WLSEL<964>
// WLSEL<963>	WLSEL<963>
// WLSEL<962>	WLSEL<962>
// WLSEL<961>	WLSEL<961>
// WLSEL<960>	WLSEL<960>
// WLSEL<959>	WLSEL<959>
// WLSEL<958>	WLSEL<958>
// WLSEL<957>	WLSEL<957>
// WLSEL<956>	WLSEL<956>
// WLSEL<955>	WLSEL<955>
// WLSEL<954>	WLSEL<954>
// WLSEL<953>	WLSEL<953>
// WLSEL<952>	WLSEL<952>
// WLSEL<951>	WLSEL<951>
// WLSEL<950>	WLSEL<950>
// WLSEL<949>	WLSEL<949>
// WLSEL<948>	WLSEL<948>
// WLSEL<947>	WLSEL<947>
// WLSEL<946>	WLSEL<946>
// WLSEL<945>	WLSEL<945>
// WLSEL<944>	WLSEL<944>
// WLSEL<943>	WLSEL<943>
// SEL7<0>	SEL7<0>
// WLSEL<1535>	WLSEL<1535>
// WLSEL<1534>	WLSEL<1534>
// WLSEL<1533>	WLSEL<1533>
// WLSEL<1532>	WLSEL<1532>
// WLSEL<1531>	WLSEL<1531>
// WLSEL<1530>	WLSEL<1530>
// WLSEL<1529>	WLSEL<1529>
// WLSEL<1528>	WLSEL<1528>
// WLSEL<1527>	WLSEL<1527>
// WLSEL<1526>	WLSEL<1526>
// WLSEL<1525>	WLSEL<1525>
// WLSEL<1524>	WLSEL<1524>
// WLSEL<1523>	WLSEL<1523>
// WLSEL<1522>	WLSEL<1522>
// WLSEL<1521>	WLSEL<1521>
// WLSEL<1520>	WLSEL<1520>
// WLSEL<1519>	WLSEL<1519>
// WLSEL<1518>	WLSEL<1518>
// WLSEL<1517>	WLSEL<1517>
// WLSEL<1516>	WLSEL<1516>
// WLSEL<1515>	WLSEL<1515>
// WLSEL<1514>	WLSEL<1514>
// WLSEL<1513>	WLSEL<1513>
// WLSEL<1512>	WLSEL<1512>
// WLSEL<1511>	WLSEL<1511>
// WLSEL<1510>	WLSEL<1510>
// WLSEL<1509>	WLSEL<1509>
// WLSEL<1508>	WLSEL<1508>
// WLSEL<1507>	WLSEL<1507>
// WLSEL<1506>	WLSEL<1506>
// WLSEL<1505>	WLSEL<1505>
// WLSEL<1504>	WLSEL<1504>
// WLSEL<1503>	WLSEL<1503>
// WLSEL<1502>	WLSEL<1502>
// WLSEL<1501>	WLSEL<1501>
// WLSEL<1500>	WLSEL<1500>
// WLSEL<1499>	WLSEL<1499>
// WLSEL<1498>	WLSEL<1498>
// WLSEL<1497>	WLSEL<1497>
// WLSEL<1496>	WLSEL<1496>
// WLSEL<1495>	WLSEL<1495>
// WLSEL<1494>	WLSEL<1494>
// WLSEL<1493>	WLSEL<1493>
// WLSEL<1492>	WLSEL<1492>
// WLSEL<1491>	WLSEL<1491>
// WLSEL<1490>	WLSEL<1490>
// WLSEL<1489>	WLSEL<1489>
// WLSEL<1488>	WLSEL<1488>
// WLSEL<1487>	WLSEL<1487>
// WLSEL<1486>	WLSEL<1486>
// WLSEL<1485>	WLSEL<1485>
// WLSEL<1484>	WLSEL<1484>
// WLSEL<1483>	WLSEL<1483>
// WLSEL<1482>	WLSEL<1482>
// WLSEL<1481>	WLSEL<1481>
// WLSEL<1480>	WLSEL<1480>
// WLSEL<1479>	WLSEL<1479>
// WLSEL<1478>	WLSEL<1478>
// WLSEL<1477>	WLSEL<1477>
// WLSEL<1476>	WLSEL<1476>
// WLSEL<1475>	WLSEL<1475>
// WLSEL<1474>	WLSEL<1474>
// WLSEL<1473>	WLSEL<1473>
// WLSEL<1472>	WLSEL<1472>
// WLSEL<1471>	WLSEL<1471>
// WLSEL<1470>	WLSEL<1470>
// WLSEL<1469>	WLSEL<1469>
// WLSEL<1468>	WLSEL<1468>
// WLSEL<1467>	WLSEL<1467>
// WLSEL<1466>	WLSEL<1466>
// WLSEL<1465>	WLSEL<1465>
// WLSEL<1464>	WLSEL<1464>
// WLSEL<1463>	WLSEL<1463>
// WLSEL<1462>	WLSEL<1462>
// WLSEL<1461>	WLSEL<1461>
// WLSEL<1460>	WLSEL<1460>
// WLSEL<1459>	WLSEL<1459>
// WLSEL<1458>	WLSEL<1458>
// WLSEL<1457>	WLSEL<1457>
// WLSEL<1456>	WLSEL<1456>
// WLSEL<1455>	WLSEL<1455>
// SEL6<0>	SEL6<0>
// WLSEL<2047>	WLSEL<2047>
// WLSEL<2046>	WLSEL<2046>
// WLSEL<2045>	WLSEL<2045>
// WLSEL<2044>	WLSEL<2044>
// WLSEL<2043>	WLSEL<2043>
// WLSEL<2042>	WLSEL<2042>
// WLSEL<2041>	WLSEL<2041>
// WLSEL<2040>	WLSEL<2040>
// WLSEL<2039>	WLSEL<2039>
// WLSEL<2038>	WLSEL<2038>
// WLSEL<2037>	WLSEL<2037>
// WLSEL<2036>	WLSEL<2036>
// WLSEL<2035>	WLSEL<2035>
// WLSEL<2034>	WLSEL<2034>
// WLSEL<2033>	WLSEL<2033>
// WLSEL<2032>	WLSEL<2032>
// WLSEL<2031>	WLSEL<2031>
// WLSEL<2030>	WLSEL<2030>
// WLSEL<2029>	WLSEL<2029>
// WLSEL<2028>	WLSEL<2028>
// WLSEL<2027>	WLSEL<2027>
// WLSEL<2026>	WLSEL<2026>
// WLSEL<2025>	WLSEL<2025>
// WLSEL<2024>	WLSEL<2024>
// WLSEL<2023>	WLSEL<2023>
// WLSEL<2022>	WLSEL<2022>
// WLSEL<2021>	WLSEL<2021>
// WLSEL<2020>	WLSEL<2020>
// WLSEL<2019>	WLSEL<2019>
// WLSEL<2018>	WLSEL<2018>
// WLSEL<2017>	WLSEL<2017>
// WLSEL<2016>	WLSEL<2016>
// WLSEL<2015>	WLSEL<2015>
// WLSEL<2014>	WLSEL<2014>
// WLSEL<2013>	WLSEL<2013>
// WLSEL<2012>	WLSEL<2012>
// WLSEL<2011>	WLSEL<2011>
// WLSEL<2010>	WLSEL<2010>
// WLSEL<2009>	WLSEL<2009>
// WLSEL<2008>	WLSEL<2008>
// WLSEL<2007>	WLSEL<2007>
// WLSEL<2006>	WLSEL<2006>
// WLSEL<2005>	WLSEL<2005>
// WLSEL<2004>	WLSEL<2004>
// WLSEL<2003>	WLSEL<2003>
// WLSEL<2002>	WLSEL<2002>
// WLSEL<2001>	WLSEL<2001>
// WLSEL<2000>	WLSEL<2000>
// WLSEL<1999>	WLSEL<1999>
// WLSEL<1998>	WLSEL<1998>
// WLSEL<1997>	WLSEL<1997>
// WLSEL<1996>	WLSEL<1996>
// WLSEL<1995>	WLSEL<1995>
// WLSEL<1994>	WLSEL<1994>
// WLSEL<1993>	WLSEL<1993>
// WLSEL<1992>	WLSEL<1992>
// WLSEL<1991>	WLSEL<1991>
// WLSEL<1990>	WLSEL<1990>
// WLSEL<1989>	WLSEL<1989>
// WLSEL<1988>	WLSEL<1988>
// WLSEL<1987>	WLSEL<1987>
// WLSEL<1986>	WLSEL<1986>
// WLSEL<1985>	WLSEL<1985>
// WLSEL<1984>	WLSEL<1984>
// WLSEL<1983>	WLSEL<1983>
// WLSEL<1982>	WLSEL<1982>
// WLSEL<1981>	WLSEL<1981>
// WLSEL<1980>	WLSEL<1980>
// WLSEL<1979>	WLSEL<1979>
// WLSEL<1978>	WLSEL<1978>
// WLSEL<1977>	WLSEL<1977>
// WLSEL<1976>	WLSEL<1976>
// WLSEL<1975>	WLSEL<1975>
// WLSEL<1974>	WLSEL<1974>
// WLSEL<1973>	WLSEL<1973>
// WLSEL<1972>	WLSEL<1972>
// WLSEL<1971>	WLSEL<1971>
// WLSEL<1970>	WLSEL<1970>
// WLSEL<1969>	WLSEL<1969>
// WLSEL<1968>	WLSEL<1968>
// WLSEL<1967>	WLSEL<1967>
// SEL3<1>	SEL3<1>
// SEL2<0>	SEL2<0>
// SEL1<0>	SEL1<0>
// SEL0<1>	SEL0<1>
// SEL6<1>	SEL6<1>
// SEL5<1>	SEL5<1>
// SEL4<1>	SEL4<1>
// SEL3<0>	SEL3<0>
// SEL2<1>	SEL2<1>
// SEL1<1>	SEL1<1>
// SEL0<0>	SEL0<0>
// SEL7<1>	SEL7<1>
XXI2\<1\>\/XI2\<1\>\/XI2\<1\>\/XI2\<1\>\/XI2\<0\>\/XI2\<1\>\/XI2\<0\>\/XI2\<1\>\/RR5 \
 (  \
 N_SEL7\<1\>_XI2\<1\>\/XI2\<1\>\/XI2\<1\>\/XI2\<1\>\/XI2\<0\>\/XI2\<1\>\/XI2\<0\>\/XI2\<1\>\/RR5_pos \
 N_WLSEL\<1967\>_XI2\<1\>\/XI2\<1\>\/XI2\<1\>\/XI2\<1\>\/XI2\<0\>\/XI2\<1\>\/XI2\<0\>\/XI2\<1\>\/RR5_neg \
 ) R_1X_LL w=1e-07 l=1e-07   res=0.149966
XXI2\<1\>\/XI2\<0\>\/XI2\<1\>\/XI2\<1\>\/XI2\<0\>\/XI2\<1\>\/XI2\<0\>\/XI2\<1\>\/RR5 \
 (  \
 N_SEL7\<1\>_XI2\<1\>\/XI2\<0\>\/XI2\<1\>\/XI2\<1\>\/XI2\<0\>\/XI2\<1\>\/XI2\<0\>\/XI2\<1\>\/RR5_pos \
 N_WLSEL\<1455\>_XI2\<1\>\/XI2\<0\>\/XI2\<1\>\/XI2\<1\>\/XI2\<0\>\/XI2\<1\>\/XI2\<0\>\/XI2\<1\>\/RR5_neg \
 ) R_1X_LL w=1e-07 l=1e-07   res=0.149966
XXI2\<0\>\/XI2\<1\>\/XI2\<1\>\/XI2\<1\>\/XI2\<0\>\/XI2\<1\>\/XI2\<0\>\/XI2\<1\>\/RR5 \
 (  \
 N_SEL7\<0\>_XI2\<0\>\/XI2\<1\>\/XI2\<1\>\/XI2\<1\>\/XI2\<0\>\/XI2\<1\>\/XI2\<0\>\/XI2\<1\>\/RR5_pos \
 N_WLSEL\<943\>_XI2\<0\>\/XI2\<1\>\/XI2\<1\>\/XI2\<1\>\/XI2\<0\>\/XI2\<1\>\/XI2\<0\>\/XI2\<1\>\/RR5_neg \
 ) R_1X_LL w=1e-07 l=1e-07   res=0.149966
XXI2\<0\>\/XI2\<0\>\/XI2\<1\>\/XI2\<1\>\/XI2\<0\>\/XI2\<1\>\/XI2\<0\>\/XI2\<1\>\/RR5 \
 (  \
 N_SEL7\<0\>_XI2\<0\>\/XI2\<0\>\/XI2\<1\>\/XI2\<1\>\/XI2\<0\>\/XI2\<1\>\/XI2\<0\>\/XI2\<1\>\/RR5_pos \
 N_WLSEL\<431\>_XI2\<0\>\/XI2\<0\>\/XI2\<1\>\/XI2\<1\>\/XI2\<0\>\/XI2\<1\>\/XI2\<0\>\/XI2\<1\>\/RR5_neg \
 ) R_1X_LL w=1e-07 l=1e-07   res=0.149966
XXI2\<1\>\/XI2\<1\>\/XI2\<1\>\/XI2\<0\>\/XI2\<0\>\/XI2\<0\>\/XI2\<0\>\/XI2\<1\>\/RR6 \
 (  \
 N_SEL6\<1\>_XI2\<1\>\/XI2\<1\>\/XI2\<1\>\/XI2\<0\>\/XI2\<0\>\/XI2\<0\>\/XI2\<0\>\/XI2\<1\>\/RR6_pos \
 N_WLSEL\<1806\>_XI2\<1\>\/XI2\<1\>\/XI2\<1\>\/XI2\<0\>\/XI2\<0\>\/XI2\<0\>\/XI2\<0\>\/XI2\<1\>\/RR6_neg \
 ) R_1X_LL w=1e-07 l=1e-07   res=0.149966
XXI2\<1\>\/XI2\<0\>\/XI2\<1\>\/XI2\<0\>\/XI2\<0\>\/XI2\<0\>\/XI2\<0\>\/XI2\<1\>\/RR6 \
 (  \
 N_SEL6\<0\>_XI2\<1\>\/XI2\<0\>\/XI2\<1\>\/XI2\<0\>\/XI2\<0\>\/XI2\<0\>\/XI2\<0\>\/XI2\<1\>\/RR6_pos \
 N_WLSEL\<1294\>_XI2\<1\>\/XI2\<0\>\/XI2\<1\>\/XI2\<0\>\/XI2\<0\>\/XI2\<0\>\/XI2\<0\>\/XI2\<1\>\/RR6_neg \
 ) R_1X_LL w=1e-07 l=1e-07   res=0.149966
XXI2\<0\>\/XI2\<1\>\/XI2\<1\>\/XI2\<0\>\/XI2\<0\>\/XI2\<0\>\/XI2\<0\>\/XI2\<1\>\/RR6 \
 (  \
 N_SEL6\<1\>_XI2\<0\>\/XI2\<1\>\/XI2\<1\>\/XI2\<0\>\/XI2\<0\>\/XI2\<0\>\/XI2\<0\>\/XI2\<1\>\/RR6_pos \
 N_WLSEL\<782\>_XI2\<0\>\/XI2\<1\>\/XI2\<1\>\/XI2\<0\>\/XI2\<0\>\/XI2\<0\>\/XI2\<0\>\/XI2\<1\>\/RR6_neg \
 ) R_1X_LL w=1e-07 l=1e-07   res=0.149966
XXI2\<0\>\/XI2\<0\>\/XI2\<1\>\/XI2\<0\>\/XI2\<0\>\/XI2\<0\>\/XI2\<0\>\/XI2\<1\>\/RR6 \
 (  \
 N_SEL6\<0\>_XI2\<0\>\/XI2\<0\>\/XI2\<1\>\/XI2\<0\>\/XI2\<0\>\/XI2\<0\>\/XI2\<0\>\/XI2\<1\>\/RR6_pos \
 N_WLSEL\<270\>_XI2\<0\>\/XI2\<0\>\/XI2\<1\>\/XI2\<0\>\/XI2\<0\>\/XI2\<0\>\/XI2\<0\>\/XI2\<1\>\/RR6_neg \
 ) R_1X_LL w=1e-07 l=1e-07   res=0.149966
XXI2\<1\>\/XI2\<1\>\/XI2\<0\>\/XI2\<0\>\/XI2\<1\>\/XI2\<1\>\/XI2\<0\>\/XI2\<1\>\/RR7 \
 (  \
 N_SEL5\<0\>_XI2\<1\>\/XI2\<1\>\/XI2\<0\>\/XI2\<0\>\/XI2\<1\>\/XI2\<1\>\/XI2\<0\>\/XI2\<1\>\/RR7_pos \
 N_WLSEL\<1645\>_XI2\<1\>\/XI2\<1\>\/XI2\<0\>\/XI2\<0\>\/XI2\<1\>\/XI2\<1\>\/XI2\<0\>\/XI2\<1\>\/RR7_neg \
 ) R_1X_LL w=1e-07 l=1e-07   res=0.149966
XXI2\<1\>\/XI2\<0\>\/XI2\<0\>\/XI2\<0\>\/XI2\<1\>\/XI2\<1\>\/XI2\<0\>\/XI2\<1\>\/RR7 \
 (  \
 N_SEL5\<0\>_XI2\<1\>\/XI2\<0\>\/XI2\<0\>\/XI2\<0\>\/XI2\<1\>\/XI2\<1\>\/XI2\<0\>\/XI2\<1\>\/RR7_pos \
 N_WLSEL\<1133\>_XI2\<1\>\/XI2\<0\>\/XI2\<0\>\/XI2\<0\>\/XI2\<1\>\/XI2\<1\>\/XI2\<0\>\/XI2\<1\>\/RR7_neg \
 ) R_1X_LL w=1e-07 l=1e-07   res=0.149966
XXI2\<0\>\/XI2\<1\>\/XI2\<0\>\/XI2\<0\>\/XI2\<1\>\/XI2\<1\>\/XI2\<0\>\/XI2\<1\>\/RR7 \
 (  \
 N_SEL5\<0\>_XI2\<0\>\/XI2\<1\>\/XI2\<0\>\/XI2\<0\>\/XI2\<1\>\/XI2\<1\>\/XI2\<0\>\/XI2\<1\>\/RR7_pos \
 N_WLSEL\<621\>_XI2\<0\>\/XI2\<1\>\/XI2\<0\>\/XI2\<0\>\/XI2\<1\>\/XI2\<1\>\/XI2\<0\>\/XI2\<1\>\/RR7_neg \
 ) R_1X_LL w=1e-07 l=1e-07   res=0.149966
XXI2\<0\>\/XI2\<0\>\/XI2\<0\>\/XI2\<0\>\/XI2\<1\>\/XI2\<1\>\/XI2\<0\>\/XI2\<1\>\/RR7 \
 (  \
 N_SEL5\<0\>_XI2\<0\>\/XI2\<0\>\/XI2\<0\>\/XI2\<0\>\/XI2\<1\>\/XI2\<1\>\/XI2\<0\>\/XI2\<1\>\/RR7_pos \
 N_WLSEL\<109\>_XI2\<0\>\/XI2\<0\>\/XI2\<0\>\/XI2\<0\>\/XI2\<1\>\/XI2\<1\>\/XI2\<0\>\/XI2\<1\>\/RR7_neg \
 ) R_1X_LL w=1e-07 l=1e-07   res=0.149966
XXI2\<1\>\/XI2\<1\>\/XI2\<1\>\/XI2\<1\>\/XI2\<0\>\/XI2\<1\>\/XI2\<1\>\/XI2\<0\>\/RR0 \
 (  \
 N_SEL0\<0\>_XI2\<1\>\/XI2\<1\>\/XI2\<1\>\/XI2\<1\>\/XI2\<0\>\/XI2\<1\>\/XI2\<1\>\/XI2\<0\>\/RR0_pos \
 N_WLSEL\<1968\>_XI2\<1\>\/XI2\<1\>\/XI2\<1\>\/XI2\<1\>\/XI2\<0\>\/XI2\<1\>\/XI2\<1\>\/XI2\<0\>\/RR0_neg \
 ) R_1X_LL w=1e-07 l=1e-07   res=0.149966
XXI2\<1\>\/XI2\<1\>\/XI2\<1\>\/XI2\<1\>\/XI2\<0\>\/XI2\<1\>\/XI2\<1\>\/XI2\<0\>\/RR1 \
 (  \
 N_SEL1\<1\>_XI2\<1\>\/XI2\<1\>\/XI2\<1\>\/XI2\<1\>\/XI2\<0\>\/XI2\<1\>\/XI2\<1\>\/XI2\<0\>\/RR1_pos \
 N_WLSEL\<1969\>_XI2\<1\>\/XI2\<1\>\/XI2\<1\>\/XI2\<1\>\/XI2\<0\>\/XI2\<1\>\/XI2\<1\>\/XI2\<0\>\/RR1_neg \
 ) R_1X_LL w=1e-07 l=1e-07   res=0.149966
XXI2\<1\>\/XI2\<1\>\/XI2\<1\>\/XI2\<1\>\/XI2\<0\>\/XI2\<1\>\/XI2\<1\>\/XI2\<0\>\/RR2 \
 (  \
 N_SEL2\<1\>_XI2\<1\>\/XI2\<1\>\/XI2\<1\>\/XI2\<1\>\/XI2\<0\>\/XI2\<1\>\/XI2\<1\>\/XI2\<0\>\/RR2_pos \
 N_WLSEL\<1970\>_XI2\<1\>\/XI2\<1\>\/XI2\<1\>\/XI2\<1\>\/XI2\<0\>\/XI2\<1\>\/XI2\<1\>\/XI2\<0\>\/RR2_neg \
 ) R_1X_LL w=1e-07 l=1e-07   res=0.149966
XXI2\<1\>\/XI2\<1\>\/XI2\<1\>\/XI2\<1\>\/XI2\<0\>\/XI2\<1\>\/XI2\<1\>\/XI2\<0\>\/RR3 \
 (  \
 N_SEL3\<0\>_XI2\<1\>\/XI2\<1\>\/XI2\<1\>\/XI2\<1\>\/XI2\<0\>\/XI2\<1\>\/XI2\<1\>\/XI2\<0\>\/RR3_pos \
 N_WLSEL\<1971\>_XI2\<1\>\/XI2\<1\>\/XI2\<1\>\/XI2\<1\>\/XI2\<0\>\/XI2\<1\>\/XI2\<1\>\/XI2\<0\>\/RR3_neg \
 ) R_1X_LL w=1e-07 l=1e-07   res=0.149966
XXI2\<1\>\/XI2\<1\>\/XI2\<1\>\/XI2\<1\>\/XI2\<0\>\/XI2\<1\>\/XI2\<1\>\/XI2\<0\>\/RR4 \
 (  \
 N_SEL4\<1\>_XI2\<1\>\/XI2\<1\>\/XI2\<1\>\/XI2\<1\>\/XI2\<0\>\/XI2\<1\>\/XI2\<1\>\/XI2\<0\>\/RR4_pos \
 N_WLSEL\<1972\>_XI2\<1\>\/XI2\<1\>\/XI2\<1\>\/XI2\<1\>\/XI2\<0\>\/XI2\<1\>\/XI2\<1\>\/XI2\<0\>\/RR4_neg \
 ) R_1X_LL w=1e-07 l=1e-07   res=0.149966
XXI2\<1\>\/XI2\<1\>\/XI2\<1\>\/XI2\<1\>\/XI2\<0\>\/XI2\<1\>\/XI2\<1\>\/XI2\<0\>\/RR7 \
 (  \
 N_SEL5\<1\>_XI2\<1\>\/XI2\<1\>\/XI2\<1\>\/XI2\<1\>\/XI2\<0\>\/XI2\<1\>\/XI2\<1\>\/XI2\<0\>\/RR7_pos \
 N_WLSEL\<1973\>_XI2\<1\>\/XI2\<1\>\/XI2\<1\>\/XI2\<1\>\/XI2\<0\>\/XI2\<1\>\/XI2\<1\>\/XI2\<0\>\/RR7_neg \
 ) R_1X_LL w=1e-07 l=1e-07   res=0.149966
XXI2\<1\>\/XI2\<1\>\/XI2\<1\>\/XI2\<1\>\/XI2\<0\>\/XI2\<1\>\/XI2\<1\>\/XI2\<0\>\/RR6 \
 (  \
 N_SEL6\<1\>_XI2\<1\>\/XI2\<1\>\/XI2\<1\>\/XI2\<1\>\/XI2\<0\>\/XI2\<1\>\/XI2\<1\>\/XI2\<0\>\/RR6_pos \
 N_WLSEL\<1974\>_XI2\<1\>\/XI2\<1\>\/XI2\<1\>\/XI2\<1\>\/XI2\<0\>\/XI2\<1\>\/XI2\<1\>\/XI2\<0\>\/RR6_neg \
 ) R_1X_LL w=1e-07 l=1e-07   res=0.149966
XXI2\<1\>\/XI2\<1\>\/XI2\<1\>\/XI2\<1\>\/XI2\<0\>\/XI2\<1\>\/XI2\<1\>\/XI2\<0\>\/RR5 \
 (  \
 N_SEL7\<1\>_XI2\<1\>\/XI2\<1\>\/XI2\<1\>\/XI2\<1\>\/XI2\<0\>\/XI2\<1\>\/XI2\<1\>\/XI2\<0\>\/RR5_pos \
 N_WLSEL\<1975\>_XI2\<1\>\/XI2\<1\>\/XI2\<1\>\/XI2\<1\>\/XI2\<0\>\/XI2\<1\>\/XI2\<1\>\/XI2\<0\>\/RR5_neg \
 ) R_1X_LL w=1e-07 l=1e-07   res=0.149966
XXI2\<1\>\/XI2\<1\>\/XI2\<1\>\/XI2\<1\>\/XI2\<0\>\/XI2\<1\>\/XI2\<1\>\/XI2\<1\>\/RR0 \
 (  \
 N_SEL0\<1\>_XI2\<1\>\/XI2\<1\>\/XI2\<1\>\/XI2\<1\>\/XI2\<0\>\/XI2\<1\>\/XI2\<1\>\/XI2\<1\>\/RR0_pos \
 N_WLSEL\<1976\>_XI2\<1\>\/XI2\<1\>\/XI2\<1\>\/XI2\<1\>\/XI2\<0\>\/XI2\<1\>\/XI2\<1\>\/XI2\<1\>\/RR0_neg \
 ) R_1X_LL w=1e-07 l=1e-07   res=0.149966
XXI2\<1\>\/XI2\<1\>\/XI2\<1\>\/XI2\<1\>\/XI2\<0\>\/XI2\<1\>\/XI2\<1\>\/XI2\<1\>\/RR1 \
 (  \
 N_SEL1\<1\>_XI2\<1\>\/XI2\<1\>\/XI2\<1\>\/XI2\<1\>\/XI2\<0\>\/XI2\<1\>\/XI2\<1\>\/XI2\<1\>\/RR1_pos \
 N_WLSEL\<1977\>_XI2\<1\>\/XI2\<1\>\/XI2\<1\>\/XI2\<1\>\/XI2\<0\>\/XI2\<1\>\/XI2\<1\>\/XI2\<1\>\/RR1_neg \
 ) R_1X_LL w=1e-07 l=1e-07   res=0.149966
XXI2\<1\>\/XI2\<1\>\/XI2\<1\>\/XI2\<1\>\/XI2\<0\>\/XI2\<1\>\/XI2\<1\>\/XI2\<1\>\/RR2 \
 (  \
 N_SEL2\<1\>_XI2\<1\>\/XI2\<1\>\/XI2\<1\>\/XI2\<1\>\/XI2\<0\>\/XI2\<1\>\/XI2\<1\>\/XI2\<1\>\/RR2_pos \
 N_WLSEL\<1978\>_XI2\<1\>\/XI2\<1\>\/XI2\<1\>\/XI2\<1\>\/XI2\<0\>\/XI2\<1\>\/XI2\<1\>\/XI2\<1\>\/RR2_neg \
 ) R_1X_LL w=1e-07 l=1e-07   res=0.149966
XXI2\<1\>\/XI2\<1\>\/XI2\<1\>\/XI2\<1\>\/XI2\<0\>\/XI2\<1\>\/XI2\<1\>\/XI2\<1\>\/RR3 \
 (  \
 N_SEL3\<0\>_XI2\<1\>\/XI2\<1\>\/XI2\<1\>\/XI2\<1\>\/XI2\<0\>\/XI2\<1\>\/XI2\<1\>\/XI2\<1\>\/RR3_pos \
 N_WLSEL\<1979\>_XI2\<1\>\/XI2\<1\>\/XI2\<1\>\/XI2\<1\>\/XI2\<0\>\/XI2\<1\>\/XI2\<1\>\/XI2\<1\>\/RR3_neg \
 ) R_1X_LL w=1e-07 l=1e-07   res=0.149966
XXI2\<1\>\/XI2\<1\>\/XI2\<1\>\/XI2\<1\>\/XI2\<0\>\/XI2\<1\>\/XI2\<1\>\/XI2\<1\>\/RR4 \
 (  \
 N_SEL4\<1\>_XI2\<1\>\/XI2\<1\>\/XI2\<1\>\/XI2\<1\>\/XI2\<0\>\/XI2\<1\>\/XI2\<1\>\/XI2\<1\>\/RR4_pos \
 N_WLSEL\<1980\>_XI2\<1\>\/XI2\<1\>\/XI2\<1\>\/XI2\<1\>\/XI2\<0\>\/XI2\<1\>\/XI2\<1\>\/XI2\<1\>\/RR4_neg \
 ) R_1X_LL w=1e-07 l=1e-07   res=0.149966
XXI2\<1\>\/XI2\<1\>\/XI2\<1\>\/XI2\<1\>\/XI2\<0\>\/XI2\<1\>\/XI2\<1\>\/XI2\<1\>\/RR7 \
 (  \
 N_SEL5\<1\>_XI2\<1\>\/XI2\<1\>\/XI2\<1\>\/XI2\<1\>\/XI2\<0\>\/XI2\<1\>\/XI2\<1\>\/XI2\<1\>\/RR7_pos \
 N_WLSEL\<1981\>_XI2\<1\>\/XI2\<1\>\/XI2\<1\>\/XI2\<1\>\/XI2\<0\>\/XI2\<1\>\/XI2\<1\>\/XI2\<1\>\/RR7_neg \
 ) R_1X_LL w=1e-07 l=1e-07   res=0.149966
XXI2\<1\>\/XI2\<1\>\/XI2\<1\>\/XI2\<1\>\/XI2\<0\>\/XI2\<1\>\/XI2\<1\>\/XI2\<1\>\/RR6 \
 (  \
 N_SEL6\<1\>_XI2\<1\>\/XI2\<1\>\/XI2\<1\>\/XI2\<1\>\/XI2\<0\>\/XI2\<1\>\/XI2\<1\>\/XI2\<1\>\/RR6_pos \
 N_WLSEL\<1982\>_XI2\<1\>\/XI2\<1\>\/XI2\<1\>\/XI2\<1\>\/XI2\<0\>\/XI2\<1\>\/XI2\<1\>\/XI2\<1\>\/RR6_neg \
 ) R_1X_LL w=1e-07 l=1e-07   res=0.149966
XXI2\<1\>\/XI2\<1\>\/XI2\<1\>\/XI2\<1\>\/XI2\<0\>\/XI2\<1\>\/XI2\<1\>\/XI2\<1\>\/RR5 \
 (  \
 N_SEL7\<1\>_XI2\<1\>\/XI2\<1\>\/XI2\<1\>\/XI2\<1\>\/XI2\<0\>\/XI2\<1\>\/XI2\<1\>\/XI2\<1\>\/RR5_pos \
 N_WLSEL\<1983\>_XI2\<1\>\/XI2\<1\>\/XI2\<1\>\/XI2\<1\>\/XI2\<0\>\/XI2\<1\>\/XI2\<1\>\/XI2\<1\>\/RR5_neg \
 ) R_1X_LL w=1e-07 l=1e-07   res=0.149966
XXI2\<1\>\/XI2\<1\>\/XI2\<1\>\/XI2\<1\>\/XI2\<1\>\/XI2\<0\>\/XI2\<0\>\/XI2\<0\>\/RR0 \
 (  \
 N_SEL0\<0\>_XI2\<1\>\/XI2\<1\>\/XI2\<1\>\/XI2\<1\>\/XI2\<1\>\/XI2\<0\>\/XI2\<0\>\/XI2\<0\>\/RR0_pos \
 N_WLSEL\<1984\>_XI2\<1\>\/XI2\<1\>\/XI2\<1\>\/XI2\<1\>\/XI2\<1\>\/XI2\<0\>\/XI2\<0\>\/XI2\<0\>\/RR0_neg \
 ) R_1X_LL w=1e-07 l=1e-07   res=0.149966
XXI2\<1\>\/XI2\<1\>\/XI2\<1\>\/XI2\<1\>\/XI2\<1\>\/XI2\<0\>\/XI2\<0\>\/XI2\<0\>\/RR1 \
 (  \
 N_SEL1\<0\>_XI2\<1\>\/XI2\<1\>\/XI2\<1\>\/XI2\<1\>\/XI2\<1\>\/XI2\<0\>\/XI2\<0\>\/XI2\<0\>\/RR1_pos \
 N_WLSEL\<1985\>_XI2\<1\>\/XI2\<1\>\/XI2\<1\>\/XI2\<1\>\/XI2\<1\>\/XI2\<0\>\/XI2\<0\>\/XI2\<0\>\/RR1_neg \
 ) R_1X_LL w=1e-07 l=1e-07   res=0.149966
XXI2\<1\>\/XI2\<1\>\/XI2\<1\>\/XI2\<1\>\/XI2\<1\>\/XI2\<0\>\/XI2\<0\>\/XI2\<0\>\/RR2 \
 (  \
 N_SEL2\<0\>_XI2\<1\>\/XI2\<1\>\/XI2\<1\>\/XI2\<1\>\/XI2\<1\>\/XI2\<0\>\/XI2\<0\>\/XI2\<0\>\/RR2_pos \
 N_WLSEL\<1986\>_XI2\<1\>\/XI2\<1\>\/XI2\<1\>\/XI2\<1\>\/XI2\<1\>\/XI2\<0\>\/XI2\<0\>\/XI2\<0\>\/RR2_neg \
 ) R_1X_LL w=1e-07 l=1e-07   res=0.149966
XXI2\<1\>\/XI2\<1\>\/XI2\<1\>\/XI2\<1\>\/XI2\<1\>\/XI2\<0\>\/XI2\<0\>\/XI2\<0\>\/RR3 \
 (  \
 N_SEL3\<1\>_XI2\<1\>\/XI2\<1\>\/XI2\<1\>\/XI2\<1\>\/XI2\<1\>\/XI2\<0\>\/XI2\<0\>\/XI2\<0\>\/RR3_pos \
 N_WLSEL\<1987\>_XI2\<1\>\/XI2\<1\>\/XI2\<1\>\/XI2\<1\>\/XI2\<1\>\/XI2\<0\>\/XI2\<0\>\/XI2\<0\>\/RR3_neg \
 ) R_1X_LL w=1e-07 l=1e-07   res=0.149966
XXI2\<1\>\/XI2\<1\>\/XI2\<1\>\/XI2\<1\>\/XI2\<1\>\/XI2\<0\>\/XI2\<0\>\/XI2\<0\>\/RR4 \
 (  \
 N_SEL4\<1\>_XI2\<1\>\/XI2\<1\>\/XI2\<1\>\/XI2\<1\>\/XI2\<1\>\/XI2\<0\>\/XI2\<0\>\/XI2\<0\>\/RR4_pos \
 N_WLSEL\<1988\>_XI2\<1\>\/XI2\<1\>\/XI2\<1\>\/XI2\<1\>\/XI2\<1\>\/XI2\<0\>\/XI2\<0\>\/XI2\<0\>\/RR4_neg \
 ) R_1X_LL w=1e-07 l=1e-07   res=0.149966
XXI2\<1\>\/XI2\<1\>\/XI2\<1\>\/XI2\<1\>\/XI2\<1\>\/XI2\<0\>\/XI2\<0\>\/XI2\<0\>\/RR7 \
 (  \
 N_SEL5\<1\>_XI2\<1\>\/XI2\<1\>\/XI2\<1\>\/XI2\<1\>\/XI2\<1\>\/XI2\<0\>\/XI2\<0\>\/XI2\<0\>\/RR7_pos \
 N_WLSEL\<1989\>_XI2\<1\>\/XI2\<1\>\/XI2\<1\>\/XI2\<1\>\/XI2\<1\>\/XI2\<0\>\/XI2\<0\>\/XI2\<0\>\/RR7_neg \
 ) R_1X_LL w=1e-07 l=1e-07   res=0.149966
XXI2\<1\>\/XI2\<1\>\/XI2\<1\>\/XI2\<1\>\/XI2\<1\>\/XI2\<0\>\/XI2\<0\>\/XI2\<0\>\/RR6 \
 (  \
 N_SEL6\<1\>_XI2\<1\>\/XI2\<1\>\/XI2\<1\>\/XI2\<1\>\/XI2\<1\>\/XI2\<0\>\/XI2\<0\>\/XI2\<0\>\/RR6_pos \
 N_WLSEL\<1990\>_XI2\<1\>\/XI2\<1\>\/XI2\<1\>\/XI2\<1\>\/XI2\<1\>\/XI2\<0\>\/XI2\<0\>\/XI2\<0\>\/RR6_neg \
 ) R_1X_LL w=1e-07 l=1e-07   res=0.149966
XXI2\<1\>\/XI2\<1\>\/XI2\<1\>\/XI2\<1\>\/XI2\<1\>\/XI2\<0\>\/XI2\<0\>\/XI2\<0\>\/RR5 \
 (  \
 N_SEL7\<1\>_XI2\<1\>\/XI2\<1\>\/XI2\<1\>\/XI2\<1\>\/XI2\<1\>\/XI2\<0\>\/XI2\<0\>\/XI2\<0\>\/RR5_pos \
 N_WLSEL\<1991\>_XI2\<1\>\/XI2\<1\>\/XI2\<1\>\/XI2\<1\>\/XI2\<1\>\/XI2\<0\>\/XI2\<0\>\/XI2\<0\>\/RR5_neg \
 ) R_1X_LL w=1e-07 l=1e-07   res=0.149966
XXI2\<1\>\/XI2\<1\>\/XI2\<1\>\/XI2\<1\>\/XI2\<1\>\/XI2\<0\>\/XI2\<0\>\/XI2\<1\>\/RR0 \
 (  \
 N_SEL0\<1\>_XI2\<1\>\/XI2\<1\>\/XI2\<1\>\/XI2\<1\>\/XI2\<1\>\/XI2\<0\>\/XI2\<0\>\/XI2\<1\>\/RR0_pos \
 N_WLSEL\<1992\>_XI2\<1\>\/XI2\<1\>\/XI2\<1\>\/XI2\<1\>\/XI2\<1\>\/XI2\<0\>\/XI2\<0\>\/XI2\<1\>\/RR0_neg \
 ) R_1X_LL w=1e-07 l=1e-07   res=0.149966
XXI2\<1\>\/XI2\<1\>\/XI2\<1\>\/XI2\<1\>\/XI2\<1\>\/XI2\<0\>\/XI2\<0\>\/XI2\<1\>\/RR1 \
 (  \
 N_SEL1\<0\>_XI2\<1\>\/XI2\<1\>\/XI2\<1\>\/XI2\<1\>\/XI2\<1\>\/XI2\<0\>\/XI2\<0\>\/XI2\<1\>\/RR1_pos \
 N_WLSEL\<1993\>_XI2\<1\>\/XI2\<1\>\/XI2\<1\>\/XI2\<1\>\/XI2\<1\>\/XI2\<0\>\/XI2\<0\>\/XI2\<1\>\/RR1_neg \
 ) R_1X_LL w=1e-07 l=1e-07   res=0.149966
XXI2\<1\>\/XI2\<1\>\/XI2\<1\>\/XI2\<1\>\/XI2\<1\>\/XI2\<0\>\/XI2\<0\>\/XI2\<1\>\/RR2 \
 (  \
 N_SEL2\<0\>_XI2\<1\>\/XI2\<1\>\/XI2\<1\>\/XI2\<1\>\/XI2\<1\>\/XI2\<0\>\/XI2\<0\>\/XI2\<1\>\/RR2_pos \
 N_WLSEL\<1994\>_XI2\<1\>\/XI2\<1\>\/XI2\<1\>\/XI2\<1\>\/XI2\<1\>\/XI2\<0\>\/XI2\<0\>\/XI2\<1\>\/RR2_neg \
 ) R_1X_LL w=1e-07 l=1e-07   res=0.149966
XXI2\<1\>\/XI2\<1\>\/XI2\<1\>\/XI2\<1\>\/XI2\<1\>\/XI2\<0\>\/XI2\<0\>\/XI2\<1\>\/RR3 \
 (  \
 N_SEL3\<1\>_XI2\<1\>\/XI2\<1\>\/XI2\<1\>\/XI2\<1\>\/XI2\<1\>\/XI2\<0\>\/XI2\<0\>\/XI2\<1\>\/RR3_pos \
 N_WLSEL\<1995\>_XI2\<1\>\/XI2\<1\>\/XI2\<1\>\/XI2\<1\>\/XI2\<1\>\/XI2\<0\>\/XI2\<0\>\/XI2\<1\>\/RR3_neg \
 ) R_1X_LL w=1e-07 l=1e-07   res=0.149966
XXI2\<1\>\/XI2\<1\>\/XI2\<1\>\/XI2\<1\>\/XI2\<1\>\/XI2\<0\>\/XI2\<0\>\/XI2\<1\>\/RR4 \
 (  \
 N_SEL4\<1\>_XI2\<1\>\/XI2\<1\>\/XI2\<1\>\/XI2\<1\>\/XI2\<1\>\/XI2\<0\>\/XI2\<0\>\/XI2\<1\>\/RR4_pos \
 N_WLSEL\<1996\>_XI2\<1\>\/XI2\<1\>\/XI2\<1\>\/XI2\<1\>\/XI2\<1\>\/XI2\<0\>\/XI2\<0\>\/XI2\<1\>\/RR4_neg \
 ) R_1X_LL w=1e-07 l=1e-07   res=0.149966
XXI2\<1\>\/XI2\<1\>\/XI2\<1\>\/XI2\<1\>\/XI2\<1\>\/XI2\<0\>\/XI2\<0\>\/XI2\<1\>\/RR7 \
 (  \
 N_SEL5\<1\>_XI2\<1\>\/XI2\<1\>\/XI2\<1\>\/XI2\<1\>\/XI2\<1\>\/XI2\<0\>\/XI2\<0\>\/XI2\<1\>\/RR7_pos \
 N_WLSEL\<1997\>_XI2\<1\>\/XI2\<1\>\/XI2\<1\>\/XI2\<1\>\/XI2\<1\>\/XI2\<0\>\/XI2\<0\>\/XI2\<1\>\/RR7_neg \
 ) R_1X_LL w=1e-07 l=1e-07   res=0.149966
XXI2\<1\>\/XI2\<1\>\/XI2\<1\>\/XI2\<1\>\/XI2\<1\>\/XI2\<0\>\/XI2\<0\>\/XI2\<1\>\/RR6 \
 (  \
 N_SEL6\<1\>_XI2\<1\>\/XI2\<1\>\/XI2\<1\>\/XI2\<1\>\/XI2\<1\>\/XI2\<0\>\/XI2\<0\>\/XI2\<1\>\/RR6_pos \
 N_WLSEL\<1998\>_XI2\<1\>\/XI2\<1\>\/XI2\<1\>\/XI2\<1\>\/XI2\<1\>\/XI2\<0\>\/XI2\<0\>\/XI2\<1\>\/RR6_neg \
 ) R_1X_LL w=1e-07 l=1e-07   res=0.149966
XXI2\<1\>\/XI2\<1\>\/XI2\<1\>\/XI2\<1\>\/XI2\<1\>\/XI2\<0\>\/XI2\<0\>\/XI2\<1\>\/RR5 \
 (  \
 N_SEL7\<1\>_XI2\<1\>\/XI2\<1\>\/XI2\<1\>\/XI2\<1\>\/XI2\<1\>\/XI2\<0\>\/XI2\<0\>\/XI2\<1\>\/RR5_pos \
 N_WLSEL\<1999\>_XI2\<1\>\/XI2\<1\>\/XI2\<1\>\/XI2\<1\>\/XI2\<1\>\/XI2\<0\>\/XI2\<0\>\/XI2\<1\>\/RR5_neg \
 ) R_1X_LL w=1e-07 l=1e-07   res=0.149966
XXI2\<1\>\/XI2\<1\>\/XI2\<1\>\/XI2\<1\>\/XI2\<1\>\/XI2\<0\>\/XI2\<1\>\/XI2\<0\>\/RR0 \
 (  \
 N_SEL0\<0\>_XI2\<1\>\/XI2\<1\>\/XI2\<1\>\/XI2\<1\>\/XI2\<1\>\/XI2\<0\>\/XI2\<1\>\/XI2\<0\>\/RR0_pos \
 N_WLSEL\<2000\>_XI2\<1\>\/XI2\<1\>\/XI2\<1\>\/XI2\<1\>\/XI2\<1\>\/XI2\<0\>\/XI2\<1\>\/XI2\<0\>\/RR0_neg \
 ) R_1X_LL w=1e-07 l=1e-07   res=0.149966
XXI2\<1\>\/XI2\<1\>\/XI2\<1\>\/XI2\<1\>\/XI2\<1\>\/XI2\<0\>\/XI2\<1\>\/XI2\<0\>\/RR1 \
 (  \
 N_SEL1\<1\>_XI2\<1\>\/XI2\<1\>\/XI2\<1\>\/XI2\<1\>\/XI2\<1\>\/XI2\<0\>\/XI2\<1\>\/XI2\<0\>\/RR1_pos \
 N_WLSEL\<2001\>_XI2\<1\>\/XI2\<1\>\/XI2\<1\>\/XI2\<1\>\/XI2\<1\>\/XI2\<0\>\/XI2\<1\>\/XI2\<0\>\/RR1_neg \
 ) R_1X_LL w=1e-07 l=1e-07   res=0.149966
XXI2\<1\>\/XI2\<1\>\/XI2\<1\>\/XI2\<1\>\/XI2\<1\>\/XI2\<0\>\/XI2\<1\>\/XI2\<0\>\/RR2 \
 (  \
 N_SEL2\<0\>_XI2\<1\>\/XI2\<1\>\/XI2\<1\>\/XI2\<1\>\/XI2\<1\>\/XI2\<0\>\/XI2\<1\>\/XI2\<0\>\/RR2_pos \
 N_WLSEL\<2002\>_XI2\<1\>\/XI2\<1\>\/XI2\<1\>\/XI2\<1\>\/XI2\<1\>\/XI2\<0\>\/XI2\<1\>\/XI2\<0\>\/RR2_neg \
 ) R_1X_LL w=1e-07 l=1e-07   res=0.149966
XXI2\<1\>\/XI2\<1\>\/XI2\<1\>\/XI2\<1\>\/XI2\<1\>\/XI2\<0\>\/XI2\<1\>\/XI2\<0\>\/RR3 \
 (  \
 N_SEL3\<1\>_XI2\<1\>\/XI2\<1\>\/XI2\<1\>\/XI2\<1\>\/XI2\<1\>\/XI2\<0\>\/XI2\<1\>\/XI2\<0\>\/RR3_pos \
 N_WLSEL\<2003\>_XI2\<1\>\/XI2\<1\>\/XI2\<1\>\/XI2\<1\>\/XI2\<1\>\/XI2\<0\>\/XI2\<1\>\/XI2\<0\>\/RR3_neg \
 ) R_1X_LL w=1e-07 l=1e-07   res=0.149966
XXI2\<1\>\/XI2\<1\>\/XI2\<1\>\/XI2\<1\>\/XI2\<1\>\/XI2\<0\>\/XI2\<1\>\/XI2\<0\>\/RR4 \
 (  \
 N_SEL4\<1\>_XI2\<1\>\/XI2\<1\>\/XI2\<1\>\/XI2\<1\>\/XI2\<1\>\/XI2\<0\>\/XI2\<1\>\/XI2\<0\>\/RR4_pos \
 N_WLSEL\<2004\>_XI2\<1\>\/XI2\<1\>\/XI2\<1\>\/XI2\<1\>\/XI2\<1\>\/XI2\<0\>\/XI2\<1\>\/XI2\<0\>\/RR4_neg \
 ) R_1X_LL w=1e-07 l=1e-07   res=0.149966
XXI2\<1\>\/XI2\<1\>\/XI2\<1\>\/XI2\<1\>\/XI2\<1\>\/XI2\<0\>\/XI2\<1\>\/XI2\<0\>\/RR7 \
 (  \
 N_SEL5\<1\>_XI2\<1\>\/XI2\<1\>\/XI2\<1\>\/XI2\<1\>\/XI2\<1\>\/XI2\<0\>\/XI2\<1\>\/XI2\<0\>\/RR7_pos \
 N_WLSEL\<2005\>_XI2\<1\>\/XI2\<1\>\/XI2\<1\>\/XI2\<1\>\/XI2\<1\>\/XI2\<0\>\/XI2\<1\>\/XI2\<0\>\/RR7_neg \
 ) R_1X_LL w=1e-07 l=1e-07   res=0.149966
XXI2\<1\>\/XI2\<1\>\/XI2\<1\>\/XI2\<1\>\/XI2\<1\>\/XI2\<0\>\/XI2\<1\>\/XI2\<0\>\/RR6 \
 (  \
 N_SEL6\<1\>_XI2\<1\>\/XI2\<1\>\/XI2\<1\>\/XI2\<1\>\/XI2\<1\>\/XI2\<0\>\/XI2\<1\>\/XI2\<0\>\/RR6_pos \
 N_WLSEL\<2006\>_XI2\<1\>\/XI2\<1\>\/XI2\<1\>\/XI2\<1\>\/XI2\<1\>\/XI2\<0\>\/XI2\<1\>\/XI2\<0\>\/RR6_neg \
 ) R_1X_LL w=1e-07 l=1e-07   res=0.149966
XXI2\<1\>\/XI2\<1\>\/XI2\<1\>\/XI2\<1\>\/XI2\<1\>\/XI2\<0\>\/XI2\<1\>\/XI2\<0\>\/RR5 \
 (  \
 N_SEL7\<1\>_XI2\<1\>\/XI2\<1\>\/XI2\<1\>\/XI2\<1\>\/XI2\<1\>\/XI2\<0\>\/XI2\<1\>\/XI2\<0\>\/RR5_pos \
 N_WLSEL\<2007\>_XI2\<1\>\/XI2\<1\>\/XI2\<1\>\/XI2\<1\>\/XI2\<1\>\/XI2\<0\>\/XI2\<1\>\/XI2\<0\>\/RR5_neg \
 ) R_1X_LL w=1e-07 l=1e-07   res=0.149966
XXI2\<1\>\/XI2\<1\>\/XI2\<1\>\/XI2\<1\>\/XI2\<1\>\/XI2\<0\>\/XI2\<1\>\/XI2\<1\>\/RR0 \
 (  \
 N_SEL0\<1\>_XI2\<1\>\/XI2\<1\>\/XI2\<1\>\/XI2\<1\>\/XI2\<1\>\/XI2\<0\>\/XI2\<1\>\/XI2\<1\>\/RR0_pos \
 N_WLSEL\<2008\>_XI2\<1\>\/XI2\<1\>\/XI2\<1\>\/XI2\<1\>\/XI2\<1\>\/XI2\<0\>\/XI2\<1\>\/XI2\<1\>\/RR0_neg \
 ) R_1X_LL w=1e-07 l=1e-07   res=0.149966
XXI2\<1\>\/XI2\<1\>\/XI2\<1\>\/XI2\<1\>\/XI2\<1\>\/XI2\<0\>\/XI2\<1\>\/XI2\<1\>\/RR1 \
 (  \
 N_SEL1\<1\>_XI2\<1\>\/XI2\<1\>\/XI2\<1\>\/XI2\<1\>\/XI2\<1\>\/XI2\<0\>\/XI2\<1\>\/XI2\<1\>\/RR1_pos \
 N_WLSEL\<2009\>_XI2\<1\>\/XI2\<1\>\/XI2\<1\>\/XI2\<1\>\/XI2\<1\>\/XI2\<0\>\/XI2\<1\>\/XI2\<1\>\/RR1_neg \
 ) R_1X_LL w=1e-07 l=1e-07   res=0.149966
XXI2\<1\>\/XI2\<1\>\/XI2\<1\>\/XI2\<1\>\/XI2\<1\>\/XI2\<0\>\/XI2\<1\>\/XI2\<1\>\/RR2 \
 (  \
 N_SEL2\<0\>_XI2\<1\>\/XI2\<1\>\/XI2\<1\>\/XI2\<1\>\/XI2\<1\>\/XI2\<0\>\/XI2\<1\>\/XI2\<1\>\/RR2_pos \
 N_WLSEL\<2010\>_XI2\<1\>\/XI2\<1\>\/XI2\<1\>\/XI2\<1\>\/XI2\<1\>\/XI2\<0\>\/XI2\<1\>\/XI2\<1\>\/RR2_neg \
 ) R_1X_LL w=1e-07 l=1e-07   res=0.149966
XXI2\<1\>\/XI2\<1\>\/XI2\<1\>\/XI2\<1\>\/XI2\<1\>\/XI2\<0\>\/XI2\<1\>\/XI2\<1\>\/RR3 \
 (  \
 N_SEL3\<1\>_XI2\<1\>\/XI2\<1\>\/XI2\<1\>\/XI2\<1\>\/XI2\<1\>\/XI2\<0\>\/XI2\<1\>\/XI2\<1\>\/RR3_pos \
 N_WLSEL\<2011\>_XI2\<1\>\/XI2\<1\>\/XI2\<1\>\/XI2\<1\>\/XI2\<1\>\/XI2\<0\>\/XI2\<1\>\/XI2\<1\>\/RR3_neg \
 ) R_1X_LL w=1e-07 l=1e-07   res=0.149966
XXI2\<1\>\/XI2\<1\>\/XI2\<1\>\/XI2\<1\>\/XI2\<1\>\/XI2\<0\>\/XI2\<1\>\/XI2\<1\>\/RR4 \
 (  \
 N_SEL4\<1\>_XI2\<1\>\/XI2\<1\>\/XI2\<1\>\/XI2\<1\>\/XI2\<1\>\/XI2\<0\>\/XI2\<1\>\/XI2\<1\>\/RR4_pos \
 N_WLSEL\<2012\>_XI2\<1\>\/XI2\<1\>\/XI2\<1\>\/XI2\<1\>\/XI2\<1\>\/XI2\<0\>\/XI2\<1\>\/XI2\<1\>\/RR4_neg \
 ) R_1X_LL w=1e-07 l=1e-07   res=0.149966
XXI2\<1\>\/XI2\<1\>\/XI2\<1\>\/XI2\<1\>\/XI2\<1\>\/XI2\<0\>\/XI2\<1\>\/XI2\<1\>\/RR7 \
 (  \
 N_SEL5\<1\>_XI2\<1\>\/XI2\<1\>\/XI2\<1\>\/XI2\<1\>\/XI2\<1\>\/XI2\<0\>\/XI2\<1\>\/XI2\<1\>\/RR7_pos \
 N_WLSEL\<2013\>_XI2\<1\>\/XI2\<1\>\/XI2\<1\>\/XI2\<1\>\/XI2\<1\>\/XI2\<0\>\/XI2\<1\>\/XI2\<1\>\/RR7_neg \
 ) R_1X_LL w=1e-07 l=1e-07   res=0.149966
XXI2\<1\>\/XI2\<1\>\/XI2\<1\>\/XI2\<1\>\/XI2\<1\>\/XI2\<0\>\/XI2\<1\>\/XI2\<1\>\/RR6 \
 (  \
 N_SEL6\<1\>_XI2\<1\>\/XI2\<1\>\/XI2\<1\>\/XI2\<1\>\/XI2\<1\>\/XI2\<0\>\/XI2\<1\>\/XI2\<1\>\/RR6_pos \
 N_WLSEL\<2014\>_XI2\<1\>\/XI2\<1\>\/XI2\<1\>\/XI2\<1\>\/XI2\<1\>\/XI2\<0\>\/XI2\<1\>\/XI2\<1\>\/RR6_neg \
 ) R_1X_LL w=1e-07 l=1e-07   res=0.149966
XXI2\<1\>\/XI2\<1\>\/XI2\<1\>\/XI2\<1\>\/XI2\<1\>\/XI2\<0\>\/XI2\<1\>\/XI2\<1\>\/RR5 \
 (  \
 N_SEL7\<1\>_XI2\<1\>\/XI2\<1\>\/XI2\<1\>\/XI2\<1\>\/XI2\<1\>\/XI2\<0\>\/XI2\<1\>\/XI2\<1\>\/RR5_pos \
 N_WLSEL\<2015\>_XI2\<1\>\/XI2\<1\>\/XI2\<1\>\/XI2\<1\>\/XI2\<1\>\/XI2\<0\>\/XI2\<1\>\/XI2\<1\>\/RR5_neg \
 ) R_1X_LL w=1e-07 l=1e-07   res=0.149966
XXI2\<1\>\/XI2\<1\>\/XI2\<1\>\/XI2\<1\>\/XI2\<1\>\/XI2\<1\>\/XI2\<0\>\/XI2\<0\>\/RR0 \
 (  \
 N_SEL0\<0\>_XI2\<1\>\/XI2\<1\>\/XI2\<1\>\/XI2\<1\>\/XI2\<1\>\/XI2\<1\>\/XI2\<0\>\/XI2\<0\>\/RR0_pos \
 N_WLSEL\<2016\>_XI2\<1\>\/XI2\<1\>\/XI2\<1\>\/XI2\<1\>\/XI2\<1\>\/XI2\<1\>\/XI2\<0\>\/XI2\<0\>\/RR0_neg \
 ) R_1X_LL w=1e-07 l=1e-07   res=0.149966
XXI2\<1\>\/XI2\<1\>\/XI2\<1\>\/XI2\<1\>\/XI2\<1\>\/XI2\<1\>\/XI2\<0\>\/XI2\<0\>\/RR1 \
 (  \
 N_SEL1\<0\>_XI2\<1\>\/XI2\<1\>\/XI2\<1\>\/XI2\<1\>\/XI2\<1\>\/XI2\<1\>\/XI2\<0\>\/XI2\<0\>\/RR1_pos \
 N_WLSEL\<2017\>_XI2\<1\>\/XI2\<1\>\/XI2\<1\>\/XI2\<1\>\/XI2\<1\>\/XI2\<1\>\/XI2\<0\>\/XI2\<0\>\/RR1_neg \
 ) R_1X_LL w=1e-07 l=1e-07   res=0.149966
XXI2\<1\>\/XI2\<1\>\/XI2\<1\>\/XI2\<1\>\/XI2\<1\>\/XI2\<1\>\/XI2\<0\>\/XI2\<0\>\/RR2 \
 (  \
 N_SEL2\<1\>_XI2\<1\>\/XI2\<1\>\/XI2\<1\>\/XI2\<1\>\/XI2\<1\>\/XI2\<1\>\/XI2\<0\>\/XI2\<0\>\/RR2_pos \
 N_WLSEL\<2018\>_XI2\<1\>\/XI2\<1\>\/XI2\<1\>\/XI2\<1\>\/XI2\<1\>\/XI2\<1\>\/XI2\<0\>\/XI2\<0\>\/RR2_neg \
 ) R_1X_LL w=1e-07 l=1e-07   res=0.149966
XXI2\<1\>\/XI2\<1\>\/XI2\<1\>\/XI2\<1\>\/XI2\<1\>\/XI2\<1\>\/XI2\<0\>\/XI2\<0\>\/RR3 \
 (  \
 N_SEL3\<1\>_XI2\<1\>\/XI2\<1\>\/XI2\<1\>\/XI2\<1\>\/XI2\<1\>\/XI2\<1\>\/XI2\<0\>\/XI2\<0\>\/RR3_pos \
 N_WLSEL\<2019\>_XI2\<1\>\/XI2\<1\>\/XI2\<1\>\/XI2\<1\>\/XI2\<1\>\/XI2\<1\>\/XI2\<0\>\/XI2\<0\>\/RR3_neg \
 ) R_1X_LL w=1e-07 l=1e-07   res=0.149966
XXI2\<1\>\/XI2\<1\>\/XI2\<1\>\/XI2\<1\>\/XI2\<1\>\/XI2\<1\>\/XI2\<0\>\/XI2\<0\>\/RR4 \
 (  \
 N_SEL4\<1\>_XI2\<1\>\/XI2\<1\>\/XI2\<1\>\/XI2\<1\>\/XI2\<1\>\/XI2\<1\>\/XI2\<0\>\/XI2\<0\>\/RR4_pos \
 N_WLSEL\<2020\>_XI2\<1\>\/XI2\<1\>\/XI2\<1\>\/XI2\<1\>\/XI2\<1\>\/XI2\<1\>\/XI2\<0\>\/XI2\<0\>\/RR4_neg \
 ) R_1X_LL w=1e-07 l=1e-07   res=0.149966
XXI2\<1\>\/XI2\<1\>\/XI2\<1\>\/XI2\<1\>\/XI2\<1\>\/XI2\<1\>\/XI2\<0\>\/XI2\<0\>\/RR7 \
 (  \
 N_SEL5\<1\>_XI2\<1\>\/XI2\<1\>\/XI2\<1\>\/XI2\<1\>\/XI2\<1\>\/XI2\<1\>\/XI2\<0\>\/XI2\<0\>\/RR7_pos \
 N_WLSEL\<2021\>_XI2\<1\>\/XI2\<1\>\/XI2\<1\>\/XI2\<1\>\/XI2\<1\>\/XI2\<1\>\/XI2\<0\>\/XI2\<0\>\/RR7_neg \
 ) R_1X_LL w=1e-07 l=1e-07   res=0.149966
XXI2\<1\>\/XI2\<1\>\/XI2\<1\>\/XI2\<1\>\/XI2\<1\>\/XI2\<1\>\/XI2\<0\>\/XI2\<0\>\/RR6 \
 (  \
 N_SEL6\<1\>_XI2\<1\>\/XI2\<1\>\/XI2\<1\>\/XI2\<1\>\/XI2\<1\>\/XI2\<1\>\/XI2\<0\>\/XI2\<0\>\/RR6_pos \
 N_WLSEL\<2022\>_XI2\<1\>\/XI2\<1\>\/XI2\<1\>\/XI2\<1\>\/XI2\<1\>\/XI2\<1\>\/XI2\<0\>\/XI2\<0\>\/RR6_neg \
 ) R_1X_LL w=1e-07 l=1e-07   res=0.149966
XXI2\<1\>\/XI2\<1\>\/XI2\<1\>\/XI2\<1\>\/XI2\<1\>\/XI2\<1\>\/XI2\<0\>\/XI2\<0\>\/RR5 \
 (  \
 N_SEL7\<1\>_XI2\<1\>\/XI2\<1\>\/XI2\<1\>\/XI2\<1\>\/XI2\<1\>\/XI2\<1\>\/XI2\<0\>\/XI2\<0\>\/RR5_pos \
 N_WLSEL\<2023\>_XI2\<1\>\/XI2\<1\>\/XI2\<1\>\/XI2\<1\>\/XI2\<1\>\/XI2\<1\>\/XI2\<0\>\/XI2\<0\>\/RR5_neg \
 ) R_1X_LL w=1e-07 l=1e-07   res=0.149966
XXI2\<1\>\/XI2\<1\>\/XI2\<1\>\/XI2\<1\>\/XI2\<1\>\/XI2\<1\>\/XI2\<0\>\/XI2\<1\>\/RR0 \
 (  \
 N_SEL0\<1\>_XI2\<1\>\/XI2\<1\>\/XI2\<1\>\/XI2\<1\>\/XI2\<1\>\/XI2\<1\>\/XI2\<0\>\/XI2\<1\>\/RR0_pos \
 N_WLSEL\<2024\>_XI2\<1\>\/XI2\<1\>\/XI2\<1\>\/XI2\<1\>\/XI2\<1\>\/XI2\<1\>\/XI2\<0\>\/XI2\<1\>\/RR0_neg \
 ) R_1X_LL w=1e-07 l=1e-07   res=0.149966
XXI2\<1\>\/XI2\<1\>\/XI2\<1\>\/XI2\<1\>\/XI2\<1\>\/XI2\<1\>\/XI2\<0\>\/XI2\<1\>\/RR1 \
 (  \
 N_SEL1\<0\>_XI2\<1\>\/XI2\<1\>\/XI2\<1\>\/XI2\<1\>\/XI2\<1\>\/XI2\<1\>\/XI2\<0\>\/XI2\<1\>\/RR1_pos \
 N_WLSEL\<2025\>_XI2\<1\>\/XI2\<1\>\/XI2\<1\>\/XI2\<1\>\/XI2\<1\>\/XI2\<1\>\/XI2\<0\>\/XI2\<1\>\/RR1_neg \
 ) R_1X_LL w=1e-07 l=1e-07   res=0.149966
XXI2\<1\>\/XI2\<1\>\/XI2\<1\>\/XI2\<1\>\/XI2\<1\>\/XI2\<1\>\/XI2\<0\>\/XI2\<1\>\/RR2 \
 (  \
 N_SEL2\<1\>_XI2\<1\>\/XI2\<1\>\/XI2\<1\>\/XI2\<1\>\/XI2\<1\>\/XI2\<1\>\/XI2\<0\>\/XI2\<1\>\/RR2_pos \
 N_WLSEL\<2026\>_XI2\<1\>\/XI2\<1\>\/XI2\<1\>\/XI2\<1\>\/XI2\<1\>\/XI2\<1\>\/XI2\<0\>\/XI2\<1\>\/RR2_neg \
 ) R_1X_LL w=1e-07 l=1e-07   res=0.149966
XXI2\<1\>\/XI2\<1\>\/XI2\<1\>\/XI2\<1\>\/XI2\<1\>\/XI2\<1\>\/XI2\<0\>\/XI2\<1\>\/RR3 \
 (  \
 N_SEL3\<1\>_XI2\<1\>\/XI2\<1\>\/XI2\<1\>\/XI2\<1\>\/XI2\<1\>\/XI2\<1\>\/XI2\<0\>\/XI2\<1\>\/RR3_pos \
 N_WLSEL\<2027\>_XI2\<1\>\/XI2\<1\>\/XI2\<1\>\/XI2\<1\>\/XI2\<1\>\/XI2\<1\>\/XI2\<0\>\/XI2\<1\>\/RR3_neg \
 ) R_1X_LL w=1e-07 l=1e-07   res=0.149966
XXI2\<1\>\/XI2\<1\>\/XI2\<1\>\/XI2\<1\>\/XI2\<1\>\/XI2\<1\>\/XI2\<0\>\/XI2\<1\>\/RR4 \
 (  \
 N_SEL4\<1\>_XI2\<1\>\/XI2\<1\>\/XI2\<1\>\/XI2\<1\>\/XI2\<1\>\/XI2\<1\>\/XI2\<0\>\/XI2\<1\>\/RR4_pos \
 N_WLSEL\<2028\>_XI2\<1\>\/XI2\<1\>\/XI2\<1\>\/XI2\<1\>\/XI2\<1\>\/XI2\<1\>\/XI2\<0\>\/XI2\<1\>\/RR4_neg \
 ) R_1X_LL w=1e-07 l=1e-07   res=0.149966
XXI2\<1\>\/XI2\<1\>\/XI2\<1\>\/XI2\<1\>\/XI2\<1\>\/XI2\<1\>\/XI2\<0\>\/XI2\<1\>\/RR7 \
 (  \
 N_SEL5\<1\>_XI2\<1\>\/XI2\<1\>\/XI2\<1\>\/XI2\<1\>\/XI2\<1\>\/XI2\<1\>\/XI2\<0\>\/XI2\<1\>\/RR7_pos \
 N_WLSEL\<2029\>_XI2\<1\>\/XI2\<1\>\/XI2\<1\>\/XI2\<1\>\/XI2\<1\>\/XI2\<1\>\/XI2\<0\>\/XI2\<1\>\/RR7_neg \
 ) R_1X_LL w=1e-07 l=1e-07   res=0.149966
XXI2\<1\>\/XI2\<1\>\/XI2\<1\>\/XI2\<1\>\/XI2\<1\>\/XI2\<1\>\/XI2\<0\>\/XI2\<1\>\/RR6 \
 (  \
 N_SEL6\<1\>_XI2\<1\>\/XI2\<1\>\/XI2\<1\>\/XI2\<1\>\/XI2\<1\>\/XI2\<1\>\/XI2\<0\>\/XI2\<1\>\/RR6_pos \
 N_WLSEL\<2030\>_XI2\<1\>\/XI2\<1\>\/XI2\<1\>\/XI2\<1\>\/XI2\<1\>\/XI2\<1\>\/XI2\<0\>\/XI2\<1\>\/RR6_neg \
 ) R_1X_LL w=1e-07 l=1e-07   res=0.149966
XXI2\<1\>\/XI2\<1\>\/XI2\<1\>\/XI2\<1\>\/XI2\<1\>\/XI2\<1\>\/XI2\<0\>\/XI2\<1\>\/RR5 \
 (  \
 N_SEL7\<1\>_XI2\<1\>\/XI2\<1\>\/XI2\<1\>\/XI2\<1\>\/XI2\<1\>\/XI2\<1\>\/XI2\<0\>\/XI2\<1\>\/RR5_pos \
 N_WLSEL\<2031\>_XI2\<1\>\/XI2\<1\>\/XI2\<1\>\/XI2\<1\>\/XI2\<1\>\/XI2\<1\>\/XI2\<0\>\/XI2\<1\>\/RR5_neg \
 ) R_1X_LL w=1e-07 l=1e-07   res=0.149966
XXI2\<1\>\/XI2\<1\>\/XI2\<1\>\/XI2\<1\>\/XI2\<1\>\/XI2\<1\>\/XI2\<1\>\/XI2\<0\>\/RR0 \
 (  \
 N_SEL0\<0\>_XI2\<1\>\/XI2\<1\>\/XI2\<1\>\/XI2\<1\>\/XI2\<1\>\/XI2\<1\>\/XI2\<1\>\/XI2\<0\>\/RR0_pos \
 N_WLSEL\<2032\>_XI2\<1\>\/XI2\<1\>\/XI2\<1\>\/XI2\<1\>\/XI2\<1\>\/XI2\<1\>\/XI2\<1\>\/XI2\<0\>\/RR0_neg \
 ) R_1X_LL w=1e-07 l=1e-07   res=0.149966
XXI2\<1\>\/XI2\<1\>\/XI2\<1\>\/XI2\<1\>\/XI2\<1\>\/XI2\<1\>\/XI2\<1\>\/XI2\<0\>\/RR1 \
 (  \
 N_SEL1\<1\>_XI2\<1\>\/XI2\<1\>\/XI2\<1\>\/XI2\<1\>\/XI2\<1\>\/XI2\<1\>\/XI2\<1\>\/XI2\<0\>\/RR1_pos \
 N_WLSEL\<2033\>_XI2\<1\>\/XI2\<1\>\/XI2\<1\>\/XI2\<1\>\/XI2\<1\>\/XI2\<1\>\/XI2\<1\>\/XI2\<0\>\/RR1_neg \
 ) R_1X_LL w=1e-07 l=1e-07   res=0.149966
XXI2\<1\>\/XI2\<1\>\/XI2\<1\>\/XI2\<1\>\/XI2\<1\>\/XI2\<1\>\/XI2\<1\>\/XI2\<0\>\/RR2 \
 (  \
 N_SEL2\<1\>_XI2\<1\>\/XI2\<1\>\/XI2\<1\>\/XI2\<1\>\/XI2\<1\>\/XI2\<1\>\/XI2\<1\>\/XI2\<0\>\/RR2_pos \
 N_WLSEL\<2034\>_XI2\<1\>\/XI2\<1\>\/XI2\<1\>\/XI2\<1\>\/XI2\<1\>\/XI2\<1\>\/XI2\<1\>\/XI2\<0\>\/RR2_neg \
 ) R_1X_LL w=1e-07 l=1e-07   res=0.149966
XXI2\<1\>\/XI2\<1\>\/XI2\<1\>\/XI2\<1\>\/XI2\<1\>\/XI2\<1\>\/XI2\<1\>\/XI2\<0\>\/RR3 \
 (  \
 N_SEL3\<1\>_XI2\<1\>\/XI2\<1\>\/XI2\<1\>\/XI2\<1\>\/XI2\<1\>\/XI2\<1\>\/XI2\<1\>\/XI2\<0\>\/RR3_pos \
 N_WLSEL\<2035\>_XI2\<1\>\/XI2\<1\>\/XI2\<1\>\/XI2\<1\>\/XI2\<1\>\/XI2\<1\>\/XI2\<1\>\/XI2\<0\>\/RR3_neg \
 ) R_1X_LL w=1e-07 l=1e-07   res=0.149966
XXI2\<1\>\/XI2\<1\>\/XI2\<1\>\/XI2\<1\>\/XI2\<1\>\/XI2\<1\>\/XI2\<1\>\/XI2\<0\>\/RR4 \
 (  \
 N_SEL4\<1\>_XI2\<1\>\/XI2\<1\>\/XI2\<1\>\/XI2\<1\>\/XI2\<1\>\/XI2\<1\>\/XI2\<1\>\/XI2\<0\>\/RR4_pos \
 N_WLSEL\<2036\>_XI2\<1\>\/XI2\<1\>\/XI2\<1\>\/XI2\<1\>\/XI2\<1\>\/XI2\<1\>\/XI2\<1\>\/XI2\<0\>\/RR4_neg \
 ) R_1X_LL w=1e-07 l=1e-07   res=0.149966
XXI2\<1\>\/XI2\<1\>\/XI2\<1\>\/XI2\<1\>\/XI2\<1\>\/XI2\<1\>\/XI2\<1\>\/XI2\<0\>\/RR7 \
 (  \
 N_SEL5\<1\>_XI2\<1\>\/XI2\<1\>\/XI2\<1\>\/XI2\<1\>\/XI2\<1\>\/XI2\<1\>\/XI2\<1\>\/XI2\<0\>\/RR7_pos \
 N_WLSEL\<2037\>_XI2\<1\>\/XI2\<1\>\/XI2\<1\>\/XI2\<1\>\/XI2\<1\>\/XI2\<1\>\/XI2\<1\>\/XI2\<0\>\/RR7_neg \
 ) R_1X_LL w=1e-07 l=1e-07   res=0.149966
XXI2\<1\>\/XI2\<1\>\/XI2\<1\>\/XI2\<1\>\/XI2\<1\>\/XI2\<1\>\/XI2\<1\>\/XI2\<0\>\/RR6 \
 (  \
 N_SEL6\<1\>_XI2\<1\>\/XI2\<1\>\/XI2\<1\>\/XI2\<1\>\/XI2\<1\>\/XI2\<1\>\/XI2\<1\>\/XI2\<0\>\/RR6_pos \
 N_WLSEL\<2038\>_XI2\<1\>\/XI2\<1\>\/XI2\<1\>\/XI2\<1\>\/XI2\<1\>\/XI2\<1\>\/XI2\<1\>\/XI2\<0\>\/RR6_neg \
 ) R_1X_LL w=1e-07 l=1e-07   res=0.149966
XXI2\<1\>\/XI2\<1\>\/XI2\<1\>\/XI2\<1\>\/XI2\<1\>\/XI2\<1\>\/XI2\<1\>\/XI2\<0\>\/RR5 \
 (  \
 N_SEL7\<1\>_XI2\<1\>\/XI2\<1\>\/XI2\<1\>\/XI2\<1\>\/XI2\<1\>\/XI2\<1\>\/XI2\<1\>\/XI2\<0\>\/RR5_pos \
 N_WLSEL\<2039\>_XI2\<1\>\/XI2\<1\>\/XI2\<1\>\/XI2\<1\>\/XI2\<1\>\/XI2\<1\>\/XI2\<1\>\/XI2\<0\>\/RR5_neg \
 ) R_1X_LL w=1e-07 l=1e-07   res=0.149966
XXI2\<1\>\/XI2\<1\>\/XI2\<1\>\/XI2\<1\>\/XI2\<1\>\/XI2\<1\>\/XI2\<1\>\/XI2\<1\>\/RR0 \
 (  \
 N_SEL0\<1\>_XI2\<1\>\/XI2\<1\>\/XI2\<1\>\/XI2\<1\>\/XI2\<1\>\/XI2\<1\>\/XI2\<1\>\/XI2\<1\>\/RR0_pos \
 N_WLSEL\<2040\>_XI2\<1\>\/XI2\<1\>\/XI2\<1\>\/XI2\<1\>\/XI2\<1\>\/XI2\<1\>\/XI2\<1\>\/XI2\<1\>\/RR0_neg \
 ) R_1X_LL w=1e-07 l=1e-07   res=0.149966
XXI2\<1\>\/XI2\<1\>\/XI2\<1\>\/XI2\<1\>\/XI2\<1\>\/XI2\<1\>\/XI2\<1\>\/XI2\<1\>\/RR1 \
 (  \
 N_SEL1\<1\>_XI2\<1\>\/XI2\<1\>\/XI2\<1\>\/XI2\<1\>\/XI2\<1\>\/XI2\<1\>\/XI2\<1\>\/XI2\<1\>\/RR1_pos \
 N_WLSEL\<2041\>_XI2\<1\>\/XI2\<1\>\/XI2\<1\>\/XI2\<1\>\/XI2\<1\>\/XI2\<1\>\/XI2\<1\>\/XI2\<1\>\/RR1_neg \
 ) R_1X_LL w=1e-07 l=1e-07   res=0.149966
XXI2\<1\>\/XI2\<1\>\/XI2\<1\>\/XI2\<1\>\/XI2\<1\>\/XI2\<1\>\/XI2\<1\>\/XI2\<1\>\/RR2 \
 (  \
 N_SEL2\<1\>_XI2\<1\>\/XI2\<1\>\/XI2\<1\>\/XI2\<1\>\/XI2\<1\>\/XI2\<1\>\/XI2\<1\>\/XI2\<1\>\/RR2_pos \
 N_WLSEL\<2042\>_XI2\<1\>\/XI2\<1\>\/XI2\<1\>\/XI2\<1\>\/XI2\<1\>\/XI2\<1\>\/XI2\<1\>\/XI2\<1\>\/RR2_neg \
 ) R_1X_LL w=1e-07 l=1e-07   res=0.149966
XXI2\<1\>\/XI2\<1\>\/XI2\<1\>\/XI2\<1\>\/XI2\<1\>\/XI2\<1\>\/XI2\<1\>\/XI2\<1\>\/RR3 \
 (  \
 N_SEL3\<1\>_XI2\<1\>\/XI2\<1\>\/XI2\<1\>\/XI2\<1\>\/XI2\<1\>\/XI2\<1\>\/XI2\<1\>\/XI2\<1\>\/RR3_pos \
 N_WLSEL\<2043\>_XI2\<1\>\/XI2\<1\>\/XI2\<1\>\/XI2\<1\>\/XI2\<1\>\/XI2\<1\>\/XI2\<1\>\/XI2\<1\>\/RR3_neg \
 ) R_1X_LL w=1e-07 l=1e-07   res=0.149966
XXI2\<1\>\/XI2\<1\>\/XI2\<1\>\/XI2\<1\>\/XI2\<1\>\/XI2\<1\>\/XI2\<1\>\/XI2\<1\>\/RR4 \
 (  \
 N_SEL4\<1\>_XI2\<1\>\/XI2\<1\>\/XI2\<1\>\/XI2\<1\>\/XI2\<1\>\/XI2\<1\>\/XI2\<1\>\/XI2\<1\>\/RR4_pos \
 N_WLSEL\<2044\>_XI2\<1\>\/XI2\<1\>\/XI2\<1\>\/XI2\<1\>\/XI2\<1\>\/XI2\<1\>\/XI2\<1\>\/XI2\<1\>\/RR4_neg \
 ) R_1X_LL w=1e-07 l=1e-07   res=0.149966
XXI2\<1\>\/XI2\<1\>\/XI2\<1\>\/XI2\<1\>\/XI2\<1\>\/XI2\<1\>\/XI2\<1\>\/XI2\<1\>\/RR7 \
 (  \
 N_SEL5\<1\>_XI2\<1\>\/XI2\<1\>\/XI2\<1\>\/XI2\<1\>\/XI2\<1\>\/XI2\<1\>\/XI2\<1\>\/XI2\<1\>\/RR7_pos \
 N_WLSEL\<2045\>_XI2\<1\>\/XI2\<1\>\/XI2\<1\>\/XI2\<1\>\/XI2\<1\>\/XI2\<1\>\/XI2\<1\>\/XI2\<1\>\/RR7_neg \
 ) R_1X_LL w=1e-07 l=1e-07   res=0.149966
XXI2\<1\>\/XI2\<1\>\/XI2\<1\>\/XI2\<1\>\/XI2\<1\>\/XI2\<1\>\/XI2\<1\>\/XI2\<1\>\/RR6 \
 (  \
 N_SEL6\<1\>_XI2\<1\>\/XI2\<1\>\/XI2\<1\>\/XI2\<1\>\/XI2\<1\>\/XI2\<1\>\/XI2\<1\>\/XI2\<1\>\/RR6_pos \
 N_WLSEL\<2046\>_XI2\<1\>\/XI2\<1\>\/XI2\<1\>\/XI2\<1\>\/XI2\<1\>\/XI2\<1\>\/XI2\<1\>\/XI2\<1\>\/RR6_neg \
 ) R_1X_LL w=1e-07 l=1e-07   res=0.149966
XXI2\<1\>\/XI2\<1\>\/XI2\<1\>\/XI2\<1\>\/XI2\<1\>\/XI2\<1\>\/XI2\<1\>\/XI2\<1\>\/RR5 \
 (  \
 N_SEL7\<1\>_XI2\<1\>\/XI2\<1\>\/XI2\<1\>\/XI2\<1\>\/XI2\<1\>\/XI2\<1\>\/XI2\<1\>\/XI2\<1\>\/RR5_pos \
 N_WLSEL\<2047\>_XI2\<1\>\/XI2\<1\>\/XI2\<1\>\/XI2\<1\>\/XI2\<1\>\/XI2\<1\>\/XI2\<1\>\/XI2\<1\>\/RR5_neg \
 ) R_1X_LL w=1e-07 l=1e-07   res=0.149966
XXI2\<1\>\/XI2\<0\>\/XI2\<1\>\/XI2\<1\>\/XI2\<0\>\/XI2\<1\>\/XI2\<1\>\/XI2\<0\>\/RR0 \
 (  \
 N_SEL0\<0\>_XI2\<1\>\/XI2\<0\>\/XI2\<1\>\/XI2\<1\>\/XI2\<0\>\/XI2\<1\>\/XI2\<1\>\/XI2\<0\>\/RR0_pos \
 N_WLSEL\<1456\>_XI2\<1\>\/XI2\<0\>\/XI2\<1\>\/XI2\<1\>\/XI2\<0\>\/XI2\<1\>\/XI2\<1\>\/XI2\<0\>\/RR0_neg \
 ) R_1X_LL w=1e-07 l=1e-07   res=0.149966
XXI2\<1\>\/XI2\<0\>\/XI2\<1\>\/XI2\<1\>\/XI2\<0\>\/XI2\<1\>\/XI2\<1\>\/XI2\<0\>\/RR1 \
 (  \
 N_SEL1\<1\>_XI2\<1\>\/XI2\<0\>\/XI2\<1\>\/XI2\<1\>\/XI2\<0\>\/XI2\<1\>\/XI2\<1\>\/XI2\<0\>\/RR1_pos \
 N_WLSEL\<1457\>_XI2\<1\>\/XI2\<0\>\/XI2\<1\>\/XI2\<1\>\/XI2\<0\>\/XI2\<1\>\/XI2\<1\>\/XI2\<0\>\/RR1_neg \
 ) R_1X_LL w=1e-07 l=1e-07   res=0.149966
XXI2\<1\>\/XI2\<0\>\/XI2\<1\>\/XI2\<1\>\/XI2\<0\>\/XI2\<1\>\/XI2\<1\>\/XI2\<0\>\/RR2 \
 (  \
 N_SEL2\<1\>_XI2\<1\>\/XI2\<0\>\/XI2\<1\>\/XI2\<1\>\/XI2\<0\>\/XI2\<1\>\/XI2\<1\>\/XI2\<0\>\/RR2_pos \
 N_WLSEL\<1458\>_XI2\<1\>\/XI2\<0\>\/XI2\<1\>\/XI2\<1\>\/XI2\<0\>\/XI2\<1\>\/XI2\<1\>\/XI2\<0\>\/RR2_neg \
 ) R_1X_LL w=1e-07 l=1e-07   res=0.149966
XXI2\<1\>\/XI2\<0\>\/XI2\<1\>\/XI2\<1\>\/XI2\<0\>\/XI2\<1\>\/XI2\<1\>\/XI2\<0\>\/RR3 \
 (  \
 N_SEL3\<0\>_XI2\<1\>\/XI2\<0\>\/XI2\<1\>\/XI2\<1\>\/XI2\<0\>\/XI2\<1\>\/XI2\<1\>\/XI2\<0\>\/RR3_pos \
 N_WLSEL\<1459\>_XI2\<1\>\/XI2\<0\>\/XI2\<1\>\/XI2\<1\>\/XI2\<0\>\/XI2\<1\>\/XI2\<1\>\/XI2\<0\>\/RR3_neg \
 ) R_1X_LL w=1e-07 l=1e-07   res=0.149966
XXI2\<1\>\/XI2\<0\>\/XI2\<1\>\/XI2\<1\>\/XI2\<0\>\/XI2\<1\>\/XI2\<1\>\/XI2\<0\>\/RR4 \
 (  \
 N_SEL4\<1\>_XI2\<1\>\/XI2\<0\>\/XI2\<1\>\/XI2\<1\>\/XI2\<0\>\/XI2\<1\>\/XI2\<1\>\/XI2\<0\>\/RR4_pos \
 N_WLSEL\<1460\>_XI2\<1\>\/XI2\<0\>\/XI2\<1\>\/XI2\<1\>\/XI2\<0\>\/XI2\<1\>\/XI2\<1\>\/XI2\<0\>\/RR4_neg \
 ) R_1X_LL w=1e-07 l=1e-07   res=0.149966
XXI2\<1\>\/XI2\<0\>\/XI2\<1\>\/XI2\<1\>\/XI2\<0\>\/XI2\<1\>\/XI2\<1\>\/XI2\<0\>\/RR7 \
 (  \
 N_SEL5\<1\>_XI2\<1\>\/XI2\<0\>\/XI2\<1\>\/XI2\<1\>\/XI2\<0\>\/XI2\<1\>\/XI2\<1\>\/XI2\<0\>\/RR7_pos \
 N_WLSEL\<1461\>_XI2\<1\>\/XI2\<0\>\/XI2\<1\>\/XI2\<1\>\/XI2\<0\>\/XI2\<1\>\/XI2\<1\>\/XI2\<0\>\/RR7_neg \
 ) R_1X_LL w=1e-07 l=1e-07   res=0.149966
XXI2\<1\>\/XI2\<0\>\/XI2\<1\>\/XI2\<1\>\/XI2\<0\>\/XI2\<1\>\/XI2\<1\>\/XI2\<0\>\/RR6 \
 (  \
 N_SEL6\<0\>_XI2\<1\>\/XI2\<0\>\/XI2\<1\>\/XI2\<1\>\/XI2\<0\>\/XI2\<1\>\/XI2\<1\>\/XI2\<0\>\/RR6_pos \
 N_WLSEL\<1462\>_XI2\<1\>\/XI2\<0\>\/XI2\<1\>\/XI2\<1\>\/XI2\<0\>\/XI2\<1\>\/XI2\<1\>\/XI2\<0\>\/RR6_neg \
 ) R_1X_LL w=1e-07 l=1e-07   res=0.149966
XXI2\<1\>\/XI2\<0\>\/XI2\<1\>\/XI2\<1\>\/XI2\<0\>\/XI2\<1\>\/XI2\<1\>\/XI2\<0\>\/RR5 \
 (  \
 N_SEL7\<1\>_XI2\<1\>\/XI2\<0\>\/XI2\<1\>\/XI2\<1\>\/XI2\<0\>\/XI2\<1\>\/XI2\<1\>\/XI2\<0\>\/RR5_pos \
 N_WLSEL\<1463\>_XI2\<1\>\/XI2\<0\>\/XI2\<1\>\/XI2\<1\>\/XI2\<0\>\/XI2\<1\>\/XI2\<1\>\/XI2\<0\>\/RR5_neg \
 ) R_1X_LL w=1e-07 l=1e-07   res=0.149966
XXI2\<1\>\/XI2\<0\>\/XI2\<1\>\/XI2\<1\>\/XI2\<0\>\/XI2\<1\>\/XI2\<1\>\/XI2\<1\>\/RR0 \
 (  \
 N_SEL0\<1\>_XI2\<1\>\/XI2\<0\>\/XI2\<1\>\/XI2\<1\>\/XI2\<0\>\/XI2\<1\>\/XI2\<1\>\/XI2\<1\>\/RR0_pos \
 N_WLSEL\<1464\>_XI2\<1\>\/XI2\<0\>\/XI2\<1\>\/XI2\<1\>\/XI2\<0\>\/XI2\<1\>\/XI2\<1\>\/XI2\<1\>\/RR0_neg \
 ) R_1X_LL w=1e-07 l=1e-07   res=0.149966
XXI2\<1\>\/XI2\<0\>\/XI2\<1\>\/XI2\<1\>\/XI2\<0\>\/XI2\<1\>\/XI2\<1\>\/XI2\<1\>\/RR1 \
 (  \
 N_SEL1\<1\>_XI2\<1\>\/XI2\<0\>\/XI2\<1\>\/XI2\<1\>\/XI2\<0\>\/XI2\<1\>\/XI2\<1\>\/XI2\<1\>\/RR1_pos \
 N_WLSEL\<1465\>_XI2\<1\>\/XI2\<0\>\/XI2\<1\>\/XI2\<1\>\/XI2\<0\>\/XI2\<1\>\/XI2\<1\>\/XI2\<1\>\/RR1_neg \
 ) R_1X_LL w=1e-07 l=1e-07   res=0.149966
XXI2\<1\>\/XI2\<0\>\/XI2\<1\>\/XI2\<1\>\/XI2\<0\>\/XI2\<1\>\/XI2\<1\>\/XI2\<1\>\/RR2 \
 (  \
 N_SEL2\<1\>_XI2\<1\>\/XI2\<0\>\/XI2\<1\>\/XI2\<1\>\/XI2\<0\>\/XI2\<1\>\/XI2\<1\>\/XI2\<1\>\/RR2_pos \
 N_WLSEL\<1466\>_XI2\<1\>\/XI2\<0\>\/XI2\<1\>\/XI2\<1\>\/XI2\<0\>\/XI2\<1\>\/XI2\<1\>\/XI2\<1\>\/RR2_neg \
 ) R_1X_LL w=1e-07 l=1e-07   res=0.149966
XXI2\<1\>\/XI2\<0\>\/XI2\<1\>\/XI2\<1\>\/XI2\<0\>\/XI2\<1\>\/XI2\<1\>\/XI2\<1\>\/RR3 \
 (  \
 N_SEL3\<0\>_XI2\<1\>\/XI2\<0\>\/XI2\<1\>\/XI2\<1\>\/XI2\<0\>\/XI2\<1\>\/XI2\<1\>\/XI2\<1\>\/RR3_pos \
 N_WLSEL\<1467\>_XI2\<1\>\/XI2\<0\>\/XI2\<1\>\/XI2\<1\>\/XI2\<0\>\/XI2\<1\>\/XI2\<1\>\/XI2\<1\>\/RR3_neg \
 ) R_1X_LL w=1e-07 l=1e-07   res=0.149966
XXI2\<1\>\/XI2\<0\>\/XI2\<1\>\/XI2\<1\>\/XI2\<0\>\/XI2\<1\>\/XI2\<1\>\/XI2\<1\>\/RR4 \
 (  \
 N_SEL4\<1\>_XI2\<1\>\/XI2\<0\>\/XI2\<1\>\/XI2\<1\>\/XI2\<0\>\/XI2\<1\>\/XI2\<1\>\/XI2\<1\>\/RR4_pos \
 N_WLSEL\<1468\>_XI2\<1\>\/XI2\<0\>\/XI2\<1\>\/XI2\<1\>\/XI2\<0\>\/XI2\<1\>\/XI2\<1\>\/XI2\<1\>\/RR4_neg \
 ) R_1X_LL w=1e-07 l=1e-07   res=0.149966
XXI2\<1\>\/XI2\<0\>\/XI2\<1\>\/XI2\<1\>\/XI2\<0\>\/XI2\<1\>\/XI2\<1\>\/XI2\<1\>\/RR7 \
 (  \
 N_SEL5\<1\>_XI2\<1\>\/XI2\<0\>\/XI2\<1\>\/XI2\<1\>\/XI2\<0\>\/XI2\<1\>\/XI2\<1\>\/XI2\<1\>\/RR7_pos \
 N_WLSEL\<1469\>_XI2\<1\>\/XI2\<0\>\/XI2\<1\>\/XI2\<1\>\/XI2\<0\>\/XI2\<1\>\/XI2\<1\>\/XI2\<1\>\/RR7_neg \
 ) R_1X_LL w=1e-07 l=1e-07   res=0.149966
XXI2\<1\>\/XI2\<0\>\/XI2\<1\>\/XI2\<1\>\/XI2\<0\>\/XI2\<1\>\/XI2\<1\>\/XI2\<1\>\/RR6 \
 (  \
 N_SEL6\<0\>_XI2\<1\>\/XI2\<0\>\/XI2\<1\>\/XI2\<1\>\/XI2\<0\>\/XI2\<1\>\/XI2\<1\>\/XI2\<1\>\/RR6_pos \
 N_WLSEL\<1470\>_XI2\<1\>\/XI2\<0\>\/XI2\<1\>\/XI2\<1\>\/XI2\<0\>\/XI2\<1\>\/XI2\<1\>\/XI2\<1\>\/RR6_neg \
 ) R_1X_LL w=1e-07 l=1e-07   res=0.149966
XXI2\<1\>\/XI2\<0\>\/XI2\<1\>\/XI2\<1\>\/XI2\<0\>\/XI2\<1\>\/XI2\<1\>\/XI2\<1\>\/RR5 \
 (  \
 N_SEL7\<1\>_XI2\<1\>\/XI2\<0\>\/XI2\<1\>\/XI2\<1\>\/XI2\<0\>\/XI2\<1\>\/XI2\<1\>\/XI2\<1\>\/RR5_pos \
 N_WLSEL\<1471\>_XI2\<1\>\/XI2\<0\>\/XI2\<1\>\/XI2\<1\>\/XI2\<0\>\/XI2\<1\>\/XI2\<1\>\/XI2\<1\>\/RR5_neg \
 ) R_1X_LL w=1e-07 l=1e-07   res=0.149966
XXI2\<1\>\/XI2\<0\>\/XI2\<1\>\/XI2\<1\>\/XI2\<1\>\/XI2\<0\>\/XI2\<0\>\/XI2\<0\>\/RR0 \
 (  \
 N_SEL0\<0\>_XI2\<1\>\/XI2\<0\>\/XI2\<1\>\/XI2\<1\>\/XI2\<1\>\/XI2\<0\>\/XI2\<0\>\/XI2\<0\>\/RR0_pos \
 N_WLSEL\<1472\>_XI2\<1\>\/XI2\<0\>\/XI2\<1\>\/XI2\<1\>\/XI2\<1\>\/XI2\<0\>\/XI2\<0\>\/XI2\<0\>\/RR0_neg \
 ) R_1X_LL w=1e-07 l=1e-07   res=0.149966
XXI2\<1\>\/XI2\<0\>\/XI2\<1\>\/XI2\<1\>\/XI2\<1\>\/XI2\<0\>\/XI2\<0\>\/XI2\<0\>\/RR1 \
 (  \
 N_SEL1\<0\>_XI2\<1\>\/XI2\<0\>\/XI2\<1\>\/XI2\<1\>\/XI2\<1\>\/XI2\<0\>\/XI2\<0\>\/XI2\<0\>\/RR1_pos \
 N_WLSEL\<1473\>_XI2\<1\>\/XI2\<0\>\/XI2\<1\>\/XI2\<1\>\/XI2\<1\>\/XI2\<0\>\/XI2\<0\>\/XI2\<0\>\/RR1_neg \
 ) R_1X_LL w=1e-07 l=1e-07   res=0.149966
XXI2\<1\>\/XI2\<0\>\/XI2\<1\>\/XI2\<1\>\/XI2\<1\>\/XI2\<0\>\/XI2\<0\>\/XI2\<0\>\/RR2 \
 (  \
 N_SEL2\<0\>_XI2\<1\>\/XI2\<0\>\/XI2\<1\>\/XI2\<1\>\/XI2\<1\>\/XI2\<0\>\/XI2\<0\>\/XI2\<0\>\/RR2_pos \
 N_WLSEL\<1474\>_XI2\<1\>\/XI2\<0\>\/XI2\<1\>\/XI2\<1\>\/XI2\<1\>\/XI2\<0\>\/XI2\<0\>\/XI2\<0\>\/RR2_neg \
 ) R_1X_LL w=1e-07 l=1e-07   res=0.149966
XXI2\<1\>\/XI2\<0\>\/XI2\<1\>\/XI2\<1\>\/XI2\<1\>\/XI2\<0\>\/XI2\<0\>\/XI2\<0\>\/RR3 \
 (  \
 N_SEL3\<1\>_XI2\<1\>\/XI2\<0\>\/XI2\<1\>\/XI2\<1\>\/XI2\<1\>\/XI2\<0\>\/XI2\<0\>\/XI2\<0\>\/RR3_pos \
 N_WLSEL\<1475\>_XI2\<1\>\/XI2\<0\>\/XI2\<1\>\/XI2\<1\>\/XI2\<1\>\/XI2\<0\>\/XI2\<0\>\/XI2\<0\>\/RR3_neg \
 ) R_1X_LL w=1e-07 l=1e-07   res=0.149966
XXI2\<1\>\/XI2\<0\>\/XI2\<1\>\/XI2\<1\>\/XI2\<1\>\/XI2\<0\>\/XI2\<0\>\/XI2\<0\>\/RR4 \
 (  \
 N_SEL4\<1\>_XI2\<1\>\/XI2\<0\>\/XI2\<1\>\/XI2\<1\>\/XI2\<1\>\/XI2\<0\>\/XI2\<0\>\/XI2\<0\>\/RR4_pos \
 N_WLSEL\<1476\>_XI2\<1\>\/XI2\<0\>\/XI2\<1\>\/XI2\<1\>\/XI2\<1\>\/XI2\<0\>\/XI2\<0\>\/XI2\<0\>\/RR4_neg \
 ) R_1X_LL w=1e-07 l=1e-07   res=0.149966
XXI2\<1\>\/XI2\<0\>\/XI2\<1\>\/XI2\<1\>\/XI2\<1\>\/XI2\<0\>\/XI2\<0\>\/XI2\<0\>\/RR7 \
 (  \
 N_SEL5\<1\>_XI2\<1\>\/XI2\<0\>\/XI2\<1\>\/XI2\<1\>\/XI2\<1\>\/XI2\<0\>\/XI2\<0\>\/XI2\<0\>\/RR7_pos \
 N_WLSEL\<1477\>_XI2\<1\>\/XI2\<0\>\/XI2\<1\>\/XI2\<1\>\/XI2\<1\>\/XI2\<0\>\/XI2\<0\>\/XI2\<0\>\/RR7_neg \
 ) R_1X_LL w=1e-07 l=1e-07   res=0.149966
XXI2\<1\>\/XI2\<0\>\/XI2\<1\>\/XI2\<1\>\/XI2\<1\>\/XI2\<0\>\/XI2\<0\>\/XI2\<0\>\/RR6 \
 (  \
 N_SEL6\<0\>_XI2\<1\>\/XI2\<0\>\/XI2\<1\>\/XI2\<1\>\/XI2\<1\>\/XI2\<0\>\/XI2\<0\>\/XI2\<0\>\/RR6_pos \
 N_WLSEL\<1478\>_XI2\<1\>\/XI2\<0\>\/XI2\<1\>\/XI2\<1\>\/XI2\<1\>\/XI2\<0\>\/XI2\<0\>\/XI2\<0\>\/RR6_neg \
 ) R_1X_LL w=1e-07 l=1e-07   res=0.149966
XXI2\<1\>\/XI2\<0\>\/XI2\<1\>\/XI2\<1\>\/XI2\<1\>\/XI2\<0\>\/XI2\<0\>\/XI2\<0\>\/RR5 \
 (  \
 N_SEL7\<1\>_XI2\<1\>\/XI2\<0\>\/XI2\<1\>\/XI2\<1\>\/XI2\<1\>\/XI2\<0\>\/XI2\<0\>\/XI2\<0\>\/RR5_pos \
 N_WLSEL\<1479\>_XI2\<1\>\/XI2\<0\>\/XI2\<1\>\/XI2\<1\>\/XI2\<1\>\/XI2\<0\>\/XI2\<0\>\/XI2\<0\>\/RR5_neg \
 ) R_1X_LL w=1e-07 l=1e-07   res=0.149966
XXI2\<1\>\/XI2\<0\>\/XI2\<1\>\/XI2\<1\>\/XI2\<1\>\/XI2\<0\>\/XI2\<0\>\/XI2\<1\>\/RR0 \
 (  \
 N_SEL0\<1\>_XI2\<1\>\/XI2\<0\>\/XI2\<1\>\/XI2\<1\>\/XI2\<1\>\/XI2\<0\>\/XI2\<0\>\/XI2\<1\>\/RR0_pos \
 N_WLSEL\<1480\>_XI2\<1\>\/XI2\<0\>\/XI2\<1\>\/XI2\<1\>\/XI2\<1\>\/XI2\<0\>\/XI2\<0\>\/XI2\<1\>\/RR0_neg \
 ) R_1X_LL w=1e-07 l=1e-07   res=0.149966
XXI2\<1\>\/XI2\<0\>\/XI2\<1\>\/XI2\<1\>\/XI2\<1\>\/XI2\<0\>\/XI2\<0\>\/XI2\<1\>\/RR1 \
 (  \
 N_SEL1\<0\>_XI2\<1\>\/XI2\<0\>\/XI2\<1\>\/XI2\<1\>\/XI2\<1\>\/XI2\<0\>\/XI2\<0\>\/XI2\<1\>\/RR1_pos \
 N_WLSEL\<1481\>_XI2\<1\>\/XI2\<0\>\/XI2\<1\>\/XI2\<1\>\/XI2\<1\>\/XI2\<0\>\/XI2\<0\>\/XI2\<1\>\/RR1_neg \
 ) R_1X_LL w=1e-07 l=1e-07   res=0.149966
XXI2\<1\>\/XI2\<0\>\/XI2\<1\>\/XI2\<1\>\/XI2\<1\>\/XI2\<0\>\/XI2\<0\>\/XI2\<1\>\/RR2 \
 (  \
 N_SEL2\<0\>_XI2\<1\>\/XI2\<0\>\/XI2\<1\>\/XI2\<1\>\/XI2\<1\>\/XI2\<0\>\/XI2\<0\>\/XI2\<1\>\/RR2_pos \
 N_WLSEL\<1482\>_XI2\<1\>\/XI2\<0\>\/XI2\<1\>\/XI2\<1\>\/XI2\<1\>\/XI2\<0\>\/XI2\<0\>\/XI2\<1\>\/RR2_neg \
 ) R_1X_LL w=1e-07 l=1e-07   res=0.149966
XXI2\<1\>\/XI2\<0\>\/XI2\<1\>\/XI2\<1\>\/XI2\<1\>\/XI2\<0\>\/XI2\<0\>\/XI2\<1\>\/RR3 \
 (  \
 N_SEL3\<1\>_XI2\<1\>\/XI2\<0\>\/XI2\<1\>\/XI2\<1\>\/XI2\<1\>\/XI2\<0\>\/XI2\<0\>\/XI2\<1\>\/RR3_pos \
 N_WLSEL\<1483\>_XI2\<1\>\/XI2\<0\>\/XI2\<1\>\/XI2\<1\>\/XI2\<1\>\/XI2\<0\>\/XI2\<0\>\/XI2\<1\>\/RR3_neg \
 ) R_1X_LL w=1e-07 l=1e-07   res=0.149966
XXI2\<1\>\/XI2\<0\>\/XI2\<1\>\/XI2\<1\>\/XI2\<1\>\/XI2\<0\>\/XI2\<0\>\/XI2\<1\>\/RR4 \
 (  \
 N_SEL4\<1\>_XI2\<1\>\/XI2\<0\>\/XI2\<1\>\/XI2\<1\>\/XI2\<1\>\/XI2\<0\>\/XI2\<0\>\/XI2\<1\>\/RR4_pos \
 N_WLSEL\<1484\>_XI2\<1\>\/XI2\<0\>\/XI2\<1\>\/XI2\<1\>\/XI2\<1\>\/XI2\<0\>\/XI2\<0\>\/XI2\<1\>\/RR4_neg \
 ) R_1X_LL w=1e-07 l=1e-07   res=0.149966
XXI2\<1\>\/XI2\<0\>\/XI2\<1\>\/XI2\<1\>\/XI2\<1\>\/XI2\<0\>\/XI2\<0\>\/XI2\<1\>\/RR7 \
 (  \
 N_SEL5\<1\>_XI2\<1\>\/XI2\<0\>\/XI2\<1\>\/XI2\<1\>\/XI2\<1\>\/XI2\<0\>\/XI2\<0\>\/XI2\<1\>\/RR7_pos \
 N_WLSEL\<1485\>_XI2\<1\>\/XI2\<0\>\/XI2\<1\>\/XI2\<1\>\/XI2\<1\>\/XI2\<0\>\/XI2\<0\>\/XI2\<1\>\/RR7_neg \
 ) R_1X_LL w=1e-07 l=1e-07   res=0.149966
XXI2\<1\>\/XI2\<0\>\/XI2\<1\>\/XI2\<1\>\/XI2\<1\>\/XI2\<0\>\/XI2\<0\>\/XI2\<1\>\/RR6 \
 (  \
 N_SEL6\<0\>_XI2\<1\>\/XI2\<0\>\/XI2\<1\>\/XI2\<1\>\/XI2\<1\>\/XI2\<0\>\/XI2\<0\>\/XI2\<1\>\/RR6_pos \
 N_WLSEL\<1486\>_XI2\<1\>\/XI2\<0\>\/XI2\<1\>\/XI2\<1\>\/XI2\<1\>\/XI2\<0\>\/XI2\<0\>\/XI2\<1\>\/RR6_neg \
 ) R_1X_LL w=1e-07 l=1e-07   res=0.149966
XXI2\<1\>\/XI2\<0\>\/XI2\<1\>\/XI2\<1\>\/XI2\<1\>\/XI2\<0\>\/XI2\<0\>\/XI2\<1\>\/RR5 \
 (  \
 N_SEL7\<1\>_XI2\<1\>\/XI2\<0\>\/XI2\<1\>\/XI2\<1\>\/XI2\<1\>\/XI2\<0\>\/XI2\<0\>\/XI2\<1\>\/RR5_pos \
 N_WLSEL\<1487\>_XI2\<1\>\/XI2\<0\>\/XI2\<1\>\/XI2\<1\>\/XI2\<1\>\/XI2\<0\>\/XI2\<0\>\/XI2\<1\>\/RR5_neg \
 ) R_1X_LL w=1e-07 l=1e-07   res=0.149966
XXI2\<1\>\/XI2\<0\>\/XI2\<1\>\/XI2\<1\>\/XI2\<1\>\/XI2\<0\>\/XI2\<1\>\/XI2\<0\>\/RR0 \
 (  \
 N_SEL0\<0\>_XI2\<1\>\/XI2\<0\>\/XI2\<1\>\/XI2\<1\>\/XI2\<1\>\/XI2\<0\>\/XI2\<1\>\/XI2\<0\>\/RR0_pos \
 N_WLSEL\<1488\>_XI2\<1\>\/XI2\<0\>\/XI2\<1\>\/XI2\<1\>\/XI2\<1\>\/XI2\<0\>\/XI2\<1\>\/XI2\<0\>\/RR0_neg \
 ) R_1X_LL w=1e-07 l=1e-07   res=0.149966
XXI2\<1\>\/XI2\<0\>\/XI2\<1\>\/XI2\<1\>\/XI2\<1\>\/XI2\<0\>\/XI2\<1\>\/XI2\<0\>\/RR1 \
 (  \
 N_SEL1\<1\>_XI2\<1\>\/XI2\<0\>\/XI2\<1\>\/XI2\<1\>\/XI2\<1\>\/XI2\<0\>\/XI2\<1\>\/XI2\<0\>\/RR1_pos \
 N_WLSEL\<1489\>_XI2\<1\>\/XI2\<0\>\/XI2\<1\>\/XI2\<1\>\/XI2\<1\>\/XI2\<0\>\/XI2\<1\>\/XI2\<0\>\/RR1_neg \
 ) R_1X_LL w=1e-07 l=1e-07   res=0.149966
XXI2\<1\>\/XI2\<0\>\/XI2\<1\>\/XI2\<1\>\/XI2\<1\>\/XI2\<0\>\/XI2\<1\>\/XI2\<0\>\/RR2 \
 (  \
 N_SEL2\<0\>_XI2\<1\>\/XI2\<0\>\/XI2\<1\>\/XI2\<1\>\/XI2\<1\>\/XI2\<0\>\/XI2\<1\>\/XI2\<0\>\/RR2_pos \
 N_WLSEL\<1490\>_XI2\<1\>\/XI2\<0\>\/XI2\<1\>\/XI2\<1\>\/XI2\<1\>\/XI2\<0\>\/XI2\<1\>\/XI2\<0\>\/RR2_neg \
 ) R_1X_LL w=1e-07 l=1e-07   res=0.149966
XXI2\<1\>\/XI2\<0\>\/XI2\<1\>\/XI2\<1\>\/XI2\<1\>\/XI2\<0\>\/XI2\<1\>\/XI2\<0\>\/RR3 \
 (  \
 N_SEL3\<1\>_XI2\<1\>\/XI2\<0\>\/XI2\<1\>\/XI2\<1\>\/XI2\<1\>\/XI2\<0\>\/XI2\<1\>\/XI2\<0\>\/RR3_pos \
 N_WLSEL\<1491\>_XI2\<1\>\/XI2\<0\>\/XI2\<1\>\/XI2\<1\>\/XI2\<1\>\/XI2\<0\>\/XI2\<1\>\/XI2\<0\>\/RR3_neg \
 ) R_1X_LL w=1e-07 l=1e-07   res=0.149966
XXI2\<1\>\/XI2\<0\>\/XI2\<1\>\/XI2\<1\>\/XI2\<1\>\/XI2\<0\>\/XI2\<1\>\/XI2\<0\>\/RR4 \
 (  \
 N_SEL4\<1\>_XI2\<1\>\/XI2\<0\>\/XI2\<1\>\/XI2\<1\>\/XI2\<1\>\/XI2\<0\>\/XI2\<1\>\/XI2\<0\>\/RR4_pos \
 N_WLSEL\<1492\>_XI2\<1\>\/XI2\<0\>\/XI2\<1\>\/XI2\<1\>\/XI2\<1\>\/XI2\<0\>\/XI2\<1\>\/XI2\<0\>\/RR4_neg \
 ) R_1X_LL w=1e-07 l=1e-07   res=0.149966
XXI2\<1\>\/XI2\<0\>\/XI2\<1\>\/XI2\<1\>\/XI2\<1\>\/XI2\<0\>\/XI2\<1\>\/XI2\<0\>\/RR7 \
 (  \
 N_SEL5\<1\>_XI2\<1\>\/XI2\<0\>\/XI2\<1\>\/XI2\<1\>\/XI2\<1\>\/XI2\<0\>\/XI2\<1\>\/XI2\<0\>\/RR7_pos \
 N_WLSEL\<1493\>_XI2\<1\>\/XI2\<0\>\/XI2\<1\>\/XI2\<1\>\/XI2\<1\>\/XI2\<0\>\/XI2\<1\>\/XI2\<0\>\/RR7_neg \
 ) R_1X_LL w=1e-07 l=1e-07   res=0.149966
XXI2\<1\>\/XI2\<0\>\/XI2\<1\>\/XI2\<1\>\/XI2\<1\>\/XI2\<0\>\/XI2\<1\>\/XI2\<0\>\/RR6 \
 (  \
 N_SEL6\<0\>_XI2\<1\>\/XI2\<0\>\/XI2\<1\>\/XI2\<1\>\/XI2\<1\>\/XI2\<0\>\/XI2\<1\>\/XI2\<0\>\/RR6_pos \
 N_WLSEL\<1494\>_XI2\<1\>\/XI2\<0\>\/XI2\<1\>\/XI2\<1\>\/XI2\<1\>\/XI2\<0\>\/XI2\<1\>\/XI2\<0\>\/RR6_neg \
 ) R_1X_LL w=1e-07 l=1e-07   res=0.149966
XXI2\<1\>\/XI2\<0\>\/XI2\<1\>\/XI2\<1\>\/XI2\<1\>\/XI2\<0\>\/XI2\<1\>\/XI2\<0\>\/RR5 \
 (  \
 N_SEL7\<1\>_XI2\<1\>\/XI2\<0\>\/XI2\<1\>\/XI2\<1\>\/XI2\<1\>\/XI2\<0\>\/XI2\<1\>\/XI2\<0\>\/RR5_pos \
 N_WLSEL\<1495\>_XI2\<1\>\/XI2\<0\>\/XI2\<1\>\/XI2\<1\>\/XI2\<1\>\/XI2\<0\>\/XI2\<1\>\/XI2\<0\>\/RR5_neg \
 ) R_1X_LL w=1e-07 l=1e-07   res=0.149966
XXI2\<1\>\/XI2\<0\>\/XI2\<1\>\/XI2\<1\>\/XI2\<1\>\/XI2\<0\>\/XI2\<1\>\/XI2\<1\>\/RR0 \
 (  \
 N_SEL0\<1\>_XI2\<1\>\/XI2\<0\>\/XI2\<1\>\/XI2\<1\>\/XI2\<1\>\/XI2\<0\>\/XI2\<1\>\/XI2\<1\>\/RR0_pos \
 N_WLSEL\<1496\>_XI2\<1\>\/XI2\<0\>\/XI2\<1\>\/XI2\<1\>\/XI2\<1\>\/XI2\<0\>\/XI2\<1\>\/XI2\<1\>\/RR0_neg \
 ) R_1X_LL w=1e-07 l=1e-07   res=0.149966
XXI2\<1\>\/XI2\<0\>\/XI2\<1\>\/XI2\<1\>\/XI2\<1\>\/XI2\<0\>\/XI2\<1\>\/XI2\<1\>\/RR1 \
 (  \
 N_SEL1\<1\>_XI2\<1\>\/XI2\<0\>\/XI2\<1\>\/XI2\<1\>\/XI2\<1\>\/XI2\<0\>\/XI2\<1\>\/XI2\<1\>\/RR1_pos \
 N_WLSEL\<1497\>_XI2\<1\>\/XI2\<0\>\/XI2\<1\>\/XI2\<1\>\/XI2\<1\>\/XI2\<0\>\/XI2\<1\>\/XI2\<1\>\/RR1_neg \
 ) R_1X_LL w=1e-07 l=1e-07   res=0.149966
XXI2\<1\>\/XI2\<0\>\/XI2\<1\>\/XI2\<1\>\/XI2\<1\>\/XI2\<0\>\/XI2\<1\>\/XI2\<1\>\/RR2 \
 (  \
 N_SEL2\<0\>_XI2\<1\>\/XI2\<0\>\/XI2\<1\>\/XI2\<1\>\/XI2\<1\>\/XI2\<0\>\/XI2\<1\>\/XI2\<1\>\/RR2_pos \
 N_WLSEL\<1498\>_XI2\<1\>\/XI2\<0\>\/XI2\<1\>\/XI2\<1\>\/XI2\<1\>\/XI2\<0\>\/XI2\<1\>\/XI2\<1\>\/RR2_neg \
 ) R_1X_LL w=1e-07 l=1e-07   res=0.149966
XXI2\<1\>\/XI2\<0\>\/XI2\<1\>\/XI2\<1\>\/XI2\<1\>\/XI2\<0\>\/XI2\<1\>\/XI2\<1\>\/RR3 \
 (  \
 N_SEL3\<1\>_XI2\<1\>\/XI2\<0\>\/XI2\<1\>\/XI2\<1\>\/XI2\<1\>\/XI2\<0\>\/XI2\<1\>\/XI2\<1\>\/RR3_pos \
 N_WLSEL\<1499\>_XI2\<1\>\/XI2\<0\>\/XI2\<1\>\/XI2\<1\>\/XI2\<1\>\/XI2\<0\>\/XI2\<1\>\/XI2\<1\>\/RR3_neg \
 ) R_1X_LL w=1e-07 l=1e-07   res=0.149966
XXI2\<1\>\/XI2\<0\>\/XI2\<1\>\/XI2\<1\>\/XI2\<1\>\/XI2\<0\>\/XI2\<1\>\/XI2\<1\>\/RR4 \
 (  \
 N_SEL4\<1\>_XI2\<1\>\/XI2\<0\>\/XI2\<1\>\/XI2\<1\>\/XI2\<1\>\/XI2\<0\>\/XI2\<1\>\/XI2\<1\>\/RR4_pos \
 N_WLSEL\<1500\>_XI2\<1\>\/XI2\<0\>\/XI2\<1\>\/XI2\<1\>\/XI2\<1\>\/XI2\<0\>\/XI2\<1\>\/XI2\<1\>\/RR4_neg \
 ) R_1X_LL w=1e-07 l=1e-07   res=0.149966
XXI2\<1\>\/XI2\<0\>\/XI2\<1\>\/XI2\<1\>\/XI2\<1\>\/XI2\<0\>\/XI2\<1\>\/XI2\<1\>\/RR7 \
 (  \
 N_SEL5\<1\>_XI2\<1\>\/XI2\<0\>\/XI2\<1\>\/XI2\<1\>\/XI2\<1\>\/XI2\<0\>\/XI2\<1\>\/XI2\<1\>\/RR7_pos \
 N_WLSEL\<1501\>_XI2\<1\>\/XI2\<0\>\/XI2\<1\>\/XI2\<1\>\/XI2\<1\>\/XI2\<0\>\/XI2\<1\>\/XI2\<1\>\/RR7_neg \
 ) R_1X_LL w=1e-07 l=1e-07   res=0.149966
XXI2\<1\>\/XI2\<0\>\/XI2\<1\>\/XI2\<1\>\/XI2\<1\>\/XI2\<0\>\/XI2\<1\>\/XI2\<1\>\/RR6 \
 (  \
 N_SEL6\<0\>_XI2\<1\>\/XI2\<0\>\/XI2\<1\>\/XI2\<1\>\/XI2\<1\>\/XI2\<0\>\/XI2\<1\>\/XI2\<1\>\/RR6_pos \
 N_WLSEL\<1502\>_XI2\<1\>\/XI2\<0\>\/XI2\<1\>\/XI2\<1\>\/XI2\<1\>\/XI2\<0\>\/XI2\<1\>\/XI2\<1\>\/RR6_neg \
 ) R_1X_LL w=1e-07 l=1e-07   res=0.149966
XXI2\<1\>\/XI2\<0\>\/XI2\<1\>\/XI2\<1\>\/XI2\<1\>\/XI2\<0\>\/XI2\<1\>\/XI2\<1\>\/RR5 \
 (  \
 N_SEL7\<1\>_XI2\<1\>\/XI2\<0\>\/XI2\<1\>\/XI2\<1\>\/XI2\<1\>\/XI2\<0\>\/XI2\<1\>\/XI2\<1\>\/RR5_pos \
 N_WLSEL\<1503\>_XI2\<1\>\/XI2\<0\>\/XI2\<1\>\/XI2\<1\>\/XI2\<1\>\/XI2\<0\>\/XI2\<1\>\/XI2\<1\>\/RR5_neg \
 ) R_1X_LL w=1e-07 l=1e-07   res=0.149966
XXI2\<1\>\/XI2\<0\>\/XI2\<1\>\/XI2\<1\>\/XI2\<1\>\/XI2\<1\>\/XI2\<0\>\/XI2\<0\>\/RR0 \
 (  \
 N_SEL0\<0\>_XI2\<1\>\/XI2\<0\>\/XI2\<1\>\/XI2\<1\>\/XI2\<1\>\/XI2\<1\>\/XI2\<0\>\/XI2\<0\>\/RR0_pos \
 N_WLSEL\<1504\>_XI2\<1\>\/XI2\<0\>\/XI2\<1\>\/XI2\<1\>\/XI2\<1\>\/XI2\<1\>\/XI2\<0\>\/XI2\<0\>\/RR0_neg \
 ) R_1X_LL w=1e-07 l=1e-07   res=0.149966
XXI2\<1\>\/XI2\<0\>\/XI2\<1\>\/XI2\<1\>\/XI2\<1\>\/XI2\<1\>\/XI2\<0\>\/XI2\<0\>\/RR1 \
 (  \
 N_SEL1\<0\>_XI2\<1\>\/XI2\<0\>\/XI2\<1\>\/XI2\<1\>\/XI2\<1\>\/XI2\<1\>\/XI2\<0\>\/XI2\<0\>\/RR1_pos \
 N_WLSEL\<1505\>_XI2\<1\>\/XI2\<0\>\/XI2\<1\>\/XI2\<1\>\/XI2\<1\>\/XI2\<1\>\/XI2\<0\>\/XI2\<0\>\/RR1_neg \
 ) R_1X_LL w=1e-07 l=1e-07   res=0.149966
XXI2\<1\>\/XI2\<0\>\/XI2\<1\>\/XI2\<1\>\/XI2\<1\>\/XI2\<1\>\/XI2\<0\>\/XI2\<0\>\/RR2 \
 (  \
 N_SEL2\<1\>_XI2\<1\>\/XI2\<0\>\/XI2\<1\>\/XI2\<1\>\/XI2\<1\>\/XI2\<1\>\/XI2\<0\>\/XI2\<0\>\/RR2_pos \
 N_WLSEL\<1506\>_XI2\<1\>\/XI2\<0\>\/XI2\<1\>\/XI2\<1\>\/XI2\<1\>\/XI2\<1\>\/XI2\<0\>\/XI2\<0\>\/RR2_neg \
 ) R_1X_LL w=1e-07 l=1e-07   res=0.149966
XXI2\<1\>\/XI2\<0\>\/XI2\<1\>\/XI2\<1\>\/XI2\<1\>\/XI2\<1\>\/XI2\<0\>\/XI2\<0\>\/RR3 \
 (  \
 N_SEL3\<1\>_XI2\<1\>\/XI2\<0\>\/XI2\<1\>\/XI2\<1\>\/XI2\<1\>\/XI2\<1\>\/XI2\<0\>\/XI2\<0\>\/RR3_pos \
 N_WLSEL\<1507\>_XI2\<1\>\/XI2\<0\>\/XI2\<1\>\/XI2\<1\>\/XI2\<1\>\/XI2\<1\>\/XI2\<0\>\/XI2\<0\>\/RR3_neg \
 ) R_1X_LL w=1e-07 l=1e-07   res=0.149966
XXI2\<1\>\/XI2\<0\>\/XI2\<1\>\/XI2\<1\>\/XI2\<1\>\/XI2\<1\>\/XI2\<0\>\/XI2\<0\>\/RR4 \
 (  \
 N_SEL4\<1\>_XI2\<1\>\/XI2\<0\>\/XI2\<1\>\/XI2\<1\>\/XI2\<1\>\/XI2\<1\>\/XI2\<0\>\/XI2\<0\>\/RR4_pos \
 N_WLSEL\<1508\>_XI2\<1\>\/XI2\<0\>\/XI2\<1\>\/XI2\<1\>\/XI2\<1\>\/XI2\<1\>\/XI2\<0\>\/XI2\<0\>\/RR4_neg \
 ) R_1X_LL w=1e-07 l=1e-07   res=0.149966
XXI2\<1\>\/XI2\<0\>\/XI2\<1\>\/XI2\<1\>\/XI2\<1\>\/XI2\<1\>\/XI2\<0\>\/XI2\<0\>\/RR7 \
 (  \
 N_SEL5\<1\>_XI2\<1\>\/XI2\<0\>\/XI2\<1\>\/XI2\<1\>\/XI2\<1\>\/XI2\<1\>\/XI2\<0\>\/XI2\<0\>\/RR7_pos \
 N_WLSEL\<1509\>_XI2\<1\>\/XI2\<0\>\/XI2\<1\>\/XI2\<1\>\/XI2\<1\>\/XI2\<1\>\/XI2\<0\>\/XI2\<0\>\/RR7_neg \
 ) R_1X_LL w=1e-07 l=1e-07   res=0.149966
XXI2\<1\>\/XI2\<0\>\/XI2\<1\>\/XI2\<1\>\/XI2\<1\>\/XI2\<1\>\/XI2\<0\>\/XI2\<0\>\/RR6 \
 (  \
 N_SEL6\<0\>_XI2\<1\>\/XI2\<0\>\/XI2\<1\>\/XI2\<1\>\/XI2\<1\>\/XI2\<1\>\/XI2\<0\>\/XI2\<0\>\/RR6_pos \
 N_WLSEL\<1510\>_XI2\<1\>\/XI2\<0\>\/XI2\<1\>\/XI2\<1\>\/XI2\<1\>\/XI2\<1\>\/XI2\<0\>\/XI2\<0\>\/RR6_neg \
 ) R_1X_LL w=1e-07 l=1e-07   res=0.149966
XXI2\<1\>\/XI2\<0\>\/XI2\<1\>\/XI2\<1\>\/XI2\<1\>\/XI2\<1\>\/XI2\<0\>\/XI2\<0\>\/RR5 \
 (  \
 N_SEL7\<1\>_XI2\<1\>\/XI2\<0\>\/XI2\<1\>\/XI2\<1\>\/XI2\<1\>\/XI2\<1\>\/XI2\<0\>\/XI2\<0\>\/RR5_pos \
 N_WLSEL\<1511\>_XI2\<1\>\/XI2\<0\>\/XI2\<1\>\/XI2\<1\>\/XI2\<1\>\/XI2\<1\>\/XI2\<0\>\/XI2\<0\>\/RR5_neg \
 ) R_1X_LL w=1e-07 l=1e-07   res=0.149966
XXI2\<1\>\/XI2\<0\>\/XI2\<1\>\/XI2\<1\>\/XI2\<1\>\/XI2\<1\>\/XI2\<0\>\/XI2\<1\>\/RR0 \
 (  \
 N_SEL0\<1\>_XI2\<1\>\/XI2\<0\>\/XI2\<1\>\/XI2\<1\>\/XI2\<1\>\/XI2\<1\>\/XI2\<0\>\/XI2\<1\>\/RR0_pos \
 N_WLSEL\<1512\>_XI2\<1\>\/XI2\<0\>\/XI2\<1\>\/XI2\<1\>\/XI2\<1\>\/XI2\<1\>\/XI2\<0\>\/XI2\<1\>\/RR0_neg \
 ) R_1X_LL w=1e-07 l=1e-07   res=0.149966
XXI2\<1\>\/XI2\<0\>\/XI2\<1\>\/XI2\<1\>\/XI2\<1\>\/XI2\<1\>\/XI2\<0\>\/XI2\<1\>\/RR1 \
 (  \
 N_SEL1\<0\>_XI2\<1\>\/XI2\<0\>\/XI2\<1\>\/XI2\<1\>\/XI2\<1\>\/XI2\<1\>\/XI2\<0\>\/XI2\<1\>\/RR1_pos \
 N_WLSEL\<1513\>_XI2\<1\>\/XI2\<0\>\/XI2\<1\>\/XI2\<1\>\/XI2\<1\>\/XI2\<1\>\/XI2\<0\>\/XI2\<1\>\/RR1_neg \
 ) R_1X_LL w=1e-07 l=1e-07   res=0.149966
XXI2\<1\>\/XI2\<0\>\/XI2\<1\>\/XI2\<1\>\/XI2\<1\>\/XI2\<1\>\/XI2\<0\>\/XI2\<1\>\/RR2 \
 (  \
 N_SEL2\<1\>_XI2\<1\>\/XI2\<0\>\/XI2\<1\>\/XI2\<1\>\/XI2\<1\>\/XI2\<1\>\/XI2\<0\>\/XI2\<1\>\/RR2_pos \
 N_WLSEL\<1514\>_XI2\<1\>\/XI2\<0\>\/XI2\<1\>\/XI2\<1\>\/XI2\<1\>\/XI2\<1\>\/XI2\<0\>\/XI2\<1\>\/RR2_neg \
 ) R_1X_LL w=1e-07 l=1e-07   res=0.149966
XXI2\<1\>\/XI2\<0\>\/XI2\<1\>\/XI2\<1\>\/XI2\<1\>\/XI2\<1\>\/XI2\<0\>\/XI2\<1\>\/RR3 \
 (  \
 N_SEL3\<1\>_XI2\<1\>\/XI2\<0\>\/XI2\<1\>\/XI2\<1\>\/XI2\<1\>\/XI2\<1\>\/XI2\<0\>\/XI2\<1\>\/RR3_pos \
 N_WLSEL\<1515\>_XI2\<1\>\/XI2\<0\>\/XI2\<1\>\/XI2\<1\>\/XI2\<1\>\/XI2\<1\>\/XI2\<0\>\/XI2\<1\>\/RR3_neg \
 ) R_1X_LL w=1e-07 l=1e-07   res=0.149966
XXI2\<1\>\/XI2\<0\>\/XI2\<1\>\/XI2\<1\>\/XI2\<1\>\/XI2\<1\>\/XI2\<0\>\/XI2\<1\>\/RR4 \
 (  \
 N_SEL4\<1\>_XI2\<1\>\/XI2\<0\>\/XI2\<1\>\/XI2\<1\>\/XI2\<1\>\/XI2\<1\>\/XI2\<0\>\/XI2\<1\>\/RR4_pos \
 N_WLSEL\<1516\>_XI2\<1\>\/XI2\<0\>\/XI2\<1\>\/XI2\<1\>\/XI2\<1\>\/XI2\<1\>\/XI2\<0\>\/XI2\<1\>\/RR4_neg \
 ) R_1X_LL w=1e-07 l=1e-07   res=0.149966
XXI2\<1\>\/XI2\<0\>\/XI2\<1\>\/XI2\<1\>\/XI2\<1\>\/XI2\<1\>\/XI2\<0\>\/XI2\<1\>\/RR7 \
 (  \
 N_SEL5\<1\>_XI2\<1\>\/XI2\<0\>\/XI2\<1\>\/XI2\<1\>\/XI2\<1\>\/XI2\<1\>\/XI2\<0\>\/XI2\<1\>\/RR7_pos \
 N_WLSEL\<1517\>_XI2\<1\>\/XI2\<0\>\/XI2\<1\>\/XI2\<1\>\/XI2\<1\>\/XI2\<1\>\/XI2\<0\>\/XI2\<1\>\/RR7_neg \
 ) R_1X_LL w=1e-07 l=1e-07   res=0.149966
XXI2\<1\>\/XI2\<0\>\/XI2\<1\>\/XI2\<1\>\/XI2\<1\>\/XI2\<1\>\/XI2\<0\>\/XI2\<1\>\/RR6 \
 (  \
 N_SEL6\<0\>_XI2\<1\>\/XI2\<0\>\/XI2\<1\>\/XI2\<1\>\/XI2\<1\>\/XI2\<1\>\/XI2\<0\>\/XI2\<1\>\/RR6_pos \
 N_WLSEL\<1518\>_XI2\<1\>\/XI2\<0\>\/XI2\<1\>\/XI2\<1\>\/XI2\<1\>\/XI2\<1\>\/XI2\<0\>\/XI2\<1\>\/RR6_neg \
 ) R_1X_LL w=1e-07 l=1e-07   res=0.149966
XXI2\<1\>\/XI2\<0\>\/XI2\<1\>\/XI2\<1\>\/XI2\<1\>\/XI2\<1\>\/XI2\<0\>\/XI2\<1\>\/RR5 \
 (  \
 N_SEL7\<1\>_XI2\<1\>\/XI2\<0\>\/XI2\<1\>\/XI2\<1\>\/XI2\<1\>\/XI2\<1\>\/XI2\<0\>\/XI2\<1\>\/RR5_pos \
 N_WLSEL\<1519\>_XI2\<1\>\/XI2\<0\>\/XI2\<1\>\/XI2\<1\>\/XI2\<1\>\/XI2\<1\>\/XI2\<0\>\/XI2\<1\>\/RR5_neg \
 ) R_1X_LL w=1e-07 l=1e-07   res=0.149966
XXI2\<1\>\/XI2\<0\>\/XI2\<1\>\/XI2\<1\>\/XI2\<1\>\/XI2\<1\>\/XI2\<1\>\/XI2\<0\>\/RR0 \
 (  \
 N_SEL0\<0\>_XI2\<1\>\/XI2\<0\>\/XI2\<1\>\/XI2\<1\>\/XI2\<1\>\/XI2\<1\>\/XI2\<1\>\/XI2\<0\>\/RR0_pos \
 N_WLSEL\<1520\>_XI2\<1\>\/XI2\<0\>\/XI2\<1\>\/XI2\<1\>\/XI2\<1\>\/XI2\<1\>\/XI2\<1\>\/XI2\<0\>\/RR0_neg \
 ) R_1X_LL w=1e-07 l=1e-07   res=0.149966
XXI2\<1\>\/XI2\<0\>\/XI2\<1\>\/XI2\<1\>\/XI2\<1\>\/XI2\<1\>\/XI2\<1\>\/XI2\<0\>\/RR1 \
 (  \
 N_SEL1\<1\>_XI2\<1\>\/XI2\<0\>\/XI2\<1\>\/XI2\<1\>\/XI2\<1\>\/XI2\<1\>\/XI2\<1\>\/XI2\<0\>\/RR1_pos \
 N_WLSEL\<1521\>_XI2\<1\>\/XI2\<0\>\/XI2\<1\>\/XI2\<1\>\/XI2\<1\>\/XI2\<1\>\/XI2\<1\>\/XI2\<0\>\/RR1_neg \
 ) R_1X_LL w=1e-07 l=1e-07   res=0.149966
XXI2\<1\>\/XI2\<0\>\/XI2\<1\>\/XI2\<1\>\/XI2\<1\>\/XI2\<1\>\/XI2\<1\>\/XI2\<0\>\/RR2 \
 (  \
 N_SEL2\<1\>_XI2\<1\>\/XI2\<0\>\/XI2\<1\>\/XI2\<1\>\/XI2\<1\>\/XI2\<1\>\/XI2\<1\>\/XI2\<0\>\/RR2_pos \
 N_WLSEL\<1522\>_XI2\<1\>\/XI2\<0\>\/XI2\<1\>\/XI2\<1\>\/XI2\<1\>\/XI2\<1\>\/XI2\<1\>\/XI2\<0\>\/RR2_neg \
 ) R_1X_LL w=1e-07 l=1e-07   res=0.149966
XXI2\<1\>\/XI2\<0\>\/XI2\<1\>\/XI2\<1\>\/XI2\<1\>\/XI2\<1\>\/XI2\<1\>\/XI2\<0\>\/RR3 \
 (  \
 N_SEL3\<1\>_XI2\<1\>\/XI2\<0\>\/XI2\<1\>\/XI2\<1\>\/XI2\<1\>\/XI2\<1\>\/XI2\<1\>\/XI2\<0\>\/RR3_pos \
 N_WLSEL\<1523\>_XI2\<1\>\/XI2\<0\>\/XI2\<1\>\/XI2\<1\>\/XI2\<1\>\/XI2\<1\>\/XI2\<1\>\/XI2\<0\>\/RR3_neg \
 ) R_1X_LL w=1e-07 l=1e-07   res=0.149966
XXI2\<1\>\/XI2\<0\>\/XI2\<1\>\/XI2\<1\>\/XI2\<1\>\/XI2\<1\>\/XI2\<1\>\/XI2\<0\>\/RR4 \
 (  \
 N_SEL4\<1\>_XI2\<1\>\/XI2\<0\>\/XI2\<1\>\/XI2\<1\>\/XI2\<1\>\/XI2\<1\>\/XI2\<1\>\/XI2\<0\>\/RR4_pos \
 N_WLSEL\<1524\>_XI2\<1\>\/XI2\<0\>\/XI2\<1\>\/XI2\<1\>\/XI2\<1\>\/XI2\<1\>\/XI2\<1\>\/XI2\<0\>\/RR4_neg \
 ) R_1X_LL w=1e-07 l=1e-07   res=0.149966
XXI2\<1\>\/XI2\<0\>\/XI2\<1\>\/XI2\<1\>\/XI2\<1\>\/XI2\<1\>\/XI2\<1\>\/XI2\<0\>\/RR7 \
 (  \
 N_SEL5\<1\>_XI2\<1\>\/XI2\<0\>\/XI2\<1\>\/XI2\<1\>\/XI2\<1\>\/XI2\<1\>\/XI2\<1\>\/XI2\<0\>\/RR7_pos \
 N_WLSEL\<1525\>_XI2\<1\>\/XI2\<0\>\/XI2\<1\>\/XI2\<1\>\/XI2\<1\>\/XI2\<1\>\/XI2\<1\>\/XI2\<0\>\/RR7_neg \
 ) R_1X_LL w=1e-07 l=1e-07   res=0.149966
XXI2\<1\>\/XI2\<0\>\/XI2\<1\>\/XI2\<1\>\/XI2\<1\>\/XI2\<1\>\/XI2\<1\>\/XI2\<0\>\/RR6 \
 (  \
 N_SEL6\<0\>_XI2\<1\>\/XI2\<0\>\/XI2\<1\>\/XI2\<1\>\/XI2\<1\>\/XI2\<1\>\/XI2\<1\>\/XI2\<0\>\/RR6_pos \
 N_WLSEL\<1526\>_XI2\<1\>\/XI2\<0\>\/XI2\<1\>\/XI2\<1\>\/XI2\<1\>\/XI2\<1\>\/XI2\<1\>\/XI2\<0\>\/RR6_neg \
 ) R_1X_LL w=1e-07 l=1e-07   res=0.149966
XXI2\<1\>\/XI2\<0\>\/XI2\<1\>\/XI2\<1\>\/XI2\<1\>\/XI2\<1\>\/XI2\<1\>\/XI2\<0\>\/RR5 \
 (  \
 N_SEL7\<1\>_XI2\<1\>\/XI2\<0\>\/XI2\<1\>\/XI2\<1\>\/XI2\<1\>\/XI2\<1\>\/XI2\<1\>\/XI2\<0\>\/RR5_pos \
 N_WLSEL\<1527\>_XI2\<1\>\/XI2\<0\>\/XI2\<1\>\/XI2\<1\>\/XI2\<1\>\/XI2\<1\>\/XI2\<1\>\/XI2\<0\>\/RR5_neg \
 ) R_1X_LL w=1e-07 l=1e-07   res=0.149966
XXI2\<1\>\/XI2\<0\>\/XI2\<1\>\/XI2\<1\>\/XI2\<1\>\/XI2\<1\>\/XI2\<1\>\/XI2\<1\>\/RR0 \
 (  \
 N_SEL0\<1\>_XI2\<1\>\/XI2\<0\>\/XI2\<1\>\/XI2\<1\>\/XI2\<1\>\/XI2\<1\>\/XI2\<1\>\/XI2\<1\>\/RR0_pos \
 N_WLSEL\<1528\>_XI2\<1\>\/XI2\<0\>\/XI2\<1\>\/XI2\<1\>\/XI2\<1\>\/XI2\<1\>\/XI2\<1\>\/XI2\<1\>\/RR0_neg \
 ) R_1X_LL w=1e-07 l=1e-07   res=0.149966
XXI2\<1\>\/XI2\<0\>\/XI2\<1\>\/XI2\<1\>\/XI2\<1\>\/XI2\<1\>\/XI2\<1\>\/XI2\<1\>\/RR1 \
 (  \
 N_SEL1\<1\>_XI2\<1\>\/XI2\<0\>\/XI2\<1\>\/XI2\<1\>\/XI2\<1\>\/XI2\<1\>\/XI2\<1\>\/XI2\<1\>\/RR1_pos \
 N_WLSEL\<1529\>_XI2\<1\>\/XI2\<0\>\/XI2\<1\>\/XI2\<1\>\/XI2\<1\>\/XI2\<1\>\/XI2\<1\>\/XI2\<1\>\/RR1_neg \
 ) R_1X_LL w=1e-07 l=1e-07   res=0.149966
XXI2\<1\>\/XI2\<0\>\/XI2\<1\>\/XI2\<1\>\/XI2\<1\>\/XI2\<1\>\/XI2\<1\>\/XI2\<1\>\/RR2 \
 (  \
 N_SEL2\<1\>_XI2\<1\>\/XI2\<0\>\/XI2\<1\>\/XI2\<1\>\/XI2\<1\>\/XI2\<1\>\/XI2\<1\>\/XI2\<1\>\/RR2_pos \
 N_WLSEL\<1530\>_XI2\<1\>\/XI2\<0\>\/XI2\<1\>\/XI2\<1\>\/XI2\<1\>\/XI2\<1\>\/XI2\<1\>\/XI2\<1\>\/RR2_neg \
 ) R_1X_LL w=1e-07 l=1e-07   res=0.149966
XXI2\<1\>\/XI2\<0\>\/XI2\<1\>\/XI2\<1\>\/XI2\<1\>\/XI2\<1\>\/XI2\<1\>\/XI2\<1\>\/RR3 \
 (  \
 N_SEL3\<1\>_XI2\<1\>\/XI2\<0\>\/XI2\<1\>\/XI2\<1\>\/XI2\<1\>\/XI2\<1\>\/XI2\<1\>\/XI2\<1\>\/RR3_pos \
 N_WLSEL\<1531\>_XI2\<1\>\/XI2\<0\>\/XI2\<1\>\/XI2\<1\>\/XI2\<1\>\/XI2\<1\>\/XI2\<1\>\/XI2\<1\>\/RR3_neg \
 ) R_1X_LL w=1e-07 l=1e-07   res=0.149966
XXI2\<1\>\/XI2\<0\>\/XI2\<1\>\/XI2\<1\>\/XI2\<1\>\/XI2\<1\>\/XI2\<1\>\/XI2\<1\>\/RR4 \
 (  \
 N_SEL4\<1\>_XI2\<1\>\/XI2\<0\>\/XI2\<1\>\/XI2\<1\>\/XI2\<1\>\/XI2\<1\>\/XI2\<1\>\/XI2\<1\>\/RR4_pos \
 N_WLSEL\<1532\>_XI2\<1\>\/XI2\<0\>\/XI2\<1\>\/XI2\<1\>\/XI2\<1\>\/XI2\<1\>\/XI2\<1\>\/XI2\<1\>\/RR4_neg \
 ) R_1X_LL w=1e-07 l=1e-07   res=0.149966
XXI2\<1\>\/XI2\<0\>\/XI2\<1\>\/XI2\<1\>\/XI2\<1\>\/XI2\<1\>\/XI2\<1\>\/XI2\<1\>\/RR7 \
 (  \
 N_SEL5\<1\>_XI2\<1\>\/XI2\<0\>\/XI2\<1\>\/XI2\<1\>\/XI2\<1\>\/XI2\<1\>\/XI2\<1\>\/XI2\<1\>\/RR7_pos \
 N_WLSEL\<1533\>_XI2\<1\>\/XI2\<0\>\/XI2\<1\>\/XI2\<1\>\/XI2\<1\>\/XI2\<1\>\/XI2\<1\>\/XI2\<1\>\/RR7_neg \
 ) R_1X_LL w=1e-07 l=1e-07   res=0.149966
XXI2\<1\>\/XI2\<0\>\/XI2\<1\>\/XI2\<1\>\/XI2\<1\>\/XI2\<1\>\/XI2\<1\>\/XI2\<1\>\/RR6 \
 (  \
 N_SEL6\<0\>_XI2\<1\>\/XI2\<0\>\/XI2\<1\>\/XI2\<1\>\/XI2\<1\>\/XI2\<1\>\/XI2\<1\>\/XI2\<1\>\/RR6_pos \
 N_WLSEL\<1534\>_XI2\<1\>\/XI2\<0\>\/XI2\<1\>\/XI2\<1\>\/XI2\<1\>\/XI2\<1\>\/XI2\<1\>\/XI2\<1\>\/RR6_neg \
 ) R_1X_LL w=1e-07 l=1e-07   res=0.149966
XXI2\<1\>\/XI2\<0\>\/XI2\<1\>\/XI2\<1\>\/XI2\<1\>\/XI2\<1\>\/XI2\<1\>\/XI2\<1\>\/RR5 \
 (  \
 N_SEL7\<1\>_XI2\<1\>\/XI2\<0\>\/XI2\<1\>\/XI2\<1\>\/XI2\<1\>\/XI2\<1\>\/XI2\<1\>\/XI2\<1\>\/RR5_pos \
 N_WLSEL\<1535\>_XI2\<1\>\/XI2\<0\>\/XI2\<1\>\/XI2\<1\>\/XI2\<1\>\/XI2\<1\>\/XI2\<1\>\/XI2\<1\>\/RR5_neg \
 ) R_1X_LL w=1e-07 l=1e-07   res=0.149966
XXI2\<0\>\/XI2\<1\>\/XI2\<1\>\/XI2\<1\>\/XI2\<0\>\/XI2\<1\>\/XI2\<1\>\/XI2\<0\>\/RR0 \
 (  \
 N_SEL0\<0\>_XI2\<0\>\/XI2\<1\>\/XI2\<1\>\/XI2\<1\>\/XI2\<0\>\/XI2\<1\>\/XI2\<1\>\/XI2\<0\>\/RR0_pos \
 N_WLSEL\<944\>_XI2\<0\>\/XI2\<1\>\/XI2\<1\>\/XI2\<1\>\/XI2\<0\>\/XI2\<1\>\/XI2\<1\>\/XI2\<0\>\/RR0_neg \
 ) R_1X_LL w=1e-07 l=1e-07   res=0.149966
XXI2\<0\>\/XI2\<1\>\/XI2\<1\>\/XI2\<1\>\/XI2\<0\>\/XI2\<1\>\/XI2\<1\>\/XI2\<0\>\/RR1 \
 (  \
 N_SEL1\<1\>_XI2\<0\>\/XI2\<1\>\/XI2\<1\>\/XI2\<1\>\/XI2\<0\>\/XI2\<1\>\/XI2\<1\>\/XI2\<0\>\/RR1_pos \
 N_WLSEL\<945\>_XI2\<0\>\/XI2\<1\>\/XI2\<1\>\/XI2\<1\>\/XI2\<0\>\/XI2\<1\>\/XI2\<1\>\/XI2\<0\>\/RR1_neg \
 ) R_1X_LL w=1e-07 l=1e-07   res=0.149966
XXI2\<0\>\/XI2\<1\>\/XI2\<1\>\/XI2\<1\>\/XI2\<0\>\/XI2\<1\>\/XI2\<1\>\/XI2\<0\>\/RR2 \
 (  \
 N_SEL2\<1\>_XI2\<0\>\/XI2\<1\>\/XI2\<1\>\/XI2\<1\>\/XI2\<0\>\/XI2\<1\>\/XI2\<1\>\/XI2\<0\>\/RR2_pos \
 N_WLSEL\<946\>_XI2\<0\>\/XI2\<1\>\/XI2\<1\>\/XI2\<1\>\/XI2\<0\>\/XI2\<1\>\/XI2\<1\>\/XI2\<0\>\/RR2_neg \
 ) R_1X_LL w=1e-07 l=1e-07   res=0.149966
XXI2\<0\>\/XI2\<1\>\/XI2\<1\>\/XI2\<1\>\/XI2\<0\>\/XI2\<1\>\/XI2\<1\>\/XI2\<0\>\/RR3 \
 (  \
 N_SEL3\<0\>_XI2\<0\>\/XI2\<1\>\/XI2\<1\>\/XI2\<1\>\/XI2\<0\>\/XI2\<1\>\/XI2\<1\>\/XI2\<0\>\/RR3_pos \
 N_WLSEL\<947\>_XI2\<0\>\/XI2\<1\>\/XI2\<1\>\/XI2\<1\>\/XI2\<0\>\/XI2\<1\>\/XI2\<1\>\/XI2\<0\>\/RR3_neg \
 ) R_1X_LL w=1e-07 l=1e-07   res=0.149966
XXI2\<0\>\/XI2\<1\>\/XI2\<1\>\/XI2\<1\>\/XI2\<0\>\/XI2\<1\>\/XI2\<1\>\/XI2\<0\>\/RR4 \
 (  \
 N_SEL4\<1\>_XI2\<0\>\/XI2\<1\>\/XI2\<1\>\/XI2\<1\>\/XI2\<0\>\/XI2\<1\>\/XI2\<1\>\/XI2\<0\>\/RR4_pos \
 N_WLSEL\<948\>_XI2\<0\>\/XI2\<1\>\/XI2\<1\>\/XI2\<1\>\/XI2\<0\>\/XI2\<1\>\/XI2\<1\>\/XI2\<0\>\/RR4_neg \
 ) R_1X_LL w=1e-07 l=1e-07   res=0.149966
XXI2\<0\>\/XI2\<1\>\/XI2\<1\>\/XI2\<1\>\/XI2\<0\>\/XI2\<1\>\/XI2\<1\>\/XI2\<0\>\/RR7 \
 (  \
 N_SEL5\<1\>_XI2\<0\>\/XI2\<1\>\/XI2\<1\>\/XI2\<1\>\/XI2\<0\>\/XI2\<1\>\/XI2\<1\>\/XI2\<0\>\/RR7_pos \
 N_WLSEL\<949\>_XI2\<0\>\/XI2\<1\>\/XI2\<1\>\/XI2\<1\>\/XI2\<0\>\/XI2\<1\>\/XI2\<1\>\/XI2\<0\>\/RR7_neg \
 ) R_1X_LL w=1e-07 l=1e-07   res=0.149966
XXI2\<0\>\/XI2\<1\>\/XI2\<1\>\/XI2\<1\>\/XI2\<0\>\/XI2\<1\>\/XI2\<1\>\/XI2\<0\>\/RR6 \
 (  \
 N_SEL6\<1\>_XI2\<0\>\/XI2\<1\>\/XI2\<1\>\/XI2\<1\>\/XI2\<0\>\/XI2\<1\>\/XI2\<1\>\/XI2\<0\>\/RR6_pos \
 N_WLSEL\<950\>_XI2\<0\>\/XI2\<1\>\/XI2\<1\>\/XI2\<1\>\/XI2\<0\>\/XI2\<1\>\/XI2\<1\>\/XI2\<0\>\/RR6_neg \
 ) R_1X_LL w=1e-07 l=1e-07   res=0.149966
XXI2\<0\>\/XI2\<1\>\/XI2\<1\>\/XI2\<1\>\/XI2\<0\>\/XI2\<1\>\/XI2\<1\>\/XI2\<0\>\/RR5 \
 (  \
 N_SEL7\<0\>_XI2\<0\>\/XI2\<1\>\/XI2\<1\>\/XI2\<1\>\/XI2\<0\>\/XI2\<1\>\/XI2\<1\>\/XI2\<0\>\/RR5_pos \
 N_WLSEL\<951\>_XI2\<0\>\/XI2\<1\>\/XI2\<1\>\/XI2\<1\>\/XI2\<0\>\/XI2\<1\>\/XI2\<1\>\/XI2\<0\>\/RR5_neg \
 ) R_1X_LL w=1e-07 l=1e-07   res=0.149966
XXI2\<0\>\/XI2\<1\>\/XI2\<1\>\/XI2\<1\>\/XI2\<0\>\/XI2\<1\>\/XI2\<1\>\/XI2\<1\>\/RR0 \
 (  \
 N_SEL0\<1\>_XI2\<0\>\/XI2\<1\>\/XI2\<1\>\/XI2\<1\>\/XI2\<0\>\/XI2\<1\>\/XI2\<1\>\/XI2\<1\>\/RR0_pos \
 N_WLSEL\<952\>_XI2\<0\>\/XI2\<1\>\/XI2\<1\>\/XI2\<1\>\/XI2\<0\>\/XI2\<1\>\/XI2\<1\>\/XI2\<1\>\/RR0_neg \
 ) R_1X_LL w=1e-07 l=1e-07   res=0.149966
XXI2\<0\>\/XI2\<1\>\/XI2\<1\>\/XI2\<1\>\/XI2\<0\>\/XI2\<1\>\/XI2\<1\>\/XI2\<1\>\/RR1 \
 (  \
 N_SEL1\<1\>_XI2\<0\>\/XI2\<1\>\/XI2\<1\>\/XI2\<1\>\/XI2\<0\>\/XI2\<1\>\/XI2\<1\>\/XI2\<1\>\/RR1_pos \
 N_WLSEL\<953\>_XI2\<0\>\/XI2\<1\>\/XI2\<1\>\/XI2\<1\>\/XI2\<0\>\/XI2\<1\>\/XI2\<1\>\/XI2\<1\>\/RR1_neg \
 ) R_1X_LL w=1e-07 l=1e-07   res=0.149966
XXI2\<0\>\/XI2\<1\>\/XI2\<1\>\/XI2\<1\>\/XI2\<0\>\/XI2\<1\>\/XI2\<1\>\/XI2\<1\>\/RR2 \
 (  \
 N_SEL2\<1\>_XI2\<0\>\/XI2\<1\>\/XI2\<1\>\/XI2\<1\>\/XI2\<0\>\/XI2\<1\>\/XI2\<1\>\/XI2\<1\>\/RR2_pos \
 N_WLSEL\<954\>_XI2\<0\>\/XI2\<1\>\/XI2\<1\>\/XI2\<1\>\/XI2\<0\>\/XI2\<1\>\/XI2\<1\>\/XI2\<1\>\/RR2_neg \
 ) R_1X_LL w=1e-07 l=1e-07   res=0.149966
XXI2\<0\>\/XI2\<1\>\/XI2\<1\>\/XI2\<1\>\/XI2\<0\>\/XI2\<1\>\/XI2\<1\>\/XI2\<1\>\/RR3 \
 (  \
 N_SEL3\<0\>_XI2\<0\>\/XI2\<1\>\/XI2\<1\>\/XI2\<1\>\/XI2\<0\>\/XI2\<1\>\/XI2\<1\>\/XI2\<1\>\/RR3_pos \
 N_WLSEL\<955\>_XI2\<0\>\/XI2\<1\>\/XI2\<1\>\/XI2\<1\>\/XI2\<0\>\/XI2\<1\>\/XI2\<1\>\/XI2\<1\>\/RR3_neg \
 ) R_1X_LL w=1e-07 l=1e-07   res=0.149966
XXI2\<0\>\/XI2\<1\>\/XI2\<1\>\/XI2\<1\>\/XI2\<0\>\/XI2\<1\>\/XI2\<1\>\/XI2\<1\>\/RR4 \
 (  \
 N_SEL4\<1\>_XI2\<0\>\/XI2\<1\>\/XI2\<1\>\/XI2\<1\>\/XI2\<0\>\/XI2\<1\>\/XI2\<1\>\/XI2\<1\>\/RR4_pos \
 N_WLSEL\<956\>_XI2\<0\>\/XI2\<1\>\/XI2\<1\>\/XI2\<1\>\/XI2\<0\>\/XI2\<1\>\/XI2\<1\>\/XI2\<1\>\/RR4_neg \
 ) R_1X_LL w=1e-07 l=1e-07   res=0.149966
XXI2\<0\>\/XI2\<1\>\/XI2\<1\>\/XI2\<1\>\/XI2\<0\>\/XI2\<1\>\/XI2\<1\>\/XI2\<1\>\/RR7 \
 (  \
 N_SEL5\<1\>_XI2\<0\>\/XI2\<1\>\/XI2\<1\>\/XI2\<1\>\/XI2\<0\>\/XI2\<1\>\/XI2\<1\>\/XI2\<1\>\/RR7_pos \
 N_WLSEL\<957\>_XI2\<0\>\/XI2\<1\>\/XI2\<1\>\/XI2\<1\>\/XI2\<0\>\/XI2\<1\>\/XI2\<1\>\/XI2\<1\>\/RR7_neg \
 ) R_1X_LL w=1e-07 l=1e-07   res=0.149966
XXI2\<0\>\/XI2\<1\>\/XI2\<1\>\/XI2\<1\>\/XI2\<0\>\/XI2\<1\>\/XI2\<1\>\/XI2\<1\>\/RR6 \
 (  \
 N_SEL6\<1\>_XI2\<0\>\/XI2\<1\>\/XI2\<1\>\/XI2\<1\>\/XI2\<0\>\/XI2\<1\>\/XI2\<1\>\/XI2\<1\>\/RR6_pos \
 N_WLSEL\<958\>_XI2\<0\>\/XI2\<1\>\/XI2\<1\>\/XI2\<1\>\/XI2\<0\>\/XI2\<1\>\/XI2\<1\>\/XI2\<1\>\/RR6_neg \
 ) R_1X_LL w=1e-07 l=1e-07   res=0.149966
XXI2\<0\>\/XI2\<1\>\/XI2\<1\>\/XI2\<1\>\/XI2\<0\>\/XI2\<1\>\/XI2\<1\>\/XI2\<1\>\/RR5 \
 (  \
 N_SEL7\<0\>_XI2\<0\>\/XI2\<1\>\/XI2\<1\>\/XI2\<1\>\/XI2\<0\>\/XI2\<1\>\/XI2\<1\>\/XI2\<1\>\/RR5_pos \
 N_WLSEL\<959\>_XI2\<0\>\/XI2\<1\>\/XI2\<1\>\/XI2\<1\>\/XI2\<0\>\/XI2\<1\>\/XI2\<1\>\/XI2\<1\>\/RR5_neg \
 ) R_1X_LL w=1e-07 l=1e-07   res=0.149966
XXI2\<0\>\/XI2\<1\>\/XI2\<1\>\/XI2\<1\>\/XI2\<1\>\/XI2\<0\>\/XI2\<0\>\/XI2\<0\>\/RR0 \
 (  \
 N_SEL0\<0\>_XI2\<0\>\/XI2\<1\>\/XI2\<1\>\/XI2\<1\>\/XI2\<1\>\/XI2\<0\>\/XI2\<0\>\/XI2\<0\>\/RR0_pos \
 N_WLSEL\<960\>_XI2\<0\>\/XI2\<1\>\/XI2\<1\>\/XI2\<1\>\/XI2\<1\>\/XI2\<0\>\/XI2\<0\>\/XI2\<0\>\/RR0_neg \
 ) R_1X_LL w=1e-07 l=1e-07   res=0.149966
XXI2\<0\>\/XI2\<1\>\/XI2\<1\>\/XI2\<1\>\/XI2\<1\>\/XI2\<0\>\/XI2\<0\>\/XI2\<0\>\/RR1 \
 (  \
 N_SEL1\<0\>_XI2\<0\>\/XI2\<1\>\/XI2\<1\>\/XI2\<1\>\/XI2\<1\>\/XI2\<0\>\/XI2\<0\>\/XI2\<0\>\/RR1_pos \
 N_WLSEL\<961\>_XI2\<0\>\/XI2\<1\>\/XI2\<1\>\/XI2\<1\>\/XI2\<1\>\/XI2\<0\>\/XI2\<0\>\/XI2\<0\>\/RR1_neg \
 ) R_1X_LL w=1e-07 l=1e-07   res=0.149966
XXI2\<0\>\/XI2\<1\>\/XI2\<1\>\/XI2\<1\>\/XI2\<1\>\/XI2\<0\>\/XI2\<0\>\/XI2\<0\>\/RR2 \
 (  \
 N_SEL2\<0\>_XI2\<0\>\/XI2\<1\>\/XI2\<1\>\/XI2\<1\>\/XI2\<1\>\/XI2\<0\>\/XI2\<0\>\/XI2\<0\>\/RR2_pos \
 N_WLSEL\<962\>_XI2\<0\>\/XI2\<1\>\/XI2\<1\>\/XI2\<1\>\/XI2\<1\>\/XI2\<0\>\/XI2\<0\>\/XI2\<0\>\/RR2_neg \
 ) R_1X_LL w=1e-07 l=1e-07   res=0.149966
XXI2\<0\>\/XI2\<1\>\/XI2\<1\>\/XI2\<1\>\/XI2\<1\>\/XI2\<0\>\/XI2\<0\>\/XI2\<0\>\/RR3 \
 (  \
 N_SEL3\<1\>_XI2\<0\>\/XI2\<1\>\/XI2\<1\>\/XI2\<1\>\/XI2\<1\>\/XI2\<0\>\/XI2\<0\>\/XI2\<0\>\/RR3_pos \
 N_WLSEL\<963\>_XI2\<0\>\/XI2\<1\>\/XI2\<1\>\/XI2\<1\>\/XI2\<1\>\/XI2\<0\>\/XI2\<0\>\/XI2\<0\>\/RR3_neg \
 ) R_1X_LL w=1e-07 l=1e-07   res=0.149966
XXI2\<0\>\/XI2\<1\>\/XI2\<1\>\/XI2\<1\>\/XI2\<1\>\/XI2\<0\>\/XI2\<0\>\/XI2\<0\>\/RR4 \
 (  \
 N_SEL4\<1\>_XI2\<0\>\/XI2\<1\>\/XI2\<1\>\/XI2\<1\>\/XI2\<1\>\/XI2\<0\>\/XI2\<0\>\/XI2\<0\>\/RR4_pos \
 N_WLSEL\<964\>_XI2\<0\>\/XI2\<1\>\/XI2\<1\>\/XI2\<1\>\/XI2\<1\>\/XI2\<0\>\/XI2\<0\>\/XI2\<0\>\/RR4_neg \
 ) R_1X_LL w=1e-07 l=1e-07   res=0.149966
XXI2\<0\>\/XI2\<1\>\/XI2\<1\>\/XI2\<1\>\/XI2\<1\>\/XI2\<0\>\/XI2\<0\>\/XI2\<0\>\/RR7 \
 (  \
 N_SEL5\<1\>_XI2\<0\>\/XI2\<1\>\/XI2\<1\>\/XI2\<1\>\/XI2\<1\>\/XI2\<0\>\/XI2\<0\>\/XI2\<0\>\/RR7_pos \
 N_WLSEL\<965\>_XI2\<0\>\/XI2\<1\>\/XI2\<1\>\/XI2\<1\>\/XI2\<1\>\/XI2\<0\>\/XI2\<0\>\/XI2\<0\>\/RR7_neg \
 ) R_1X_LL w=1e-07 l=1e-07   res=0.149966
XXI2\<0\>\/XI2\<1\>\/XI2\<1\>\/XI2\<1\>\/XI2\<1\>\/XI2\<0\>\/XI2\<0\>\/XI2\<0\>\/RR6 \
 (  \
 N_SEL6\<1\>_XI2\<0\>\/XI2\<1\>\/XI2\<1\>\/XI2\<1\>\/XI2\<1\>\/XI2\<0\>\/XI2\<0\>\/XI2\<0\>\/RR6_pos \
 N_WLSEL\<966\>_XI2\<0\>\/XI2\<1\>\/XI2\<1\>\/XI2\<1\>\/XI2\<1\>\/XI2\<0\>\/XI2\<0\>\/XI2\<0\>\/RR6_neg \
 ) R_1X_LL w=1e-07 l=1e-07   res=0.149966
XXI2\<0\>\/XI2\<1\>\/XI2\<1\>\/XI2\<1\>\/XI2\<1\>\/XI2\<0\>\/XI2\<0\>\/XI2\<0\>\/RR5 \
 (  \
 N_SEL7\<0\>_XI2\<0\>\/XI2\<1\>\/XI2\<1\>\/XI2\<1\>\/XI2\<1\>\/XI2\<0\>\/XI2\<0\>\/XI2\<0\>\/RR5_pos \
 N_WLSEL\<967\>_XI2\<0\>\/XI2\<1\>\/XI2\<1\>\/XI2\<1\>\/XI2\<1\>\/XI2\<0\>\/XI2\<0\>\/XI2\<0\>\/RR5_neg \
 ) R_1X_LL w=1e-07 l=1e-07   res=0.149966
XXI2\<0\>\/XI2\<1\>\/XI2\<1\>\/XI2\<1\>\/XI2\<1\>\/XI2\<0\>\/XI2\<0\>\/XI2\<1\>\/RR0 \
 (  \
 N_SEL0\<1\>_XI2\<0\>\/XI2\<1\>\/XI2\<1\>\/XI2\<1\>\/XI2\<1\>\/XI2\<0\>\/XI2\<0\>\/XI2\<1\>\/RR0_pos \
 N_WLSEL\<968\>_XI2\<0\>\/XI2\<1\>\/XI2\<1\>\/XI2\<1\>\/XI2\<1\>\/XI2\<0\>\/XI2\<0\>\/XI2\<1\>\/RR0_neg \
 ) R_1X_LL w=1e-07 l=1e-07   res=0.149966
XXI2\<0\>\/XI2\<1\>\/XI2\<1\>\/XI2\<1\>\/XI2\<1\>\/XI2\<0\>\/XI2\<0\>\/XI2\<1\>\/RR1 \
 (  \
 N_SEL1\<0\>_XI2\<0\>\/XI2\<1\>\/XI2\<1\>\/XI2\<1\>\/XI2\<1\>\/XI2\<0\>\/XI2\<0\>\/XI2\<1\>\/RR1_pos \
 N_WLSEL\<969\>_XI2\<0\>\/XI2\<1\>\/XI2\<1\>\/XI2\<1\>\/XI2\<1\>\/XI2\<0\>\/XI2\<0\>\/XI2\<1\>\/RR1_neg \
 ) R_1X_LL w=1e-07 l=1e-07   res=0.149966
XXI2\<0\>\/XI2\<1\>\/XI2\<1\>\/XI2\<1\>\/XI2\<1\>\/XI2\<0\>\/XI2\<0\>\/XI2\<1\>\/RR2 \
 (  \
 N_SEL2\<0\>_XI2\<0\>\/XI2\<1\>\/XI2\<1\>\/XI2\<1\>\/XI2\<1\>\/XI2\<0\>\/XI2\<0\>\/XI2\<1\>\/RR2_pos \
 N_WLSEL\<970\>_XI2\<0\>\/XI2\<1\>\/XI2\<1\>\/XI2\<1\>\/XI2\<1\>\/XI2\<0\>\/XI2\<0\>\/XI2\<1\>\/RR2_neg \
 ) R_1X_LL w=1e-07 l=1e-07   res=0.149966
XXI2\<0\>\/XI2\<1\>\/XI2\<1\>\/XI2\<1\>\/XI2\<1\>\/XI2\<0\>\/XI2\<0\>\/XI2\<1\>\/RR3 \
 (  \
 N_SEL3\<1\>_XI2\<0\>\/XI2\<1\>\/XI2\<1\>\/XI2\<1\>\/XI2\<1\>\/XI2\<0\>\/XI2\<0\>\/XI2\<1\>\/RR3_pos \
 N_WLSEL\<971\>_XI2\<0\>\/XI2\<1\>\/XI2\<1\>\/XI2\<1\>\/XI2\<1\>\/XI2\<0\>\/XI2\<0\>\/XI2\<1\>\/RR3_neg \
 ) R_1X_LL w=1e-07 l=1e-07   res=0.149966
XXI2\<0\>\/XI2\<1\>\/XI2\<1\>\/XI2\<1\>\/XI2\<1\>\/XI2\<0\>\/XI2\<0\>\/XI2\<1\>\/RR4 \
 (  \
 N_SEL4\<1\>_XI2\<0\>\/XI2\<1\>\/XI2\<1\>\/XI2\<1\>\/XI2\<1\>\/XI2\<0\>\/XI2\<0\>\/XI2\<1\>\/RR4_pos \
 N_WLSEL\<972\>_XI2\<0\>\/XI2\<1\>\/XI2\<1\>\/XI2\<1\>\/XI2\<1\>\/XI2\<0\>\/XI2\<0\>\/XI2\<1\>\/RR4_neg \
 ) R_1X_LL w=1e-07 l=1e-07   res=0.149966
XXI2\<0\>\/XI2\<1\>\/XI2\<1\>\/XI2\<1\>\/XI2\<1\>\/XI2\<0\>\/XI2\<0\>\/XI2\<1\>\/RR7 \
 (  \
 N_SEL5\<1\>_XI2\<0\>\/XI2\<1\>\/XI2\<1\>\/XI2\<1\>\/XI2\<1\>\/XI2\<0\>\/XI2\<0\>\/XI2\<1\>\/RR7_pos \
 N_WLSEL\<973\>_XI2\<0\>\/XI2\<1\>\/XI2\<1\>\/XI2\<1\>\/XI2\<1\>\/XI2\<0\>\/XI2\<0\>\/XI2\<1\>\/RR7_neg \
 ) R_1X_LL w=1e-07 l=1e-07   res=0.149966
XXI2\<0\>\/XI2\<1\>\/XI2\<1\>\/XI2\<1\>\/XI2\<1\>\/XI2\<0\>\/XI2\<0\>\/XI2\<1\>\/RR6 \
 (  \
 N_SEL6\<1\>_XI2\<0\>\/XI2\<1\>\/XI2\<1\>\/XI2\<1\>\/XI2\<1\>\/XI2\<0\>\/XI2\<0\>\/XI2\<1\>\/RR6_pos \
 N_WLSEL\<974\>_XI2\<0\>\/XI2\<1\>\/XI2\<1\>\/XI2\<1\>\/XI2\<1\>\/XI2\<0\>\/XI2\<0\>\/XI2\<1\>\/RR6_neg \
 ) R_1X_LL w=1e-07 l=1e-07   res=0.149966
XXI2\<0\>\/XI2\<1\>\/XI2\<1\>\/XI2\<1\>\/XI2\<1\>\/XI2\<0\>\/XI2\<0\>\/XI2\<1\>\/RR5 \
 (  \
 N_SEL7\<0\>_XI2\<0\>\/XI2\<1\>\/XI2\<1\>\/XI2\<1\>\/XI2\<1\>\/XI2\<0\>\/XI2\<0\>\/XI2\<1\>\/RR5_pos \
 N_WLSEL\<975\>_XI2\<0\>\/XI2\<1\>\/XI2\<1\>\/XI2\<1\>\/XI2\<1\>\/XI2\<0\>\/XI2\<0\>\/XI2\<1\>\/RR5_neg \
 ) R_1X_LL w=1e-07 l=1e-07   res=0.149966
XXI2\<0\>\/XI2\<1\>\/XI2\<1\>\/XI2\<1\>\/XI2\<1\>\/XI2\<0\>\/XI2\<1\>\/XI2\<0\>\/RR0 \
 (  \
 N_SEL0\<0\>_XI2\<0\>\/XI2\<1\>\/XI2\<1\>\/XI2\<1\>\/XI2\<1\>\/XI2\<0\>\/XI2\<1\>\/XI2\<0\>\/RR0_pos \
 N_WLSEL\<976\>_XI2\<0\>\/XI2\<1\>\/XI2\<1\>\/XI2\<1\>\/XI2\<1\>\/XI2\<0\>\/XI2\<1\>\/XI2\<0\>\/RR0_neg \
 ) R_1X_LL w=1e-07 l=1e-07   res=0.149966
XXI2\<0\>\/XI2\<1\>\/XI2\<1\>\/XI2\<1\>\/XI2\<1\>\/XI2\<0\>\/XI2\<1\>\/XI2\<0\>\/RR1 \
 (  \
 N_SEL1\<1\>_XI2\<0\>\/XI2\<1\>\/XI2\<1\>\/XI2\<1\>\/XI2\<1\>\/XI2\<0\>\/XI2\<1\>\/XI2\<0\>\/RR1_pos \
 N_WLSEL\<977\>_XI2\<0\>\/XI2\<1\>\/XI2\<1\>\/XI2\<1\>\/XI2\<1\>\/XI2\<0\>\/XI2\<1\>\/XI2\<0\>\/RR1_neg \
 ) R_1X_LL w=1e-07 l=1e-07   res=0.149966
XXI2\<0\>\/XI2\<1\>\/XI2\<1\>\/XI2\<1\>\/XI2\<1\>\/XI2\<0\>\/XI2\<1\>\/XI2\<0\>\/RR2 \
 (  \
 N_SEL2\<0\>_XI2\<0\>\/XI2\<1\>\/XI2\<1\>\/XI2\<1\>\/XI2\<1\>\/XI2\<0\>\/XI2\<1\>\/XI2\<0\>\/RR2_pos \
 N_WLSEL\<978\>_XI2\<0\>\/XI2\<1\>\/XI2\<1\>\/XI2\<1\>\/XI2\<1\>\/XI2\<0\>\/XI2\<1\>\/XI2\<0\>\/RR2_neg \
 ) R_1X_LL w=1e-07 l=1e-07   res=0.149966
XXI2\<0\>\/XI2\<1\>\/XI2\<1\>\/XI2\<1\>\/XI2\<1\>\/XI2\<0\>\/XI2\<1\>\/XI2\<0\>\/RR3 \
 (  \
 N_SEL3\<1\>_XI2\<0\>\/XI2\<1\>\/XI2\<1\>\/XI2\<1\>\/XI2\<1\>\/XI2\<0\>\/XI2\<1\>\/XI2\<0\>\/RR3_pos \
 N_WLSEL\<979\>_XI2\<0\>\/XI2\<1\>\/XI2\<1\>\/XI2\<1\>\/XI2\<1\>\/XI2\<0\>\/XI2\<1\>\/XI2\<0\>\/RR3_neg \
 ) R_1X_LL w=1e-07 l=1e-07   res=0.149966
XXI2\<0\>\/XI2\<1\>\/XI2\<1\>\/XI2\<1\>\/XI2\<1\>\/XI2\<0\>\/XI2\<1\>\/XI2\<0\>\/RR4 \
 (  \
 N_SEL4\<1\>_XI2\<0\>\/XI2\<1\>\/XI2\<1\>\/XI2\<1\>\/XI2\<1\>\/XI2\<0\>\/XI2\<1\>\/XI2\<0\>\/RR4_pos \
 N_WLSEL\<980\>_XI2\<0\>\/XI2\<1\>\/XI2\<1\>\/XI2\<1\>\/XI2\<1\>\/XI2\<0\>\/XI2\<1\>\/XI2\<0\>\/RR4_neg \
 ) R_1X_LL w=1e-07 l=1e-07   res=0.149966
XXI2\<0\>\/XI2\<1\>\/XI2\<1\>\/XI2\<1\>\/XI2\<1\>\/XI2\<0\>\/XI2\<1\>\/XI2\<0\>\/RR7 \
 (  \
 N_SEL5\<1\>_XI2\<0\>\/XI2\<1\>\/XI2\<1\>\/XI2\<1\>\/XI2\<1\>\/XI2\<0\>\/XI2\<1\>\/XI2\<0\>\/RR7_pos \
 N_WLSEL\<981\>_XI2\<0\>\/XI2\<1\>\/XI2\<1\>\/XI2\<1\>\/XI2\<1\>\/XI2\<0\>\/XI2\<1\>\/XI2\<0\>\/RR7_neg \
 ) R_1X_LL w=1e-07 l=1e-07   res=0.149966
XXI2\<0\>\/XI2\<1\>\/XI2\<1\>\/XI2\<1\>\/XI2\<1\>\/XI2\<0\>\/XI2\<1\>\/XI2\<0\>\/RR6 \
 (  \
 N_SEL6\<1\>_XI2\<0\>\/XI2\<1\>\/XI2\<1\>\/XI2\<1\>\/XI2\<1\>\/XI2\<0\>\/XI2\<1\>\/XI2\<0\>\/RR6_pos \
 N_WLSEL\<982\>_XI2\<0\>\/XI2\<1\>\/XI2\<1\>\/XI2\<1\>\/XI2\<1\>\/XI2\<0\>\/XI2\<1\>\/XI2\<0\>\/RR6_neg \
 ) R_1X_LL w=1e-07 l=1e-07   res=0.149966
XXI2\<0\>\/XI2\<1\>\/XI2\<1\>\/XI2\<1\>\/XI2\<1\>\/XI2\<0\>\/XI2\<1\>\/XI2\<0\>\/RR5 \
 (  \
 N_SEL7\<0\>_XI2\<0\>\/XI2\<1\>\/XI2\<1\>\/XI2\<1\>\/XI2\<1\>\/XI2\<0\>\/XI2\<1\>\/XI2\<0\>\/RR5_pos \
 N_WLSEL\<983\>_XI2\<0\>\/XI2\<1\>\/XI2\<1\>\/XI2\<1\>\/XI2\<1\>\/XI2\<0\>\/XI2\<1\>\/XI2\<0\>\/RR5_neg \
 ) R_1X_LL w=1e-07 l=1e-07   res=0.149966
XXI2\<0\>\/XI2\<1\>\/XI2\<1\>\/XI2\<1\>\/XI2\<1\>\/XI2\<0\>\/XI2\<1\>\/XI2\<1\>\/RR0 \
 (  \
 N_SEL0\<1\>_XI2\<0\>\/XI2\<1\>\/XI2\<1\>\/XI2\<1\>\/XI2\<1\>\/XI2\<0\>\/XI2\<1\>\/XI2\<1\>\/RR0_pos \
 N_WLSEL\<984\>_XI2\<0\>\/XI2\<1\>\/XI2\<1\>\/XI2\<1\>\/XI2\<1\>\/XI2\<0\>\/XI2\<1\>\/XI2\<1\>\/RR0_neg \
 ) R_1X_LL w=1e-07 l=1e-07   res=0.149966
XXI2\<0\>\/XI2\<1\>\/XI2\<1\>\/XI2\<1\>\/XI2\<1\>\/XI2\<0\>\/XI2\<1\>\/XI2\<1\>\/RR1 \
 (  \
 N_SEL1\<1\>_XI2\<0\>\/XI2\<1\>\/XI2\<1\>\/XI2\<1\>\/XI2\<1\>\/XI2\<0\>\/XI2\<1\>\/XI2\<1\>\/RR1_pos \
 N_WLSEL\<985\>_XI2\<0\>\/XI2\<1\>\/XI2\<1\>\/XI2\<1\>\/XI2\<1\>\/XI2\<0\>\/XI2\<1\>\/XI2\<1\>\/RR1_neg \
 ) R_1X_LL w=1e-07 l=1e-07   res=0.149966
XXI2\<0\>\/XI2\<1\>\/XI2\<1\>\/XI2\<1\>\/XI2\<1\>\/XI2\<0\>\/XI2\<1\>\/XI2\<1\>\/RR2 \
 (  \
 N_SEL2\<0\>_XI2\<0\>\/XI2\<1\>\/XI2\<1\>\/XI2\<1\>\/XI2\<1\>\/XI2\<0\>\/XI2\<1\>\/XI2\<1\>\/RR2_pos \
 N_WLSEL\<986\>_XI2\<0\>\/XI2\<1\>\/XI2\<1\>\/XI2\<1\>\/XI2\<1\>\/XI2\<0\>\/XI2\<1\>\/XI2\<1\>\/RR2_neg \
 ) R_1X_LL w=1e-07 l=1e-07   res=0.149966
XXI2\<0\>\/XI2\<1\>\/XI2\<1\>\/XI2\<1\>\/XI2\<1\>\/XI2\<0\>\/XI2\<1\>\/XI2\<1\>\/RR3 \
 (  \
 N_SEL3\<1\>_XI2\<0\>\/XI2\<1\>\/XI2\<1\>\/XI2\<1\>\/XI2\<1\>\/XI2\<0\>\/XI2\<1\>\/XI2\<1\>\/RR3_pos \
 N_WLSEL\<987\>_XI2\<0\>\/XI2\<1\>\/XI2\<1\>\/XI2\<1\>\/XI2\<1\>\/XI2\<0\>\/XI2\<1\>\/XI2\<1\>\/RR3_neg \
 ) R_1X_LL w=1e-07 l=1e-07   res=0.149966
XXI2\<0\>\/XI2\<1\>\/XI2\<1\>\/XI2\<1\>\/XI2\<1\>\/XI2\<0\>\/XI2\<1\>\/XI2\<1\>\/RR4 \
 (  \
 N_SEL4\<1\>_XI2\<0\>\/XI2\<1\>\/XI2\<1\>\/XI2\<1\>\/XI2\<1\>\/XI2\<0\>\/XI2\<1\>\/XI2\<1\>\/RR4_pos \
 N_WLSEL\<988\>_XI2\<0\>\/XI2\<1\>\/XI2\<1\>\/XI2\<1\>\/XI2\<1\>\/XI2\<0\>\/XI2\<1\>\/XI2\<1\>\/RR4_neg \
 ) R_1X_LL w=1e-07 l=1e-07   res=0.149966
XXI2\<0\>\/XI2\<1\>\/XI2\<1\>\/XI2\<1\>\/XI2\<1\>\/XI2\<0\>\/XI2\<1\>\/XI2\<1\>\/RR7 \
 (  \
 N_SEL5\<1\>_XI2\<0\>\/XI2\<1\>\/XI2\<1\>\/XI2\<1\>\/XI2\<1\>\/XI2\<0\>\/XI2\<1\>\/XI2\<1\>\/RR7_pos \
 N_WLSEL\<989\>_XI2\<0\>\/XI2\<1\>\/XI2\<1\>\/XI2\<1\>\/XI2\<1\>\/XI2\<0\>\/XI2\<1\>\/XI2\<1\>\/RR7_neg \
 ) R_1X_LL w=1e-07 l=1e-07   res=0.149966
XXI2\<0\>\/XI2\<1\>\/XI2\<1\>\/XI2\<1\>\/XI2\<1\>\/XI2\<0\>\/XI2\<1\>\/XI2\<1\>\/RR6 \
 (  \
 N_SEL6\<1\>_XI2\<0\>\/XI2\<1\>\/XI2\<1\>\/XI2\<1\>\/XI2\<1\>\/XI2\<0\>\/XI2\<1\>\/XI2\<1\>\/RR6_pos \
 N_WLSEL\<990\>_XI2\<0\>\/XI2\<1\>\/XI2\<1\>\/XI2\<1\>\/XI2\<1\>\/XI2\<0\>\/XI2\<1\>\/XI2\<1\>\/RR6_neg \
 ) R_1X_LL w=1e-07 l=1e-07   res=0.149966
XXI2\<0\>\/XI2\<1\>\/XI2\<1\>\/XI2\<1\>\/XI2\<1\>\/XI2\<0\>\/XI2\<1\>\/XI2\<1\>\/RR5 \
 (  \
 N_SEL7\<0\>_XI2\<0\>\/XI2\<1\>\/XI2\<1\>\/XI2\<1\>\/XI2\<1\>\/XI2\<0\>\/XI2\<1\>\/XI2\<1\>\/RR5_pos \
 N_WLSEL\<991\>_XI2\<0\>\/XI2\<1\>\/XI2\<1\>\/XI2\<1\>\/XI2\<1\>\/XI2\<0\>\/XI2\<1\>\/XI2\<1\>\/RR5_neg \
 ) R_1X_LL w=1e-07 l=1e-07   res=0.149966
XXI2\<0\>\/XI2\<1\>\/XI2\<1\>\/XI2\<1\>\/XI2\<1\>\/XI2\<1\>\/XI2\<0\>\/XI2\<0\>\/RR0 \
 (  \
 N_SEL0\<0\>_XI2\<0\>\/XI2\<1\>\/XI2\<1\>\/XI2\<1\>\/XI2\<1\>\/XI2\<1\>\/XI2\<0\>\/XI2\<0\>\/RR0_pos \
 N_WLSEL\<992\>_XI2\<0\>\/XI2\<1\>\/XI2\<1\>\/XI2\<1\>\/XI2\<1\>\/XI2\<1\>\/XI2\<0\>\/XI2\<0\>\/RR0_neg \
 ) R_1X_LL w=1e-07 l=1e-07   res=0.149966
XXI2\<0\>\/XI2\<1\>\/XI2\<1\>\/XI2\<1\>\/XI2\<1\>\/XI2\<1\>\/XI2\<0\>\/XI2\<0\>\/RR1 \
 (  \
 N_SEL1\<0\>_XI2\<0\>\/XI2\<1\>\/XI2\<1\>\/XI2\<1\>\/XI2\<1\>\/XI2\<1\>\/XI2\<0\>\/XI2\<0\>\/RR1_pos \
 N_WLSEL\<993\>_XI2\<0\>\/XI2\<1\>\/XI2\<1\>\/XI2\<1\>\/XI2\<1\>\/XI2\<1\>\/XI2\<0\>\/XI2\<0\>\/RR1_neg \
 ) R_1X_LL w=1e-07 l=1e-07   res=0.149966
XXI2\<0\>\/XI2\<1\>\/XI2\<1\>\/XI2\<1\>\/XI2\<1\>\/XI2\<1\>\/XI2\<0\>\/XI2\<0\>\/RR2 \
 (  \
 N_SEL2\<1\>_XI2\<0\>\/XI2\<1\>\/XI2\<1\>\/XI2\<1\>\/XI2\<1\>\/XI2\<1\>\/XI2\<0\>\/XI2\<0\>\/RR2_pos \
 N_WLSEL\<994\>_XI2\<0\>\/XI2\<1\>\/XI2\<1\>\/XI2\<1\>\/XI2\<1\>\/XI2\<1\>\/XI2\<0\>\/XI2\<0\>\/RR2_neg \
 ) R_1X_LL w=1e-07 l=1e-07   res=0.149966
XXI2\<0\>\/XI2\<1\>\/XI2\<1\>\/XI2\<1\>\/XI2\<1\>\/XI2\<1\>\/XI2\<0\>\/XI2\<0\>\/RR3 \
 (  \
 N_SEL3\<1\>_XI2\<0\>\/XI2\<1\>\/XI2\<1\>\/XI2\<1\>\/XI2\<1\>\/XI2\<1\>\/XI2\<0\>\/XI2\<0\>\/RR3_pos \
 N_WLSEL\<995\>_XI2\<0\>\/XI2\<1\>\/XI2\<1\>\/XI2\<1\>\/XI2\<1\>\/XI2\<1\>\/XI2\<0\>\/XI2\<0\>\/RR3_neg \
 ) R_1X_LL w=1e-07 l=1e-07   res=0.149966
XXI2\<0\>\/XI2\<1\>\/XI2\<1\>\/XI2\<1\>\/XI2\<1\>\/XI2\<1\>\/XI2\<0\>\/XI2\<0\>\/RR4 \
 (  \
 N_SEL4\<1\>_XI2\<0\>\/XI2\<1\>\/XI2\<1\>\/XI2\<1\>\/XI2\<1\>\/XI2\<1\>\/XI2\<0\>\/XI2\<0\>\/RR4_pos \
 N_WLSEL\<996\>_XI2\<0\>\/XI2\<1\>\/XI2\<1\>\/XI2\<1\>\/XI2\<1\>\/XI2\<1\>\/XI2\<0\>\/XI2\<0\>\/RR4_neg \
 ) R_1X_LL w=1e-07 l=1e-07   res=0.149966
XXI2\<0\>\/XI2\<1\>\/XI2\<1\>\/XI2\<1\>\/XI2\<1\>\/XI2\<1\>\/XI2\<0\>\/XI2\<0\>\/RR7 \
 (  \
 N_SEL5\<1\>_XI2\<0\>\/XI2\<1\>\/XI2\<1\>\/XI2\<1\>\/XI2\<1\>\/XI2\<1\>\/XI2\<0\>\/XI2\<0\>\/RR7_pos \
 N_WLSEL\<997\>_XI2\<0\>\/XI2\<1\>\/XI2\<1\>\/XI2\<1\>\/XI2\<1\>\/XI2\<1\>\/XI2\<0\>\/XI2\<0\>\/RR7_neg \
 ) R_1X_LL w=1e-07 l=1e-07   res=0.149966
XXI2\<0\>\/XI2\<1\>\/XI2\<1\>\/XI2\<1\>\/XI2\<1\>\/XI2\<1\>\/XI2\<0\>\/XI2\<0\>\/RR6 \
 (  \
 N_SEL6\<1\>_XI2\<0\>\/XI2\<1\>\/XI2\<1\>\/XI2\<1\>\/XI2\<1\>\/XI2\<1\>\/XI2\<0\>\/XI2\<0\>\/RR6_pos \
 N_WLSEL\<998\>_XI2\<0\>\/XI2\<1\>\/XI2\<1\>\/XI2\<1\>\/XI2\<1\>\/XI2\<1\>\/XI2\<0\>\/XI2\<0\>\/RR6_neg \
 ) R_1X_LL w=1e-07 l=1e-07   res=0.149966
XXI2\<0\>\/XI2\<1\>\/XI2\<1\>\/XI2\<1\>\/XI2\<1\>\/XI2\<1\>\/XI2\<0\>\/XI2\<0\>\/RR5 \
 (  \
 N_SEL7\<0\>_XI2\<0\>\/XI2\<1\>\/XI2\<1\>\/XI2\<1\>\/XI2\<1\>\/XI2\<1\>\/XI2\<0\>\/XI2\<0\>\/RR5_pos \
 N_WLSEL\<999\>_XI2\<0\>\/XI2\<1\>\/XI2\<1\>\/XI2\<1\>\/XI2\<1\>\/XI2\<1\>\/XI2\<0\>\/XI2\<0\>\/RR5_neg \
 ) R_1X_LL w=1e-07 l=1e-07   res=0.149966
XXI2\<0\>\/XI2\<1\>\/XI2\<1\>\/XI2\<1\>\/XI2\<1\>\/XI2\<1\>\/XI2\<0\>\/XI2\<1\>\/RR0 \
 (  \
 N_SEL0\<1\>_XI2\<0\>\/XI2\<1\>\/XI2\<1\>\/XI2\<1\>\/XI2\<1\>\/XI2\<1\>\/XI2\<0\>\/XI2\<1\>\/RR0_pos \
 N_WLSEL\<1000\>_XI2\<0\>\/XI2\<1\>\/XI2\<1\>\/XI2\<1\>\/XI2\<1\>\/XI2\<1\>\/XI2\<0\>\/XI2\<1\>\/RR0_neg \
 ) R_1X_LL w=1e-07 l=1e-07   res=0.149966
XXI2\<0\>\/XI2\<1\>\/XI2\<1\>\/XI2\<1\>\/XI2\<1\>\/XI2\<1\>\/XI2\<0\>\/XI2\<1\>\/RR1 \
 (  \
 N_SEL1\<0\>_XI2\<0\>\/XI2\<1\>\/XI2\<1\>\/XI2\<1\>\/XI2\<1\>\/XI2\<1\>\/XI2\<0\>\/XI2\<1\>\/RR1_pos \
 N_WLSEL\<1001\>_XI2\<0\>\/XI2\<1\>\/XI2\<1\>\/XI2\<1\>\/XI2\<1\>\/XI2\<1\>\/XI2\<0\>\/XI2\<1\>\/RR1_neg \
 ) R_1X_LL w=1e-07 l=1e-07   res=0.149966
XXI2\<0\>\/XI2\<1\>\/XI2\<1\>\/XI2\<1\>\/XI2\<1\>\/XI2\<1\>\/XI2\<0\>\/XI2\<1\>\/RR2 \
 (  \
 N_SEL2\<1\>_XI2\<0\>\/XI2\<1\>\/XI2\<1\>\/XI2\<1\>\/XI2\<1\>\/XI2\<1\>\/XI2\<0\>\/XI2\<1\>\/RR2_pos \
 N_WLSEL\<1002\>_XI2\<0\>\/XI2\<1\>\/XI2\<1\>\/XI2\<1\>\/XI2\<1\>\/XI2\<1\>\/XI2\<0\>\/XI2\<1\>\/RR2_neg \
 ) R_1X_LL w=1e-07 l=1e-07   res=0.149966
XXI2\<0\>\/XI2\<1\>\/XI2\<1\>\/XI2\<1\>\/XI2\<1\>\/XI2\<1\>\/XI2\<0\>\/XI2\<1\>\/RR3 \
 (  \
 N_SEL3\<1\>_XI2\<0\>\/XI2\<1\>\/XI2\<1\>\/XI2\<1\>\/XI2\<1\>\/XI2\<1\>\/XI2\<0\>\/XI2\<1\>\/RR3_pos \
 N_WLSEL\<1003\>_XI2\<0\>\/XI2\<1\>\/XI2\<1\>\/XI2\<1\>\/XI2\<1\>\/XI2\<1\>\/XI2\<0\>\/XI2\<1\>\/RR3_neg \
 ) R_1X_LL w=1e-07 l=1e-07   res=0.149966
XXI2\<0\>\/XI2\<1\>\/XI2\<1\>\/XI2\<1\>\/XI2\<1\>\/XI2\<1\>\/XI2\<0\>\/XI2\<1\>\/RR4 \
 (  \
 N_SEL4\<1\>_XI2\<0\>\/XI2\<1\>\/XI2\<1\>\/XI2\<1\>\/XI2\<1\>\/XI2\<1\>\/XI2\<0\>\/XI2\<1\>\/RR4_pos \
 N_WLSEL\<1004\>_XI2\<0\>\/XI2\<1\>\/XI2\<1\>\/XI2\<1\>\/XI2\<1\>\/XI2\<1\>\/XI2\<0\>\/XI2\<1\>\/RR4_neg \
 ) R_1X_LL w=1e-07 l=1e-07   res=0.149966
XXI2\<0\>\/XI2\<1\>\/XI2\<1\>\/XI2\<1\>\/XI2\<1\>\/XI2\<1\>\/XI2\<0\>\/XI2\<1\>\/RR7 \
 (  \
 N_SEL5\<1\>_XI2\<0\>\/XI2\<1\>\/XI2\<1\>\/XI2\<1\>\/XI2\<1\>\/XI2\<1\>\/XI2\<0\>\/XI2\<1\>\/RR7_pos \
 N_WLSEL\<1005\>_XI2\<0\>\/XI2\<1\>\/XI2\<1\>\/XI2\<1\>\/XI2\<1\>\/XI2\<1\>\/XI2\<0\>\/XI2\<1\>\/RR7_neg \
 ) R_1X_LL w=1e-07 l=1e-07   res=0.149966
XXI2\<0\>\/XI2\<1\>\/XI2\<1\>\/XI2\<1\>\/XI2\<1\>\/XI2\<1\>\/XI2\<0\>\/XI2\<1\>\/RR6 \
 (  \
 N_SEL6\<1\>_XI2\<0\>\/XI2\<1\>\/XI2\<1\>\/XI2\<1\>\/XI2\<1\>\/XI2\<1\>\/XI2\<0\>\/XI2\<1\>\/RR6_pos \
 N_WLSEL\<1006\>_XI2\<0\>\/XI2\<1\>\/XI2\<1\>\/XI2\<1\>\/XI2\<1\>\/XI2\<1\>\/XI2\<0\>\/XI2\<1\>\/RR6_neg \
 ) R_1X_LL w=1e-07 l=1e-07   res=0.149966
XXI2\<0\>\/XI2\<1\>\/XI2\<1\>\/XI2\<1\>\/XI2\<1\>\/XI2\<1\>\/XI2\<0\>\/XI2\<1\>\/RR5 \
 (  \
 N_SEL7\<0\>_XI2\<0\>\/XI2\<1\>\/XI2\<1\>\/XI2\<1\>\/XI2\<1\>\/XI2\<1\>\/XI2\<0\>\/XI2\<1\>\/RR5_pos \
 N_WLSEL\<1007\>_XI2\<0\>\/XI2\<1\>\/XI2\<1\>\/XI2\<1\>\/XI2\<1\>\/XI2\<1\>\/XI2\<0\>\/XI2\<1\>\/RR5_neg \
 ) R_1X_LL w=1e-07 l=1e-07   res=0.149966
XXI2\<0\>\/XI2\<1\>\/XI2\<1\>\/XI2\<1\>\/XI2\<1\>\/XI2\<1\>\/XI2\<1\>\/XI2\<0\>\/RR0 \
 (  \
 N_SEL0\<0\>_XI2\<0\>\/XI2\<1\>\/XI2\<1\>\/XI2\<1\>\/XI2\<1\>\/XI2\<1\>\/XI2\<1\>\/XI2\<0\>\/RR0_pos \
 N_WLSEL\<1008\>_XI2\<0\>\/XI2\<1\>\/XI2\<1\>\/XI2\<1\>\/XI2\<1\>\/XI2\<1\>\/XI2\<1\>\/XI2\<0\>\/RR0_neg \
 ) R_1X_LL w=1e-07 l=1e-07   res=0.149966
XXI2\<0\>\/XI2\<1\>\/XI2\<1\>\/XI2\<1\>\/XI2\<1\>\/XI2\<1\>\/XI2\<1\>\/XI2\<0\>\/RR1 \
 (  \
 N_SEL1\<1\>_XI2\<0\>\/XI2\<1\>\/XI2\<1\>\/XI2\<1\>\/XI2\<1\>\/XI2\<1\>\/XI2\<1\>\/XI2\<0\>\/RR1_pos \
 N_WLSEL\<1009\>_XI2\<0\>\/XI2\<1\>\/XI2\<1\>\/XI2\<1\>\/XI2\<1\>\/XI2\<1\>\/XI2\<1\>\/XI2\<0\>\/RR1_neg \
 ) R_1X_LL w=1e-07 l=1e-07   res=0.149966
XXI2\<0\>\/XI2\<1\>\/XI2\<1\>\/XI2\<1\>\/XI2\<1\>\/XI2\<1\>\/XI2\<1\>\/XI2\<0\>\/RR2 \
 (  \
 N_SEL2\<1\>_XI2\<0\>\/XI2\<1\>\/XI2\<1\>\/XI2\<1\>\/XI2\<1\>\/XI2\<1\>\/XI2\<1\>\/XI2\<0\>\/RR2_pos \
 N_WLSEL\<1010\>_XI2\<0\>\/XI2\<1\>\/XI2\<1\>\/XI2\<1\>\/XI2\<1\>\/XI2\<1\>\/XI2\<1\>\/XI2\<0\>\/RR2_neg \
 ) R_1X_LL w=1e-07 l=1e-07   res=0.149966
XXI2\<0\>\/XI2\<1\>\/XI2\<1\>\/XI2\<1\>\/XI2\<1\>\/XI2\<1\>\/XI2\<1\>\/XI2\<0\>\/RR3 \
 (  \
 N_SEL3\<1\>_XI2\<0\>\/XI2\<1\>\/XI2\<1\>\/XI2\<1\>\/XI2\<1\>\/XI2\<1\>\/XI2\<1\>\/XI2\<0\>\/RR3_pos \
 N_WLSEL\<1011\>_XI2\<0\>\/XI2\<1\>\/XI2\<1\>\/XI2\<1\>\/XI2\<1\>\/XI2\<1\>\/XI2\<1\>\/XI2\<0\>\/RR3_neg \
 ) R_1X_LL w=1e-07 l=1e-07   res=0.149966
XXI2\<0\>\/XI2\<1\>\/XI2\<1\>\/XI2\<1\>\/XI2\<1\>\/XI2\<1\>\/XI2\<1\>\/XI2\<0\>\/RR4 \
 (  \
 N_SEL4\<1\>_XI2\<0\>\/XI2\<1\>\/XI2\<1\>\/XI2\<1\>\/XI2\<1\>\/XI2\<1\>\/XI2\<1\>\/XI2\<0\>\/RR4_pos \
 N_WLSEL\<1012\>_XI2\<0\>\/XI2\<1\>\/XI2\<1\>\/XI2\<1\>\/XI2\<1\>\/XI2\<1\>\/XI2\<1\>\/XI2\<0\>\/RR4_neg \
 ) R_1X_LL w=1e-07 l=1e-07   res=0.149966
XXI2\<0\>\/XI2\<1\>\/XI2\<1\>\/XI2\<1\>\/XI2\<1\>\/XI2\<1\>\/XI2\<1\>\/XI2\<0\>\/RR7 \
 (  \
 N_SEL5\<1\>_XI2\<0\>\/XI2\<1\>\/XI2\<1\>\/XI2\<1\>\/XI2\<1\>\/XI2\<1\>\/XI2\<1\>\/XI2\<0\>\/RR7_pos \
 N_WLSEL\<1013\>_XI2\<0\>\/XI2\<1\>\/XI2\<1\>\/XI2\<1\>\/XI2\<1\>\/XI2\<1\>\/XI2\<1\>\/XI2\<0\>\/RR7_neg \
 ) R_1X_LL w=1e-07 l=1e-07   res=0.149966
XXI2\<0\>\/XI2\<1\>\/XI2\<1\>\/XI2\<1\>\/XI2\<1\>\/XI2\<1\>\/XI2\<1\>\/XI2\<0\>\/RR6 \
 (  \
 N_SEL6\<1\>_XI2\<0\>\/XI2\<1\>\/XI2\<1\>\/XI2\<1\>\/XI2\<1\>\/XI2\<1\>\/XI2\<1\>\/XI2\<0\>\/RR6_pos \
 N_WLSEL\<1014\>_XI2\<0\>\/XI2\<1\>\/XI2\<1\>\/XI2\<1\>\/XI2\<1\>\/XI2\<1\>\/XI2\<1\>\/XI2\<0\>\/RR6_neg \
 ) R_1X_LL w=1e-07 l=1e-07   res=0.149966
XXI2\<0\>\/XI2\<1\>\/XI2\<1\>\/XI2\<1\>\/XI2\<1\>\/XI2\<1\>\/XI2\<1\>\/XI2\<0\>\/RR5 \
 (  \
 N_SEL7\<0\>_XI2\<0\>\/XI2\<1\>\/XI2\<1\>\/XI2\<1\>\/XI2\<1\>\/XI2\<1\>\/XI2\<1\>\/XI2\<0\>\/RR5_pos \
 N_WLSEL\<1015\>_XI2\<0\>\/XI2\<1\>\/XI2\<1\>\/XI2\<1\>\/XI2\<1\>\/XI2\<1\>\/XI2\<1\>\/XI2\<0\>\/RR5_neg \
 ) R_1X_LL w=1e-07 l=1e-07   res=0.149966
XXI2\<0\>\/XI2\<1\>\/XI2\<1\>\/XI2\<1\>\/XI2\<1\>\/XI2\<1\>\/XI2\<1\>\/XI2\<1\>\/RR0 \
 (  \
 N_SEL0\<1\>_XI2\<0\>\/XI2\<1\>\/XI2\<1\>\/XI2\<1\>\/XI2\<1\>\/XI2\<1\>\/XI2\<1\>\/XI2\<1\>\/RR0_pos \
 N_WLSEL\<1016\>_XI2\<0\>\/XI2\<1\>\/XI2\<1\>\/XI2\<1\>\/XI2\<1\>\/XI2\<1\>\/XI2\<1\>\/XI2\<1\>\/RR0_neg \
 ) R_1X_LL w=1e-07 l=1e-07   res=0.149966
XXI2\<0\>\/XI2\<1\>\/XI2\<1\>\/XI2\<1\>\/XI2\<1\>\/XI2\<1\>\/XI2\<1\>\/XI2\<1\>\/RR1 \
 (  \
 N_SEL1\<1\>_XI2\<0\>\/XI2\<1\>\/XI2\<1\>\/XI2\<1\>\/XI2\<1\>\/XI2\<1\>\/XI2\<1\>\/XI2\<1\>\/RR1_pos \
 N_WLSEL\<1017\>_XI2\<0\>\/XI2\<1\>\/XI2\<1\>\/XI2\<1\>\/XI2\<1\>\/XI2\<1\>\/XI2\<1\>\/XI2\<1\>\/RR1_neg \
 ) R_1X_LL w=1e-07 l=1e-07   res=0.149966
XXI2\<0\>\/XI2\<1\>\/XI2\<1\>\/XI2\<1\>\/XI2\<1\>\/XI2\<1\>\/XI2\<1\>\/XI2\<1\>\/RR2 \
 (  \
 N_SEL2\<1\>_XI2\<0\>\/XI2\<1\>\/XI2\<1\>\/XI2\<1\>\/XI2\<1\>\/XI2\<1\>\/XI2\<1\>\/XI2\<1\>\/RR2_pos \
 N_WLSEL\<1018\>_XI2\<0\>\/XI2\<1\>\/XI2\<1\>\/XI2\<1\>\/XI2\<1\>\/XI2\<1\>\/XI2\<1\>\/XI2\<1\>\/RR2_neg \
 ) R_1X_LL w=1e-07 l=1e-07   res=0.149966
XXI2\<0\>\/XI2\<1\>\/XI2\<1\>\/XI2\<1\>\/XI2\<1\>\/XI2\<1\>\/XI2\<1\>\/XI2\<1\>\/RR3 \
 (  \
 N_SEL3\<1\>_XI2\<0\>\/XI2\<1\>\/XI2\<1\>\/XI2\<1\>\/XI2\<1\>\/XI2\<1\>\/XI2\<1\>\/XI2\<1\>\/RR3_pos \
 N_WLSEL\<1019\>_XI2\<0\>\/XI2\<1\>\/XI2\<1\>\/XI2\<1\>\/XI2\<1\>\/XI2\<1\>\/XI2\<1\>\/XI2\<1\>\/RR3_neg \
 ) R_1X_LL w=1e-07 l=1e-07   res=0.149966
XXI2\<0\>\/XI2\<1\>\/XI2\<1\>\/XI2\<1\>\/XI2\<1\>\/XI2\<1\>\/XI2\<1\>\/XI2\<1\>\/RR4 \
 (  \
 N_SEL4\<1\>_XI2\<0\>\/XI2\<1\>\/XI2\<1\>\/XI2\<1\>\/XI2\<1\>\/XI2\<1\>\/XI2\<1\>\/XI2\<1\>\/RR4_pos \
 N_WLSEL\<1020\>_XI2\<0\>\/XI2\<1\>\/XI2\<1\>\/XI2\<1\>\/XI2\<1\>\/XI2\<1\>\/XI2\<1\>\/XI2\<1\>\/RR4_neg \
 ) R_1X_LL w=1e-07 l=1e-07   res=0.149966
XXI2\<0\>\/XI2\<1\>\/XI2\<1\>\/XI2\<1\>\/XI2\<1\>\/XI2\<1\>\/XI2\<1\>\/XI2\<1\>\/RR7 \
 (  \
 N_SEL5\<1\>_XI2\<0\>\/XI2\<1\>\/XI2\<1\>\/XI2\<1\>\/XI2\<1\>\/XI2\<1\>\/XI2\<1\>\/XI2\<1\>\/RR7_pos \
 N_WLSEL\<1021\>_XI2\<0\>\/XI2\<1\>\/XI2\<1\>\/XI2\<1\>\/XI2\<1\>\/XI2\<1\>\/XI2\<1\>\/XI2\<1\>\/RR7_neg \
 ) R_1X_LL w=1e-07 l=1e-07   res=0.149966
XXI2\<0\>\/XI2\<1\>\/XI2\<1\>\/XI2\<1\>\/XI2\<1\>\/XI2\<1\>\/XI2\<1\>\/XI2\<1\>\/RR6 \
 (  \
 N_SEL6\<1\>_XI2\<0\>\/XI2\<1\>\/XI2\<1\>\/XI2\<1\>\/XI2\<1\>\/XI2\<1\>\/XI2\<1\>\/XI2\<1\>\/RR6_pos \
 N_WLSEL\<1022\>_XI2\<0\>\/XI2\<1\>\/XI2\<1\>\/XI2\<1\>\/XI2\<1\>\/XI2\<1\>\/XI2\<1\>\/XI2\<1\>\/RR6_neg \
 ) R_1X_LL w=1e-07 l=1e-07   res=0.149966
XXI2\<0\>\/XI2\<1\>\/XI2\<1\>\/XI2\<1\>\/XI2\<1\>\/XI2\<1\>\/XI2\<1\>\/XI2\<1\>\/RR5 \
 (  \
 N_SEL7\<0\>_XI2\<0\>\/XI2\<1\>\/XI2\<1\>\/XI2\<1\>\/XI2\<1\>\/XI2\<1\>\/XI2\<1\>\/XI2\<1\>\/RR5_pos \
 N_WLSEL\<1023\>_XI2\<0\>\/XI2\<1\>\/XI2\<1\>\/XI2\<1\>\/XI2\<1\>\/XI2\<1\>\/XI2\<1\>\/XI2\<1\>\/RR5_neg \
 ) R_1X_LL w=1e-07 l=1e-07   res=0.149966
XXI2\<0\>\/XI2\<0\>\/XI2\<1\>\/XI2\<1\>\/XI2\<0\>\/XI2\<1\>\/XI2\<1\>\/XI2\<0\>\/RR0 \
 (  \
 N_SEL0\<0\>_XI2\<0\>\/XI2\<0\>\/XI2\<1\>\/XI2\<1\>\/XI2\<0\>\/XI2\<1\>\/XI2\<1\>\/XI2\<0\>\/RR0_pos \
 N_WLSEL\<432\>_XI2\<0\>\/XI2\<0\>\/XI2\<1\>\/XI2\<1\>\/XI2\<0\>\/XI2\<1\>\/XI2\<1\>\/XI2\<0\>\/RR0_neg \
 ) R_1X_LL w=1e-07 l=1e-07   res=0.149966
XXI2\<0\>\/XI2\<0\>\/XI2\<1\>\/XI2\<1\>\/XI2\<0\>\/XI2\<1\>\/XI2\<1\>\/XI2\<0\>\/RR1 \
 (  \
 N_SEL1\<1\>_XI2\<0\>\/XI2\<0\>\/XI2\<1\>\/XI2\<1\>\/XI2\<0\>\/XI2\<1\>\/XI2\<1\>\/XI2\<0\>\/RR1_pos \
 N_WLSEL\<433\>_XI2\<0\>\/XI2\<0\>\/XI2\<1\>\/XI2\<1\>\/XI2\<0\>\/XI2\<1\>\/XI2\<1\>\/XI2\<0\>\/RR1_neg \
 ) R_1X_LL w=1e-07 l=1e-07   res=0.149966
XXI2\<0\>\/XI2\<0\>\/XI2\<1\>\/XI2\<1\>\/XI2\<0\>\/XI2\<1\>\/XI2\<1\>\/XI2\<0\>\/RR2 \
 (  \
 N_SEL2\<1\>_XI2\<0\>\/XI2\<0\>\/XI2\<1\>\/XI2\<1\>\/XI2\<0\>\/XI2\<1\>\/XI2\<1\>\/XI2\<0\>\/RR2_pos \
 N_WLSEL\<434\>_XI2\<0\>\/XI2\<0\>\/XI2\<1\>\/XI2\<1\>\/XI2\<0\>\/XI2\<1\>\/XI2\<1\>\/XI2\<0\>\/RR2_neg \
 ) R_1X_LL w=1e-07 l=1e-07   res=0.149966
XXI2\<0\>\/XI2\<0\>\/XI2\<1\>\/XI2\<1\>\/XI2\<0\>\/XI2\<1\>\/XI2\<1\>\/XI2\<0\>\/RR3 \
 (  \
 N_SEL3\<0\>_XI2\<0\>\/XI2\<0\>\/XI2\<1\>\/XI2\<1\>\/XI2\<0\>\/XI2\<1\>\/XI2\<1\>\/XI2\<0\>\/RR3_pos \
 N_WLSEL\<435\>_XI2\<0\>\/XI2\<0\>\/XI2\<1\>\/XI2\<1\>\/XI2\<0\>\/XI2\<1\>\/XI2\<1\>\/XI2\<0\>\/RR3_neg \
 ) R_1X_LL w=1e-07 l=1e-07   res=0.149966
XXI2\<0\>\/XI2\<0\>\/XI2\<1\>\/XI2\<1\>\/XI2\<0\>\/XI2\<1\>\/XI2\<1\>\/XI2\<0\>\/RR4 \
 (  \
 N_SEL4\<1\>_XI2\<0\>\/XI2\<0\>\/XI2\<1\>\/XI2\<1\>\/XI2\<0\>\/XI2\<1\>\/XI2\<1\>\/XI2\<0\>\/RR4_pos \
 N_WLSEL\<436\>_XI2\<0\>\/XI2\<0\>\/XI2\<1\>\/XI2\<1\>\/XI2\<0\>\/XI2\<1\>\/XI2\<1\>\/XI2\<0\>\/RR4_neg \
 ) R_1X_LL w=1e-07 l=1e-07   res=0.149966
XXI2\<0\>\/XI2\<0\>\/XI2\<1\>\/XI2\<1\>\/XI2\<0\>\/XI2\<1\>\/XI2\<1\>\/XI2\<0\>\/RR7 \
 (  \
 N_SEL5\<1\>_XI2\<0\>\/XI2\<0\>\/XI2\<1\>\/XI2\<1\>\/XI2\<0\>\/XI2\<1\>\/XI2\<1\>\/XI2\<0\>\/RR7_pos \
 N_WLSEL\<437\>_XI2\<0\>\/XI2\<0\>\/XI2\<1\>\/XI2\<1\>\/XI2\<0\>\/XI2\<1\>\/XI2\<1\>\/XI2\<0\>\/RR7_neg \
 ) R_1X_LL w=1e-07 l=1e-07   res=0.149966
XXI2\<0\>\/XI2\<0\>\/XI2\<1\>\/XI2\<1\>\/XI2\<0\>\/XI2\<1\>\/XI2\<1\>\/XI2\<0\>\/RR6 \
 (  \
 N_SEL6\<0\>_XI2\<0\>\/XI2\<0\>\/XI2\<1\>\/XI2\<1\>\/XI2\<0\>\/XI2\<1\>\/XI2\<1\>\/XI2\<0\>\/RR6_pos \
 N_WLSEL\<438\>_XI2\<0\>\/XI2\<0\>\/XI2\<1\>\/XI2\<1\>\/XI2\<0\>\/XI2\<1\>\/XI2\<1\>\/XI2\<0\>\/RR6_neg \
 ) R_1X_LL w=1e-07 l=1e-07   res=0.149966
XXI2\<0\>\/XI2\<0\>\/XI2\<1\>\/XI2\<1\>\/XI2\<0\>\/XI2\<1\>\/XI2\<1\>\/XI2\<0\>\/RR5 \
 (  \
 N_SEL7\<0\>_XI2\<0\>\/XI2\<0\>\/XI2\<1\>\/XI2\<1\>\/XI2\<0\>\/XI2\<1\>\/XI2\<1\>\/XI2\<0\>\/RR5_pos \
 N_WLSEL\<439\>_XI2\<0\>\/XI2\<0\>\/XI2\<1\>\/XI2\<1\>\/XI2\<0\>\/XI2\<1\>\/XI2\<1\>\/XI2\<0\>\/RR5_neg \
 ) R_1X_LL w=1e-07 l=1e-07   res=0.149966
XXI2\<0\>\/XI2\<0\>\/XI2\<1\>\/XI2\<1\>\/XI2\<0\>\/XI2\<1\>\/XI2\<1\>\/XI2\<1\>\/RR0 \
 (  \
 N_SEL0\<1\>_XI2\<0\>\/XI2\<0\>\/XI2\<1\>\/XI2\<1\>\/XI2\<0\>\/XI2\<1\>\/XI2\<1\>\/XI2\<1\>\/RR0_pos \
 N_WLSEL\<440\>_XI2\<0\>\/XI2\<0\>\/XI2\<1\>\/XI2\<1\>\/XI2\<0\>\/XI2\<1\>\/XI2\<1\>\/XI2\<1\>\/RR0_neg \
 ) R_1X_LL w=1e-07 l=1e-07   res=0.149966
XXI2\<0\>\/XI2\<0\>\/XI2\<1\>\/XI2\<1\>\/XI2\<0\>\/XI2\<1\>\/XI2\<1\>\/XI2\<1\>\/RR1 \
 (  \
 N_SEL1\<1\>_XI2\<0\>\/XI2\<0\>\/XI2\<1\>\/XI2\<1\>\/XI2\<0\>\/XI2\<1\>\/XI2\<1\>\/XI2\<1\>\/RR1_pos \
 N_WLSEL\<441\>_XI2\<0\>\/XI2\<0\>\/XI2\<1\>\/XI2\<1\>\/XI2\<0\>\/XI2\<1\>\/XI2\<1\>\/XI2\<1\>\/RR1_neg \
 ) R_1X_LL w=1e-07 l=1e-07   res=0.149966
XXI2\<0\>\/XI2\<0\>\/XI2\<1\>\/XI2\<1\>\/XI2\<0\>\/XI2\<1\>\/XI2\<1\>\/XI2\<1\>\/RR2 \
 (  \
 N_SEL2\<1\>_XI2\<0\>\/XI2\<0\>\/XI2\<1\>\/XI2\<1\>\/XI2\<0\>\/XI2\<1\>\/XI2\<1\>\/XI2\<1\>\/RR2_pos \
 N_WLSEL\<442\>_XI2\<0\>\/XI2\<0\>\/XI2\<1\>\/XI2\<1\>\/XI2\<0\>\/XI2\<1\>\/XI2\<1\>\/XI2\<1\>\/RR2_neg \
 ) R_1X_LL w=1e-07 l=1e-07   res=0.149966
XXI2\<0\>\/XI2\<0\>\/XI2\<1\>\/XI2\<1\>\/XI2\<0\>\/XI2\<1\>\/XI2\<1\>\/XI2\<1\>\/RR3 \
 (  \
 N_SEL3\<0\>_XI2\<0\>\/XI2\<0\>\/XI2\<1\>\/XI2\<1\>\/XI2\<0\>\/XI2\<1\>\/XI2\<1\>\/XI2\<1\>\/RR3_pos \
 N_WLSEL\<443\>_XI2\<0\>\/XI2\<0\>\/XI2\<1\>\/XI2\<1\>\/XI2\<0\>\/XI2\<1\>\/XI2\<1\>\/XI2\<1\>\/RR3_neg \
 ) R_1X_LL w=1e-07 l=1e-07   res=0.149966
XXI2\<0\>\/XI2\<0\>\/XI2\<1\>\/XI2\<1\>\/XI2\<0\>\/XI2\<1\>\/XI2\<1\>\/XI2\<1\>\/RR4 \
 (  \
 N_SEL4\<1\>_XI2\<0\>\/XI2\<0\>\/XI2\<1\>\/XI2\<1\>\/XI2\<0\>\/XI2\<1\>\/XI2\<1\>\/XI2\<1\>\/RR4_pos \
 N_WLSEL\<444\>_XI2\<0\>\/XI2\<0\>\/XI2\<1\>\/XI2\<1\>\/XI2\<0\>\/XI2\<1\>\/XI2\<1\>\/XI2\<1\>\/RR4_neg \
 ) R_1X_LL w=1e-07 l=1e-07   res=0.149966
XXI2\<0\>\/XI2\<0\>\/XI2\<1\>\/XI2\<1\>\/XI2\<0\>\/XI2\<1\>\/XI2\<1\>\/XI2\<1\>\/RR7 \
 (  \
 N_SEL5\<1\>_XI2\<0\>\/XI2\<0\>\/XI2\<1\>\/XI2\<1\>\/XI2\<0\>\/XI2\<1\>\/XI2\<1\>\/XI2\<1\>\/RR7_pos \
 N_WLSEL\<445\>_XI2\<0\>\/XI2\<0\>\/XI2\<1\>\/XI2\<1\>\/XI2\<0\>\/XI2\<1\>\/XI2\<1\>\/XI2\<1\>\/RR7_neg \
 ) R_1X_LL w=1e-07 l=1e-07   res=0.149966
XXI2\<0\>\/XI2\<0\>\/XI2\<1\>\/XI2\<1\>\/XI2\<0\>\/XI2\<1\>\/XI2\<1\>\/XI2\<1\>\/RR6 \
 (  \
 N_SEL6\<0\>_XI2\<0\>\/XI2\<0\>\/XI2\<1\>\/XI2\<1\>\/XI2\<0\>\/XI2\<1\>\/XI2\<1\>\/XI2\<1\>\/RR6_pos \
 N_WLSEL\<446\>_XI2\<0\>\/XI2\<0\>\/XI2\<1\>\/XI2\<1\>\/XI2\<0\>\/XI2\<1\>\/XI2\<1\>\/XI2\<1\>\/RR6_neg \
 ) R_1X_LL w=1e-07 l=1e-07   res=0.149966
XXI2\<0\>\/XI2\<0\>\/XI2\<1\>\/XI2\<1\>\/XI2\<0\>\/XI2\<1\>\/XI2\<1\>\/XI2\<1\>\/RR5 \
 (  \
 N_SEL7\<0\>_XI2\<0\>\/XI2\<0\>\/XI2\<1\>\/XI2\<1\>\/XI2\<0\>\/XI2\<1\>\/XI2\<1\>\/XI2\<1\>\/RR5_pos \
 N_WLSEL\<447\>_XI2\<0\>\/XI2\<0\>\/XI2\<1\>\/XI2\<1\>\/XI2\<0\>\/XI2\<1\>\/XI2\<1\>\/XI2\<1\>\/RR5_neg \
 ) R_1X_LL w=1e-07 l=1e-07   res=0.149966
XXI2\<0\>\/XI2\<0\>\/XI2\<1\>\/XI2\<1\>\/XI2\<1\>\/XI2\<0\>\/XI2\<0\>\/XI2\<0\>\/RR0 \
 (  \
 N_SEL0\<0\>_XI2\<0\>\/XI2\<0\>\/XI2\<1\>\/XI2\<1\>\/XI2\<1\>\/XI2\<0\>\/XI2\<0\>\/XI2\<0\>\/RR0_pos \
 N_WLSEL\<448\>_XI2\<0\>\/XI2\<0\>\/XI2\<1\>\/XI2\<1\>\/XI2\<1\>\/XI2\<0\>\/XI2\<0\>\/XI2\<0\>\/RR0_neg \
 ) R_1X_LL w=1e-07 l=1e-07   res=0.149966
XXI2\<0\>\/XI2\<0\>\/XI2\<1\>\/XI2\<1\>\/XI2\<1\>\/XI2\<0\>\/XI2\<0\>\/XI2\<0\>\/RR1 \
 (  \
 N_SEL1\<0\>_XI2\<0\>\/XI2\<0\>\/XI2\<1\>\/XI2\<1\>\/XI2\<1\>\/XI2\<0\>\/XI2\<0\>\/XI2\<0\>\/RR1_pos \
 N_WLSEL\<449\>_XI2\<0\>\/XI2\<0\>\/XI2\<1\>\/XI2\<1\>\/XI2\<1\>\/XI2\<0\>\/XI2\<0\>\/XI2\<0\>\/RR1_neg \
 ) R_1X_LL w=1e-07 l=1e-07   res=0.149966
XXI2\<0\>\/XI2\<0\>\/XI2\<1\>\/XI2\<1\>\/XI2\<1\>\/XI2\<0\>\/XI2\<0\>\/XI2\<0\>\/RR2 \
 (  \
 N_SEL2\<0\>_XI2\<0\>\/XI2\<0\>\/XI2\<1\>\/XI2\<1\>\/XI2\<1\>\/XI2\<0\>\/XI2\<0\>\/XI2\<0\>\/RR2_pos \
 N_WLSEL\<450\>_XI2\<0\>\/XI2\<0\>\/XI2\<1\>\/XI2\<1\>\/XI2\<1\>\/XI2\<0\>\/XI2\<0\>\/XI2\<0\>\/RR2_neg \
 ) R_1X_LL w=1e-07 l=1e-07   res=0.149966
XXI2\<0\>\/XI2\<0\>\/XI2\<1\>\/XI2\<1\>\/XI2\<1\>\/XI2\<0\>\/XI2\<0\>\/XI2\<0\>\/RR3 \
 (  \
 N_SEL3\<1\>_XI2\<0\>\/XI2\<0\>\/XI2\<1\>\/XI2\<1\>\/XI2\<1\>\/XI2\<0\>\/XI2\<0\>\/XI2\<0\>\/RR3_pos \
 N_WLSEL\<451\>_XI2\<0\>\/XI2\<0\>\/XI2\<1\>\/XI2\<1\>\/XI2\<1\>\/XI2\<0\>\/XI2\<0\>\/XI2\<0\>\/RR3_neg \
 ) R_1X_LL w=1e-07 l=1e-07   res=0.149966
XXI2\<0\>\/XI2\<0\>\/XI2\<1\>\/XI2\<1\>\/XI2\<1\>\/XI2\<0\>\/XI2\<0\>\/XI2\<0\>\/RR4 \
 (  \
 N_SEL4\<1\>_XI2\<0\>\/XI2\<0\>\/XI2\<1\>\/XI2\<1\>\/XI2\<1\>\/XI2\<0\>\/XI2\<0\>\/XI2\<0\>\/RR4_pos \
 N_WLSEL\<452\>_XI2\<0\>\/XI2\<0\>\/XI2\<1\>\/XI2\<1\>\/XI2\<1\>\/XI2\<0\>\/XI2\<0\>\/XI2\<0\>\/RR4_neg \
 ) R_1X_LL w=1e-07 l=1e-07   res=0.149966
XXI2\<0\>\/XI2\<0\>\/XI2\<1\>\/XI2\<1\>\/XI2\<1\>\/XI2\<0\>\/XI2\<0\>\/XI2\<0\>\/RR7 \
 (  \
 N_SEL5\<1\>_XI2\<0\>\/XI2\<0\>\/XI2\<1\>\/XI2\<1\>\/XI2\<1\>\/XI2\<0\>\/XI2\<0\>\/XI2\<0\>\/RR7_pos \
 N_WLSEL\<453\>_XI2\<0\>\/XI2\<0\>\/XI2\<1\>\/XI2\<1\>\/XI2\<1\>\/XI2\<0\>\/XI2\<0\>\/XI2\<0\>\/RR7_neg \
 ) R_1X_LL w=1e-07 l=1e-07   res=0.149966
XXI2\<0\>\/XI2\<0\>\/XI2\<1\>\/XI2\<1\>\/XI2\<1\>\/XI2\<0\>\/XI2\<0\>\/XI2\<0\>\/RR6 \
 (  \
 N_SEL6\<0\>_XI2\<0\>\/XI2\<0\>\/XI2\<1\>\/XI2\<1\>\/XI2\<1\>\/XI2\<0\>\/XI2\<0\>\/XI2\<0\>\/RR6_pos \
 N_WLSEL\<454\>_XI2\<0\>\/XI2\<0\>\/XI2\<1\>\/XI2\<1\>\/XI2\<1\>\/XI2\<0\>\/XI2\<0\>\/XI2\<0\>\/RR6_neg \
 ) R_1X_LL w=1e-07 l=1e-07   res=0.149966
XXI2\<0\>\/XI2\<0\>\/XI2\<1\>\/XI2\<1\>\/XI2\<1\>\/XI2\<0\>\/XI2\<0\>\/XI2\<0\>\/RR5 \
 (  \
 N_SEL7\<0\>_XI2\<0\>\/XI2\<0\>\/XI2\<1\>\/XI2\<1\>\/XI2\<1\>\/XI2\<0\>\/XI2\<0\>\/XI2\<0\>\/RR5_pos \
 N_WLSEL\<455\>_XI2\<0\>\/XI2\<0\>\/XI2\<1\>\/XI2\<1\>\/XI2\<1\>\/XI2\<0\>\/XI2\<0\>\/XI2\<0\>\/RR5_neg \
 ) R_1X_LL w=1e-07 l=1e-07   res=0.149966
XXI2\<0\>\/XI2\<0\>\/XI2\<1\>\/XI2\<1\>\/XI2\<1\>\/XI2\<0\>\/XI2\<0\>\/XI2\<1\>\/RR0 \
 (  \
 N_SEL0\<1\>_XI2\<0\>\/XI2\<0\>\/XI2\<1\>\/XI2\<1\>\/XI2\<1\>\/XI2\<0\>\/XI2\<0\>\/XI2\<1\>\/RR0_pos \
 N_WLSEL\<456\>_XI2\<0\>\/XI2\<0\>\/XI2\<1\>\/XI2\<1\>\/XI2\<1\>\/XI2\<0\>\/XI2\<0\>\/XI2\<1\>\/RR0_neg \
 ) R_1X_LL w=1e-07 l=1e-07   res=0.149966
XXI2\<0\>\/XI2\<0\>\/XI2\<1\>\/XI2\<1\>\/XI2\<1\>\/XI2\<0\>\/XI2\<0\>\/XI2\<1\>\/RR1 \
 (  \
 N_SEL1\<0\>_XI2\<0\>\/XI2\<0\>\/XI2\<1\>\/XI2\<1\>\/XI2\<1\>\/XI2\<0\>\/XI2\<0\>\/XI2\<1\>\/RR1_pos \
 N_WLSEL\<457\>_XI2\<0\>\/XI2\<0\>\/XI2\<1\>\/XI2\<1\>\/XI2\<1\>\/XI2\<0\>\/XI2\<0\>\/XI2\<1\>\/RR1_neg \
 ) R_1X_LL w=1e-07 l=1e-07   res=0.149966
XXI2\<0\>\/XI2\<0\>\/XI2\<1\>\/XI2\<1\>\/XI2\<1\>\/XI2\<0\>\/XI2\<0\>\/XI2\<1\>\/RR2 \
 (  \
 N_SEL2\<0\>_XI2\<0\>\/XI2\<0\>\/XI2\<1\>\/XI2\<1\>\/XI2\<1\>\/XI2\<0\>\/XI2\<0\>\/XI2\<1\>\/RR2_pos \
 N_WLSEL\<458\>_XI2\<0\>\/XI2\<0\>\/XI2\<1\>\/XI2\<1\>\/XI2\<1\>\/XI2\<0\>\/XI2\<0\>\/XI2\<1\>\/RR2_neg \
 ) R_1X_LL w=1e-07 l=1e-07   res=0.149966
XXI2\<0\>\/XI2\<0\>\/XI2\<1\>\/XI2\<1\>\/XI2\<1\>\/XI2\<0\>\/XI2\<0\>\/XI2\<1\>\/RR3 \
 (  \
 N_SEL3\<1\>_XI2\<0\>\/XI2\<0\>\/XI2\<1\>\/XI2\<1\>\/XI2\<1\>\/XI2\<0\>\/XI2\<0\>\/XI2\<1\>\/RR3_pos \
 N_WLSEL\<459\>_XI2\<0\>\/XI2\<0\>\/XI2\<1\>\/XI2\<1\>\/XI2\<1\>\/XI2\<0\>\/XI2\<0\>\/XI2\<1\>\/RR3_neg \
 ) R_1X_LL w=1e-07 l=1e-07   res=0.149966
XXI2\<0\>\/XI2\<0\>\/XI2\<1\>\/XI2\<1\>\/XI2\<1\>\/XI2\<0\>\/XI2\<0\>\/XI2\<1\>\/RR4 \
 (  \
 N_SEL4\<1\>_XI2\<0\>\/XI2\<0\>\/XI2\<1\>\/XI2\<1\>\/XI2\<1\>\/XI2\<0\>\/XI2\<0\>\/XI2\<1\>\/RR4_pos \
 N_WLSEL\<460\>_XI2\<0\>\/XI2\<0\>\/XI2\<1\>\/XI2\<1\>\/XI2\<1\>\/XI2\<0\>\/XI2\<0\>\/XI2\<1\>\/RR4_neg \
 ) R_1X_LL w=1e-07 l=1e-07   res=0.149966
XXI2\<0\>\/XI2\<0\>\/XI2\<1\>\/XI2\<1\>\/XI2\<1\>\/XI2\<0\>\/XI2\<0\>\/XI2\<1\>\/RR7 \
 (  \
 N_SEL5\<1\>_XI2\<0\>\/XI2\<0\>\/XI2\<1\>\/XI2\<1\>\/XI2\<1\>\/XI2\<0\>\/XI2\<0\>\/XI2\<1\>\/RR7_pos \
 N_WLSEL\<461\>_XI2\<0\>\/XI2\<0\>\/XI2\<1\>\/XI2\<1\>\/XI2\<1\>\/XI2\<0\>\/XI2\<0\>\/XI2\<1\>\/RR7_neg \
 ) R_1X_LL w=1e-07 l=1e-07   res=0.149966
XXI2\<0\>\/XI2\<0\>\/XI2\<1\>\/XI2\<1\>\/XI2\<1\>\/XI2\<0\>\/XI2\<0\>\/XI2\<1\>\/RR6 \
 (  \
 N_SEL6\<0\>_XI2\<0\>\/XI2\<0\>\/XI2\<1\>\/XI2\<1\>\/XI2\<1\>\/XI2\<0\>\/XI2\<0\>\/XI2\<1\>\/RR6_pos \
 N_WLSEL\<462\>_XI2\<0\>\/XI2\<0\>\/XI2\<1\>\/XI2\<1\>\/XI2\<1\>\/XI2\<0\>\/XI2\<0\>\/XI2\<1\>\/RR6_neg \
 ) R_1X_LL w=1e-07 l=1e-07   res=0.149966
XXI2\<0\>\/XI2\<0\>\/XI2\<1\>\/XI2\<1\>\/XI2\<1\>\/XI2\<0\>\/XI2\<0\>\/XI2\<1\>\/RR5 \
 (  \
 N_SEL7\<0\>_XI2\<0\>\/XI2\<0\>\/XI2\<1\>\/XI2\<1\>\/XI2\<1\>\/XI2\<0\>\/XI2\<0\>\/XI2\<1\>\/RR5_pos \
 N_WLSEL\<463\>_XI2\<0\>\/XI2\<0\>\/XI2\<1\>\/XI2\<1\>\/XI2\<1\>\/XI2\<0\>\/XI2\<0\>\/XI2\<1\>\/RR5_neg \
 ) R_1X_LL w=1e-07 l=1e-07   res=0.149966
XXI2\<0\>\/XI2\<0\>\/XI2\<1\>\/XI2\<1\>\/XI2\<1\>\/XI2\<0\>\/XI2\<1\>\/XI2\<0\>\/RR0 \
 (  \
 N_SEL0\<0\>_XI2\<0\>\/XI2\<0\>\/XI2\<1\>\/XI2\<1\>\/XI2\<1\>\/XI2\<0\>\/XI2\<1\>\/XI2\<0\>\/RR0_pos \
 N_WLSEL\<464\>_XI2\<0\>\/XI2\<0\>\/XI2\<1\>\/XI2\<1\>\/XI2\<1\>\/XI2\<0\>\/XI2\<1\>\/XI2\<0\>\/RR0_neg \
 ) R_1X_LL w=1e-07 l=1e-07   res=0.149966
XXI2\<0\>\/XI2\<0\>\/XI2\<1\>\/XI2\<1\>\/XI2\<1\>\/XI2\<0\>\/XI2\<1\>\/XI2\<0\>\/RR1 \
 (  \
 N_SEL1\<1\>_XI2\<0\>\/XI2\<0\>\/XI2\<1\>\/XI2\<1\>\/XI2\<1\>\/XI2\<0\>\/XI2\<1\>\/XI2\<0\>\/RR1_pos \
 N_WLSEL\<465\>_XI2\<0\>\/XI2\<0\>\/XI2\<1\>\/XI2\<1\>\/XI2\<1\>\/XI2\<0\>\/XI2\<1\>\/XI2\<0\>\/RR1_neg \
 ) R_1X_LL w=1e-07 l=1e-07   res=0.149966
XXI2\<0\>\/XI2\<0\>\/XI2\<1\>\/XI2\<1\>\/XI2\<1\>\/XI2\<0\>\/XI2\<1\>\/XI2\<0\>\/RR2 \
 (  \
 N_SEL2\<0\>_XI2\<0\>\/XI2\<0\>\/XI2\<1\>\/XI2\<1\>\/XI2\<1\>\/XI2\<0\>\/XI2\<1\>\/XI2\<0\>\/RR2_pos \
 N_WLSEL\<466\>_XI2\<0\>\/XI2\<0\>\/XI2\<1\>\/XI2\<1\>\/XI2\<1\>\/XI2\<0\>\/XI2\<1\>\/XI2\<0\>\/RR2_neg \
 ) R_1X_LL w=1e-07 l=1e-07   res=0.149966
XXI2\<0\>\/XI2\<0\>\/XI2\<1\>\/XI2\<1\>\/XI2\<1\>\/XI2\<0\>\/XI2\<1\>\/XI2\<0\>\/RR3 \
 (  \
 N_SEL3\<1\>_XI2\<0\>\/XI2\<0\>\/XI2\<1\>\/XI2\<1\>\/XI2\<1\>\/XI2\<0\>\/XI2\<1\>\/XI2\<0\>\/RR3_pos \
 N_WLSEL\<467\>_XI2\<0\>\/XI2\<0\>\/XI2\<1\>\/XI2\<1\>\/XI2\<1\>\/XI2\<0\>\/XI2\<1\>\/XI2\<0\>\/RR3_neg \
 ) R_1X_LL w=1e-07 l=1e-07   res=0.149966
XXI2\<0\>\/XI2\<0\>\/XI2\<1\>\/XI2\<1\>\/XI2\<1\>\/XI2\<0\>\/XI2\<1\>\/XI2\<0\>\/RR4 \
 (  \
 N_SEL4\<1\>_XI2\<0\>\/XI2\<0\>\/XI2\<1\>\/XI2\<1\>\/XI2\<1\>\/XI2\<0\>\/XI2\<1\>\/XI2\<0\>\/RR4_pos \
 N_WLSEL\<468\>_XI2\<0\>\/XI2\<0\>\/XI2\<1\>\/XI2\<1\>\/XI2\<1\>\/XI2\<0\>\/XI2\<1\>\/XI2\<0\>\/RR4_neg \
 ) R_1X_LL w=1e-07 l=1e-07   res=0.149966
XXI2\<0\>\/XI2\<0\>\/XI2\<1\>\/XI2\<1\>\/XI2\<1\>\/XI2\<0\>\/XI2\<1\>\/XI2\<0\>\/RR7 \
 (  \
 N_SEL5\<1\>_XI2\<0\>\/XI2\<0\>\/XI2\<1\>\/XI2\<1\>\/XI2\<1\>\/XI2\<0\>\/XI2\<1\>\/XI2\<0\>\/RR7_pos \
 N_WLSEL\<469\>_XI2\<0\>\/XI2\<0\>\/XI2\<1\>\/XI2\<1\>\/XI2\<1\>\/XI2\<0\>\/XI2\<1\>\/XI2\<0\>\/RR7_neg \
 ) R_1X_LL w=1e-07 l=1e-07   res=0.149966
XXI2\<0\>\/XI2\<0\>\/XI2\<1\>\/XI2\<1\>\/XI2\<1\>\/XI2\<0\>\/XI2\<1\>\/XI2\<0\>\/RR6 \
 (  \
 N_SEL6\<0\>_XI2\<0\>\/XI2\<0\>\/XI2\<1\>\/XI2\<1\>\/XI2\<1\>\/XI2\<0\>\/XI2\<1\>\/XI2\<0\>\/RR6_pos \
 N_WLSEL\<470\>_XI2\<0\>\/XI2\<0\>\/XI2\<1\>\/XI2\<1\>\/XI2\<1\>\/XI2\<0\>\/XI2\<1\>\/XI2\<0\>\/RR6_neg \
 ) R_1X_LL w=1e-07 l=1e-07   res=0.149966
XXI2\<0\>\/XI2\<0\>\/XI2\<1\>\/XI2\<1\>\/XI2\<1\>\/XI2\<0\>\/XI2\<1\>\/XI2\<0\>\/RR5 \
 (  \
 N_SEL7\<0\>_XI2\<0\>\/XI2\<0\>\/XI2\<1\>\/XI2\<1\>\/XI2\<1\>\/XI2\<0\>\/XI2\<1\>\/XI2\<0\>\/RR5_pos \
 N_WLSEL\<471\>_XI2\<0\>\/XI2\<0\>\/XI2\<1\>\/XI2\<1\>\/XI2\<1\>\/XI2\<0\>\/XI2\<1\>\/XI2\<0\>\/RR5_neg \
 ) R_1X_LL w=1e-07 l=1e-07   res=0.149966
XXI2\<0\>\/XI2\<0\>\/XI2\<1\>\/XI2\<1\>\/XI2\<1\>\/XI2\<0\>\/XI2\<1\>\/XI2\<1\>\/RR0 \
 (  \
 N_SEL0\<1\>_XI2\<0\>\/XI2\<0\>\/XI2\<1\>\/XI2\<1\>\/XI2\<1\>\/XI2\<0\>\/XI2\<1\>\/XI2\<1\>\/RR0_pos \
 N_WLSEL\<472\>_XI2\<0\>\/XI2\<0\>\/XI2\<1\>\/XI2\<1\>\/XI2\<1\>\/XI2\<0\>\/XI2\<1\>\/XI2\<1\>\/RR0_neg \
 ) R_1X_LL w=1e-07 l=1e-07   res=0.149966
XXI2\<0\>\/XI2\<0\>\/XI2\<1\>\/XI2\<1\>\/XI2\<1\>\/XI2\<0\>\/XI2\<1\>\/XI2\<1\>\/RR1 \
 (  \
 N_SEL1\<1\>_XI2\<0\>\/XI2\<0\>\/XI2\<1\>\/XI2\<1\>\/XI2\<1\>\/XI2\<0\>\/XI2\<1\>\/XI2\<1\>\/RR1_pos \
 N_WLSEL\<473\>_XI2\<0\>\/XI2\<0\>\/XI2\<1\>\/XI2\<1\>\/XI2\<1\>\/XI2\<0\>\/XI2\<1\>\/XI2\<1\>\/RR1_neg \
 ) R_1X_LL w=1e-07 l=1e-07   res=0.149966
XXI2\<0\>\/XI2\<0\>\/XI2\<1\>\/XI2\<1\>\/XI2\<1\>\/XI2\<0\>\/XI2\<1\>\/XI2\<1\>\/RR2 \
 (  \
 N_SEL2\<0\>_XI2\<0\>\/XI2\<0\>\/XI2\<1\>\/XI2\<1\>\/XI2\<1\>\/XI2\<0\>\/XI2\<1\>\/XI2\<1\>\/RR2_pos \
 N_WLSEL\<474\>_XI2\<0\>\/XI2\<0\>\/XI2\<1\>\/XI2\<1\>\/XI2\<1\>\/XI2\<0\>\/XI2\<1\>\/XI2\<1\>\/RR2_neg \
 ) R_1X_LL w=1e-07 l=1e-07   res=0.149966
XXI2\<0\>\/XI2\<0\>\/XI2\<1\>\/XI2\<1\>\/XI2\<1\>\/XI2\<0\>\/XI2\<1\>\/XI2\<1\>\/RR3 \
 (  \
 N_SEL3\<1\>_XI2\<0\>\/XI2\<0\>\/XI2\<1\>\/XI2\<1\>\/XI2\<1\>\/XI2\<0\>\/XI2\<1\>\/XI2\<1\>\/RR3_pos \
 N_WLSEL\<475\>_XI2\<0\>\/XI2\<0\>\/XI2\<1\>\/XI2\<1\>\/XI2\<1\>\/XI2\<0\>\/XI2\<1\>\/XI2\<1\>\/RR3_neg \
 ) R_1X_LL w=1e-07 l=1e-07   res=0.149966
XXI2\<0\>\/XI2\<0\>\/XI2\<1\>\/XI2\<1\>\/XI2\<1\>\/XI2\<0\>\/XI2\<1\>\/XI2\<1\>\/RR4 \
 (  \
 N_SEL4\<1\>_XI2\<0\>\/XI2\<0\>\/XI2\<1\>\/XI2\<1\>\/XI2\<1\>\/XI2\<0\>\/XI2\<1\>\/XI2\<1\>\/RR4_pos \
 N_WLSEL\<476\>_XI2\<0\>\/XI2\<0\>\/XI2\<1\>\/XI2\<1\>\/XI2\<1\>\/XI2\<0\>\/XI2\<1\>\/XI2\<1\>\/RR4_neg \
 ) R_1X_LL w=1e-07 l=1e-07   res=0.149966
XXI2\<0\>\/XI2\<0\>\/XI2\<1\>\/XI2\<1\>\/XI2\<1\>\/XI2\<0\>\/XI2\<1\>\/XI2\<1\>\/RR7 \
 (  \
 N_SEL5\<1\>_XI2\<0\>\/XI2\<0\>\/XI2\<1\>\/XI2\<1\>\/XI2\<1\>\/XI2\<0\>\/XI2\<1\>\/XI2\<1\>\/RR7_pos \
 N_WLSEL\<477\>_XI2\<0\>\/XI2\<0\>\/XI2\<1\>\/XI2\<1\>\/XI2\<1\>\/XI2\<0\>\/XI2\<1\>\/XI2\<1\>\/RR7_neg \
 ) R_1X_LL w=1e-07 l=1e-07   res=0.149966
XXI2\<0\>\/XI2\<0\>\/XI2\<1\>\/XI2\<1\>\/XI2\<1\>\/XI2\<0\>\/XI2\<1\>\/XI2\<1\>\/RR6 \
 (  \
 N_SEL6\<0\>_XI2\<0\>\/XI2\<0\>\/XI2\<1\>\/XI2\<1\>\/XI2\<1\>\/XI2\<0\>\/XI2\<1\>\/XI2\<1\>\/RR6_pos \
 N_WLSEL\<478\>_XI2\<0\>\/XI2\<0\>\/XI2\<1\>\/XI2\<1\>\/XI2\<1\>\/XI2\<0\>\/XI2\<1\>\/XI2\<1\>\/RR6_neg \
 ) R_1X_LL w=1e-07 l=1e-07   res=0.149966
XXI2\<0\>\/XI2\<0\>\/XI2\<1\>\/XI2\<1\>\/XI2\<1\>\/XI2\<0\>\/XI2\<1\>\/XI2\<1\>\/RR5 \
 (  \
 N_SEL7\<0\>_XI2\<0\>\/XI2\<0\>\/XI2\<1\>\/XI2\<1\>\/XI2\<1\>\/XI2\<0\>\/XI2\<1\>\/XI2\<1\>\/RR5_pos \
 N_WLSEL\<479\>_XI2\<0\>\/XI2\<0\>\/XI2\<1\>\/XI2\<1\>\/XI2\<1\>\/XI2\<0\>\/XI2\<1\>\/XI2\<1\>\/RR5_neg \
 ) R_1X_LL w=1e-07 l=1e-07   res=0.149966
XXI2\<0\>\/XI2\<0\>\/XI2\<1\>\/XI2\<1\>\/XI2\<1\>\/XI2\<1\>\/XI2\<0\>\/XI2\<0\>\/RR0 \
 (  \
 N_SEL0\<0\>_XI2\<0\>\/XI2\<0\>\/XI2\<1\>\/XI2\<1\>\/XI2\<1\>\/XI2\<1\>\/XI2\<0\>\/XI2\<0\>\/RR0_pos \
 N_WLSEL\<480\>_XI2\<0\>\/XI2\<0\>\/XI2\<1\>\/XI2\<1\>\/XI2\<1\>\/XI2\<1\>\/XI2\<0\>\/XI2\<0\>\/RR0_neg \
 ) R_1X_LL w=1e-07 l=1e-07   res=0.149966
XXI2\<0\>\/XI2\<0\>\/XI2\<1\>\/XI2\<1\>\/XI2\<1\>\/XI2\<1\>\/XI2\<0\>\/XI2\<0\>\/RR1 \
 (  \
 N_SEL1\<0\>_XI2\<0\>\/XI2\<0\>\/XI2\<1\>\/XI2\<1\>\/XI2\<1\>\/XI2\<1\>\/XI2\<0\>\/XI2\<0\>\/RR1_pos \
 N_WLSEL\<481\>_XI2\<0\>\/XI2\<0\>\/XI2\<1\>\/XI2\<1\>\/XI2\<1\>\/XI2\<1\>\/XI2\<0\>\/XI2\<0\>\/RR1_neg \
 ) R_1X_LL w=1e-07 l=1e-07   res=0.149966
XXI2\<0\>\/XI2\<0\>\/XI2\<1\>\/XI2\<1\>\/XI2\<1\>\/XI2\<1\>\/XI2\<0\>\/XI2\<0\>\/RR2 \
 (  \
 N_SEL2\<1\>_XI2\<0\>\/XI2\<0\>\/XI2\<1\>\/XI2\<1\>\/XI2\<1\>\/XI2\<1\>\/XI2\<0\>\/XI2\<0\>\/RR2_pos \
 N_WLSEL\<482\>_XI2\<0\>\/XI2\<0\>\/XI2\<1\>\/XI2\<1\>\/XI2\<1\>\/XI2\<1\>\/XI2\<0\>\/XI2\<0\>\/RR2_neg \
 ) R_1X_LL w=1e-07 l=1e-07   res=0.149966
XXI2\<0\>\/XI2\<0\>\/XI2\<1\>\/XI2\<1\>\/XI2\<1\>\/XI2\<1\>\/XI2\<0\>\/XI2\<0\>\/RR3 \
 (  \
 N_SEL3\<1\>_XI2\<0\>\/XI2\<0\>\/XI2\<1\>\/XI2\<1\>\/XI2\<1\>\/XI2\<1\>\/XI2\<0\>\/XI2\<0\>\/RR3_pos \
 N_WLSEL\<483\>_XI2\<0\>\/XI2\<0\>\/XI2\<1\>\/XI2\<1\>\/XI2\<1\>\/XI2\<1\>\/XI2\<0\>\/XI2\<0\>\/RR3_neg \
 ) R_1X_LL w=1e-07 l=1e-07   res=0.149966
XXI2\<0\>\/XI2\<0\>\/XI2\<1\>\/XI2\<1\>\/XI2\<1\>\/XI2\<1\>\/XI2\<0\>\/XI2\<0\>\/RR4 \
 (  \
 N_SEL4\<1\>_XI2\<0\>\/XI2\<0\>\/XI2\<1\>\/XI2\<1\>\/XI2\<1\>\/XI2\<1\>\/XI2\<0\>\/XI2\<0\>\/RR4_pos \
 N_WLSEL\<484\>_XI2\<0\>\/XI2\<0\>\/XI2\<1\>\/XI2\<1\>\/XI2\<1\>\/XI2\<1\>\/XI2\<0\>\/XI2\<0\>\/RR4_neg \
 ) R_1X_LL w=1e-07 l=1e-07   res=0.149966
XXI2\<0\>\/XI2\<0\>\/XI2\<1\>\/XI2\<1\>\/XI2\<1\>\/XI2\<1\>\/XI2\<0\>\/XI2\<0\>\/RR7 \
 (  \
 N_SEL5\<1\>_XI2\<0\>\/XI2\<0\>\/XI2\<1\>\/XI2\<1\>\/XI2\<1\>\/XI2\<1\>\/XI2\<0\>\/XI2\<0\>\/RR7_pos \
 N_WLSEL\<485\>_XI2\<0\>\/XI2\<0\>\/XI2\<1\>\/XI2\<1\>\/XI2\<1\>\/XI2\<1\>\/XI2\<0\>\/XI2\<0\>\/RR7_neg \
 ) R_1X_LL w=1e-07 l=1e-07   res=0.149966
XXI2\<0\>\/XI2\<0\>\/XI2\<1\>\/XI2\<1\>\/XI2\<1\>\/XI2\<1\>\/XI2\<0\>\/XI2\<0\>\/RR6 \
 (  \
 N_SEL6\<0\>_XI2\<0\>\/XI2\<0\>\/XI2\<1\>\/XI2\<1\>\/XI2\<1\>\/XI2\<1\>\/XI2\<0\>\/XI2\<0\>\/RR6_pos \
 N_WLSEL\<486\>_XI2\<0\>\/XI2\<0\>\/XI2\<1\>\/XI2\<1\>\/XI2\<1\>\/XI2\<1\>\/XI2\<0\>\/XI2\<0\>\/RR6_neg \
 ) R_1X_LL w=1e-07 l=1e-07   res=0.149966
XXI2\<0\>\/XI2\<0\>\/XI2\<1\>\/XI2\<1\>\/XI2\<1\>\/XI2\<1\>\/XI2\<0\>\/XI2\<0\>\/RR5 \
 (  \
 N_SEL7\<0\>_XI2\<0\>\/XI2\<0\>\/XI2\<1\>\/XI2\<1\>\/XI2\<1\>\/XI2\<1\>\/XI2\<0\>\/XI2\<0\>\/RR5_pos \
 N_WLSEL\<487\>_XI2\<0\>\/XI2\<0\>\/XI2\<1\>\/XI2\<1\>\/XI2\<1\>\/XI2\<1\>\/XI2\<0\>\/XI2\<0\>\/RR5_neg \
 ) R_1X_LL w=1e-07 l=1e-07   res=0.149966
XXI2\<0\>\/XI2\<0\>\/XI2\<1\>\/XI2\<1\>\/XI2\<1\>\/XI2\<1\>\/XI2\<0\>\/XI2\<1\>\/RR0 \
 (  \
 N_SEL0\<1\>_XI2\<0\>\/XI2\<0\>\/XI2\<1\>\/XI2\<1\>\/XI2\<1\>\/XI2\<1\>\/XI2\<0\>\/XI2\<1\>\/RR0_pos \
 N_WLSEL\<488\>_XI2\<0\>\/XI2\<0\>\/XI2\<1\>\/XI2\<1\>\/XI2\<1\>\/XI2\<1\>\/XI2\<0\>\/XI2\<1\>\/RR0_neg \
 ) R_1X_LL w=1e-07 l=1e-07   res=0.149966
XXI2\<0\>\/XI2\<0\>\/XI2\<1\>\/XI2\<1\>\/XI2\<1\>\/XI2\<1\>\/XI2\<0\>\/XI2\<1\>\/RR1 \
 (  \
 N_SEL1\<0\>_XI2\<0\>\/XI2\<0\>\/XI2\<1\>\/XI2\<1\>\/XI2\<1\>\/XI2\<1\>\/XI2\<0\>\/XI2\<1\>\/RR1_pos \
 N_WLSEL\<489\>_XI2\<0\>\/XI2\<0\>\/XI2\<1\>\/XI2\<1\>\/XI2\<1\>\/XI2\<1\>\/XI2\<0\>\/XI2\<1\>\/RR1_neg \
 ) R_1X_LL w=1e-07 l=1e-07   res=0.149966
XXI2\<0\>\/XI2\<0\>\/XI2\<1\>\/XI2\<1\>\/XI2\<1\>\/XI2\<1\>\/XI2\<0\>\/XI2\<1\>\/RR2 \
 (  \
 N_SEL2\<1\>_XI2\<0\>\/XI2\<0\>\/XI2\<1\>\/XI2\<1\>\/XI2\<1\>\/XI2\<1\>\/XI2\<0\>\/XI2\<1\>\/RR2_pos \
 N_WLSEL\<490\>_XI2\<0\>\/XI2\<0\>\/XI2\<1\>\/XI2\<1\>\/XI2\<1\>\/XI2\<1\>\/XI2\<0\>\/XI2\<1\>\/RR2_neg \
 ) R_1X_LL w=1e-07 l=1e-07   res=0.149966
XXI2\<0\>\/XI2\<0\>\/XI2\<1\>\/XI2\<1\>\/XI2\<1\>\/XI2\<1\>\/XI2\<0\>\/XI2\<1\>\/RR3 \
 (  \
 N_SEL3\<1\>_XI2\<0\>\/XI2\<0\>\/XI2\<1\>\/XI2\<1\>\/XI2\<1\>\/XI2\<1\>\/XI2\<0\>\/XI2\<1\>\/RR3_pos \
 N_WLSEL\<491\>_XI2\<0\>\/XI2\<0\>\/XI2\<1\>\/XI2\<1\>\/XI2\<1\>\/XI2\<1\>\/XI2\<0\>\/XI2\<1\>\/RR3_neg \
 ) R_1X_LL w=1e-07 l=1e-07   res=0.149966
XXI2\<0\>\/XI2\<0\>\/XI2\<1\>\/XI2\<1\>\/XI2\<1\>\/XI2\<1\>\/XI2\<0\>\/XI2\<1\>\/RR4 \
 (  \
 N_SEL4\<1\>_XI2\<0\>\/XI2\<0\>\/XI2\<1\>\/XI2\<1\>\/XI2\<1\>\/XI2\<1\>\/XI2\<0\>\/XI2\<1\>\/RR4_pos \
 N_WLSEL\<492\>_XI2\<0\>\/XI2\<0\>\/XI2\<1\>\/XI2\<1\>\/XI2\<1\>\/XI2\<1\>\/XI2\<0\>\/XI2\<1\>\/RR4_neg \
 ) R_1X_LL w=1e-07 l=1e-07   res=0.149966
XXI2\<0\>\/XI2\<0\>\/XI2\<1\>\/XI2\<1\>\/XI2\<1\>\/XI2\<1\>\/XI2\<0\>\/XI2\<1\>\/RR7 \
 (  \
 N_SEL5\<1\>_XI2\<0\>\/XI2\<0\>\/XI2\<1\>\/XI2\<1\>\/XI2\<1\>\/XI2\<1\>\/XI2\<0\>\/XI2\<1\>\/RR7_pos \
 N_WLSEL\<493\>_XI2\<0\>\/XI2\<0\>\/XI2\<1\>\/XI2\<1\>\/XI2\<1\>\/XI2\<1\>\/XI2\<0\>\/XI2\<1\>\/RR7_neg \
 ) R_1X_LL w=1e-07 l=1e-07   res=0.149966
XXI2\<0\>\/XI2\<0\>\/XI2\<1\>\/XI2\<1\>\/XI2\<1\>\/XI2\<1\>\/XI2\<0\>\/XI2\<1\>\/RR6 \
 (  \
 N_SEL6\<0\>_XI2\<0\>\/XI2\<0\>\/XI2\<1\>\/XI2\<1\>\/XI2\<1\>\/XI2\<1\>\/XI2\<0\>\/XI2\<1\>\/RR6_pos \
 N_WLSEL\<494\>_XI2\<0\>\/XI2\<0\>\/XI2\<1\>\/XI2\<1\>\/XI2\<1\>\/XI2\<1\>\/XI2\<0\>\/XI2\<1\>\/RR6_neg \
 ) R_1X_LL w=1e-07 l=1e-07   res=0.149966
XXI2\<0\>\/XI2\<0\>\/XI2\<1\>\/XI2\<1\>\/XI2\<1\>\/XI2\<1\>\/XI2\<0\>\/XI2\<1\>\/RR5 \
 (  \
 N_SEL7\<0\>_XI2\<0\>\/XI2\<0\>\/XI2\<1\>\/XI2\<1\>\/XI2\<1\>\/XI2\<1\>\/XI2\<0\>\/XI2\<1\>\/RR5_pos \
 N_WLSEL\<495\>_XI2\<0\>\/XI2\<0\>\/XI2\<1\>\/XI2\<1\>\/XI2\<1\>\/XI2\<1\>\/XI2\<0\>\/XI2\<1\>\/RR5_neg \
 ) R_1X_LL w=1e-07 l=1e-07   res=0.149966
XXI2\<0\>\/XI2\<0\>\/XI2\<1\>\/XI2\<1\>\/XI2\<1\>\/XI2\<1\>\/XI2\<1\>\/XI2\<0\>\/RR0 \
 (  \
 N_SEL0\<0\>_XI2\<0\>\/XI2\<0\>\/XI2\<1\>\/XI2\<1\>\/XI2\<1\>\/XI2\<1\>\/XI2\<1\>\/XI2\<0\>\/RR0_pos \
 N_WLSEL\<496\>_XI2\<0\>\/XI2\<0\>\/XI2\<1\>\/XI2\<1\>\/XI2\<1\>\/XI2\<1\>\/XI2\<1\>\/XI2\<0\>\/RR0_neg \
 ) R_1X_LL w=1e-07 l=1e-07   res=0.149966
XXI2\<0\>\/XI2\<0\>\/XI2\<1\>\/XI2\<1\>\/XI2\<1\>\/XI2\<1\>\/XI2\<1\>\/XI2\<0\>\/RR1 \
 (  \
 N_SEL1\<1\>_XI2\<0\>\/XI2\<0\>\/XI2\<1\>\/XI2\<1\>\/XI2\<1\>\/XI2\<1\>\/XI2\<1\>\/XI2\<0\>\/RR1_pos \
 N_WLSEL\<497\>_XI2\<0\>\/XI2\<0\>\/XI2\<1\>\/XI2\<1\>\/XI2\<1\>\/XI2\<1\>\/XI2\<1\>\/XI2\<0\>\/RR1_neg \
 ) R_1X_LL w=1e-07 l=1e-07   res=0.149966
XXI2\<0\>\/XI2\<0\>\/XI2\<1\>\/XI2\<1\>\/XI2\<1\>\/XI2\<1\>\/XI2\<1\>\/XI2\<0\>\/RR2 \
 (  \
 N_SEL2\<1\>_XI2\<0\>\/XI2\<0\>\/XI2\<1\>\/XI2\<1\>\/XI2\<1\>\/XI2\<1\>\/XI2\<1\>\/XI2\<0\>\/RR2_pos \
 N_WLSEL\<498\>_XI2\<0\>\/XI2\<0\>\/XI2\<1\>\/XI2\<1\>\/XI2\<1\>\/XI2\<1\>\/XI2\<1\>\/XI2\<0\>\/RR2_neg \
 ) R_1X_LL w=1e-07 l=1e-07   res=0.149966
XXI2\<0\>\/XI2\<0\>\/XI2\<1\>\/XI2\<1\>\/XI2\<1\>\/XI2\<1\>\/XI2\<1\>\/XI2\<0\>\/RR3 \
 (  \
 N_SEL3\<1\>_XI2\<0\>\/XI2\<0\>\/XI2\<1\>\/XI2\<1\>\/XI2\<1\>\/XI2\<1\>\/XI2\<1\>\/XI2\<0\>\/RR3_pos \
 N_WLSEL\<499\>_XI2\<0\>\/XI2\<0\>\/XI2\<1\>\/XI2\<1\>\/XI2\<1\>\/XI2\<1\>\/XI2\<1\>\/XI2\<0\>\/RR3_neg \
 ) R_1X_LL w=1e-07 l=1e-07   res=0.149966
XXI2\<0\>\/XI2\<0\>\/XI2\<1\>\/XI2\<1\>\/XI2\<1\>\/XI2\<1\>\/XI2\<1\>\/XI2\<0\>\/RR4 \
 (  \
 N_SEL4\<1\>_XI2\<0\>\/XI2\<0\>\/XI2\<1\>\/XI2\<1\>\/XI2\<1\>\/XI2\<1\>\/XI2\<1\>\/XI2\<0\>\/RR4_pos \
 N_WLSEL\<500\>_XI2\<0\>\/XI2\<0\>\/XI2\<1\>\/XI2\<1\>\/XI2\<1\>\/XI2\<1\>\/XI2\<1\>\/XI2\<0\>\/RR4_neg \
 ) R_1X_LL w=1e-07 l=1e-07   res=0.149966
XXI2\<0\>\/XI2\<0\>\/XI2\<1\>\/XI2\<1\>\/XI2\<1\>\/XI2\<1\>\/XI2\<1\>\/XI2\<0\>\/RR7 \
 (  \
 N_SEL5\<1\>_XI2\<0\>\/XI2\<0\>\/XI2\<1\>\/XI2\<1\>\/XI2\<1\>\/XI2\<1\>\/XI2\<1\>\/XI2\<0\>\/RR7_pos \
 N_WLSEL\<501\>_XI2\<0\>\/XI2\<0\>\/XI2\<1\>\/XI2\<1\>\/XI2\<1\>\/XI2\<1\>\/XI2\<1\>\/XI2\<0\>\/RR7_neg \
 ) R_1X_LL w=1e-07 l=1e-07   res=0.149966
XXI2\<0\>\/XI2\<0\>\/XI2\<1\>\/XI2\<1\>\/XI2\<1\>\/XI2\<1\>\/XI2\<1\>\/XI2\<0\>\/RR6 \
 (  \
 N_SEL6\<0\>_XI2\<0\>\/XI2\<0\>\/XI2\<1\>\/XI2\<1\>\/XI2\<1\>\/XI2\<1\>\/XI2\<1\>\/XI2\<0\>\/RR6_pos \
 N_WLSEL\<502\>_XI2\<0\>\/XI2\<0\>\/XI2\<1\>\/XI2\<1\>\/XI2\<1\>\/XI2\<1\>\/XI2\<1\>\/XI2\<0\>\/RR6_neg \
 ) R_1X_LL w=1e-07 l=1e-07   res=0.149966
XXI2\<0\>\/XI2\<0\>\/XI2\<1\>\/XI2\<1\>\/XI2\<1\>\/XI2\<1\>\/XI2\<1\>\/XI2\<0\>\/RR5 \
 (  \
 N_SEL7\<0\>_XI2\<0\>\/XI2\<0\>\/XI2\<1\>\/XI2\<1\>\/XI2\<1\>\/XI2\<1\>\/XI2\<1\>\/XI2\<0\>\/RR5_pos \
 N_WLSEL\<503\>_XI2\<0\>\/XI2\<0\>\/XI2\<1\>\/XI2\<1\>\/XI2\<1\>\/XI2\<1\>\/XI2\<1\>\/XI2\<0\>\/RR5_neg \
 ) R_1X_LL w=1e-07 l=1e-07   res=0.149966
XXI2\<0\>\/XI2\<0\>\/XI2\<1\>\/XI2\<1\>\/XI2\<1\>\/XI2\<1\>\/XI2\<1\>\/XI2\<1\>\/RR0 \
 (  \
 N_SEL0\<1\>_XI2\<0\>\/XI2\<0\>\/XI2\<1\>\/XI2\<1\>\/XI2\<1\>\/XI2\<1\>\/XI2\<1\>\/XI2\<1\>\/RR0_pos \
 N_WLSEL\<504\>_XI2\<0\>\/XI2\<0\>\/XI2\<1\>\/XI2\<1\>\/XI2\<1\>\/XI2\<1\>\/XI2\<1\>\/XI2\<1\>\/RR0_neg \
 ) R_1X_LL w=1e-07 l=1e-07   res=0.149966
XXI2\<0\>\/XI2\<0\>\/XI2\<1\>\/XI2\<1\>\/XI2\<1\>\/XI2\<1\>\/XI2\<1\>\/XI2\<1\>\/RR1 \
 (  \
 N_SEL1\<1\>_XI2\<0\>\/XI2\<0\>\/XI2\<1\>\/XI2\<1\>\/XI2\<1\>\/XI2\<1\>\/XI2\<1\>\/XI2\<1\>\/RR1_pos \
 N_WLSEL\<505\>_XI2\<0\>\/XI2\<0\>\/XI2\<1\>\/XI2\<1\>\/XI2\<1\>\/XI2\<1\>\/XI2\<1\>\/XI2\<1\>\/RR1_neg \
 ) R_1X_LL w=1e-07 l=1e-07   res=0.149966
XXI2\<0\>\/XI2\<0\>\/XI2\<1\>\/XI2\<1\>\/XI2\<1\>\/XI2\<1\>\/XI2\<1\>\/XI2\<1\>\/RR2 \
 (  \
 N_SEL2\<1\>_XI2\<0\>\/XI2\<0\>\/XI2\<1\>\/XI2\<1\>\/XI2\<1\>\/XI2\<1\>\/XI2\<1\>\/XI2\<1\>\/RR2_pos \
 N_WLSEL\<506\>_XI2\<0\>\/XI2\<0\>\/XI2\<1\>\/XI2\<1\>\/XI2\<1\>\/XI2\<1\>\/XI2\<1\>\/XI2\<1\>\/RR2_neg \
 ) R_1X_LL w=1e-07 l=1e-07   res=0.149966
XXI2\<0\>\/XI2\<0\>\/XI2\<1\>\/XI2\<1\>\/XI2\<1\>\/XI2\<1\>\/XI2\<1\>\/XI2\<1\>\/RR3 \
 (  \
 N_SEL3\<1\>_XI2\<0\>\/XI2\<0\>\/XI2\<1\>\/XI2\<1\>\/XI2\<1\>\/XI2\<1\>\/XI2\<1\>\/XI2\<1\>\/RR3_pos \
 N_WLSEL\<507\>_XI2\<0\>\/XI2\<0\>\/XI2\<1\>\/XI2\<1\>\/XI2\<1\>\/XI2\<1\>\/XI2\<1\>\/XI2\<1\>\/RR3_neg \
 ) R_1X_LL w=1e-07 l=1e-07   res=0.149966
XXI2\<0\>\/XI2\<0\>\/XI2\<1\>\/XI2\<1\>\/XI2\<1\>\/XI2\<1\>\/XI2\<1\>\/XI2\<1\>\/RR4 \
 (  \
 N_SEL4\<1\>_XI2\<0\>\/XI2\<0\>\/XI2\<1\>\/XI2\<1\>\/XI2\<1\>\/XI2\<1\>\/XI2\<1\>\/XI2\<1\>\/RR4_pos \
 N_WLSEL\<508\>_XI2\<0\>\/XI2\<0\>\/XI2\<1\>\/XI2\<1\>\/XI2\<1\>\/XI2\<1\>\/XI2\<1\>\/XI2\<1\>\/RR4_neg \
 ) R_1X_LL w=1e-07 l=1e-07   res=0.149966
XXI2\<0\>\/XI2\<0\>\/XI2\<1\>\/XI2\<1\>\/XI2\<1\>\/XI2\<1\>\/XI2\<1\>\/XI2\<1\>\/RR7 \
 (  \
 N_SEL5\<1\>_XI2\<0\>\/XI2\<0\>\/XI2\<1\>\/XI2\<1\>\/XI2\<1\>\/XI2\<1\>\/XI2\<1\>\/XI2\<1\>\/RR7_pos \
 N_WLSEL\<509\>_XI2\<0\>\/XI2\<0\>\/XI2\<1\>\/XI2\<1\>\/XI2\<1\>\/XI2\<1\>\/XI2\<1\>\/XI2\<1\>\/RR7_neg \
 ) R_1X_LL w=1e-07 l=1e-07   res=0.149966
XXI2\<0\>\/XI2\<0\>\/XI2\<1\>\/XI2\<1\>\/XI2\<1\>\/XI2\<1\>\/XI2\<1\>\/XI2\<1\>\/RR6 \
 (  \
 N_SEL6\<0\>_XI2\<0\>\/XI2\<0\>\/XI2\<1\>\/XI2\<1\>\/XI2\<1\>\/XI2\<1\>\/XI2\<1\>\/XI2\<1\>\/RR6_pos \
 N_WLSEL\<510\>_XI2\<0\>\/XI2\<0\>\/XI2\<1\>\/XI2\<1\>\/XI2\<1\>\/XI2\<1\>\/XI2\<1\>\/XI2\<1\>\/RR6_neg \
 ) R_1X_LL w=1e-07 l=1e-07   res=0.149966
XXI2\<0\>\/XI2\<0\>\/XI2\<1\>\/XI2\<1\>\/XI2\<1\>\/XI2\<1\>\/XI2\<1\>\/XI2\<1\>\/RR5 \
 (  \
 N_SEL7\<0\>_XI2\<0\>\/XI2\<0\>\/XI2\<1\>\/XI2\<1\>\/XI2\<1\>\/XI2\<1\>\/XI2\<1\>\/XI2\<1\>\/RR5_pos \
 N_WLSEL\<511\>_XI2\<0\>\/XI2\<0\>\/XI2\<1\>\/XI2\<1\>\/XI2\<1\>\/XI2\<1\>\/XI2\<1\>\/XI2\<1\>\/RR5_neg \
 ) R_1X_LL w=1e-07 l=1e-07   res=0.149966
XXI2\<1\>\/XI2\<1\>\/XI2\<1\>\/XI2\<0\>\/XI2\<1\>\/XI2\<0\>\/XI2\<1\>\/XI2\<1\>\/RR5 \
 (  \
 N_SEL7\<1\>_XI2\<1\>\/XI2\<1\>\/XI2\<1\>\/XI2\<0\>\/XI2\<1\>\/XI2\<0\>\/XI2\<1\>\/XI2\<1\>\/RR5_pos \
 N_WLSEL\<1887\>_XI2\<1\>\/XI2\<1\>\/XI2\<1\>\/XI2\<0\>\/XI2\<1\>\/XI2\<0\>\/XI2\<1\>\/XI2\<1\>\/RR5_neg \
 ) R_1X_LL w=1e-07 l=1e-07   res=0.149966
XXI2\<1\>\/XI2\<1\>\/XI2\<1\>\/XI2\<0\>\/XI2\<1\>\/XI2\<1\>\/XI2\<0\>\/XI2\<0\>\/RR0 \
 (  \
 N_SEL0\<0\>_XI2\<1\>\/XI2\<1\>\/XI2\<1\>\/XI2\<0\>\/XI2\<1\>\/XI2\<1\>\/XI2\<0\>\/XI2\<0\>\/RR0_pos \
 N_WLSEL\<1888\>_XI2\<1\>\/XI2\<1\>\/XI2\<1\>\/XI2\<0\>\/XI2\<1\>\/XI2\<1\>\/XI2\<0\>\/XI2\<0\>\/RR0_neg \
 ) R_1X_LL w=1e-07 l=1e-07   res=0.149966
XXI2\<1\>\/XI2\<1\>\/XI2\<1\>\/XI2\<0\>\/XI2\<1\>\/XI2\<1\>\/XI2\<0\>\/XI2\<0\>\/RR1 \
 (  \
 N_SEL1\<0\>_XI2\<1\>\/XI2\<1\>\/XI2\<1\>\/XI2\<0\>\/XI2\<1\>\/XI2\<1\>\/XI2\<0\>\/XI2\<0\>\/RR1_pos \
 N_WLSEL\<1889\>_XI2\<1\>\/XI2\<1\>\/XI2\<1\>\/XI2\<0\>\/XI2\<1\>\/XI2\<1\>\/XI2\<0\>\/XI2\<0\>\/RR1_neg \
 ) R_1X_LL w=1e-07 l=1e-07   res=0.149966
XXI2\<1\>\/XI2\<1\>\/XI2\<1\>\/XI2\<0\>\/XI2\<1\>\/XI2\<1\>\/XI2\<0\>\/XI2\<0\>\/RR2 \
 (  \
 N_SEL2\<1\>_XI2\<1\>\/XI2\<1\>\/XI2\<1\>\/XI2\<0\>\/XI2\<1\>\/XI2\<1\>\/XI2\<0\>\/XI2\<0\>\/RR2_pos \
 N_WLSEL\<1890\>_XI2\<1\>\/XI2\<1\>\/XI2\<1\>\/XI2\<0\>\/XI2\<1\>\/XI2\<1\>\/XI2\<0\>\/XI2\<0\>\/RR2_neg \
 ) R_1X_LL w=1e-07 l=1e-07   res=0.149966
XXI2\<1\>\/XI2\<1\>\/XI2\<1\>\/XI2\<0\>\/XI2\<1\>\/XI2\<1\>\/XI2\<0\>\/XI2\<0\>\/RR3 \
 (  \
 N_SEL3\<1\>_XI2\<1\>\/XI2\<1\>\/XI2\<1\>\/XI2\<0\>\/XI2\<1\>\/XI2\<1\>\/XI2\<0\>\/XI2\<0\>\/RR3_pos \
 N_WLSEL\<1891\>_XI2\<1\>\/XI2\<1\>\/XI2\<1\>\/XI2\<0\>\/XI2\<1\>\/XI2\<1\>\/XI2\<0\>\/XI2\<0\>\/RR3_neg \
 ) R_1X_LL w=1e-07 l=1e-07   res=0.149966
XXI2\<1\>\/XI2\<1\>\/XI2\<1\>\/XI2\<0\>\/XI2\<1\>\/XI2\<1\>\/XI2\<0\>\/XI2\<0\>\/RR4 \
 (  \
 N_SEL4\<0\>_XI2\<1\>\/XI2\<1\>\/XI2\<1\>\/XI2\<0\>\/XI2\<1\>\/XI2\<1\>\/XI2\<0\>\/XI2\<0\>\/RR4_pos \
 N_WLSEL\<1892\>_XI2\<1\>\/XI2\<1\>\/XI2\<1\>\/XI2\<0\>\/XI2\<1\>\/XI2\<1\>\/XI2\<0\>\/XI2\<0\>\/RR4_neg \
 ) R_1X_LL w=1e-07 l=1e-07   res=0.149966
XXI2\<1\>\/XI2\<1\>\/XI2\<1\>\/XI2\<0\>\/XI2\<1\>\/XI2\<1\>\/XI2\<0\>\/XI2\<0\>\/RR7 \
 (  \
 N_SEL5\<1\>_XI2\<1\>\/XI2\<1\>\/XI2\<1\>\/XI2\<0\>\/XI2\<1\>\/XI2\<1\>\/XI2\<0\>\/XI2\<0\>\/RR7_pos \
 N_WLSEL\<1893\>_XI2\<1\>\/XI2\<1\>\/XI2\<1\>\/XI2\<0\>\/XI2\<1\>\/XI2\<1\>\/XI2\<0\>\/XI2\<0\>\/RR7_neg \
 ) R_1X_LL w=1e-07 l=1e-07   res=0.149966
XXI2\<1\>\/XI2\<1\>\/XI2\<1\>\/XI2\<0\>\/XI2\<1\>\/XI2\<1\>\/XI2\<0\>\/XI2\<0\>\/RR6 \
 (  \
 N_SEL6\<1\>_XI2\<1\>\/XI2\<1\>\/XI2\<1\>\/XI2\<0\>\/XI2\<1\>\/XI2\<1\>\/XI2\<0\>\/XI2\<0\>\/RR6_pos \
 N_WLSEL\<1894\>_XI2\<1\>\/XI2\<1\>\/XI2\<1\>\/XI2\<0\>\/XI2\<1\>\/XI2\<1\>\/XI2\<0\>\/XI2\<0\>\/RR6_neg \
 ) R_1X_LL w=1e-07 l=1e-07   res=0.149966
XXI2\<1\>\/XI2\<1\>\/XI2\<1\>\/XI2\<0\>\/XI2\<1\>\/XI2\<1\>\/XI2\<0\>\/XI2\<0\>\/RR5 \
 (  \
 N_SEL7\<1\>_XI2\<1\>\/XI2\<1\>\/XI2\<1\>\/XI2\<0\>\/XI2\<1\>\/XI2\<1\>\/XI2\<0\>\/XI2\<0\>\/RR5_pos \
 N_WLSEL\<1895\>_XI2\<1\>\/XI2\<1\>\/XI2\<1\>\/XI2\<0\>\/XI2\<1\>\/XI2\<1\>\/XI2\<0\>\/XI2\<0\>\/RR5_neg \
 ) R_1X_LL w=1e-07 l=1e-07   res=0.149966
XXI2\<1\>\/XI2\<1\>\/XI2\<1\>\/XI2\<0\>\/XI2\<1\>\/XI2\<1\>\/XI2\<0\>\/XI2\<1\>\/RR0 \
 (  \
 N_SEL0\<1\>_XI2\<1\>\/XI2\<1\>\/XI2\<1\>\/XI2\<0\>\/XI2\<1\>\/XI2\<1\>\/XI2\<0\>\/XI2\<1\>\/RR0_pos \
 N_WLSEL\<1896\>_XI2\<1\>\/XI2\<1\>\/XI2\<1\>\/XI2\<0\>\/XI2\<1\>\/XI2\<1\>\/XI2\<0\>\/XI2\<1\>\/RR0_neg \
 ) R_1X_LL w=1e-07 l=1e-07   res=0.149966
XXI2\<1\>\/XI2\<1\>\/XI2\<1\>\/XI2\<0\>\/XI2\<1\>\/XI2\<1\>\/XI2\<0\>\/XI2\<1\>\/RR1 \
 (  \
 N_SEL1\<0\>_XI2\<1\>\/XI2\<1\>\/XI2\<1\>\/XI2\<0\>\/XI2\<1\>\/XI2\<1\>\/XI2\<0\>\/XI2\<1\>\/RR1_pos \
 N_WLSEL\<1897\>_XI2\<1\>\/XI2\<1\>\/XI2\<1\>\/XI2\<0\>\/XI2\<1\>\/XI2\<1\>\/XI2\<0\>\/XI2\<1\>\/RR1_neg \
 ) R_1X_LL w=1e-07 l=1e-07   res=0.149966
XXI2\<1\>\/XI2\<1\>\/XI2\<1\>\/XI2\<0\>\/XI2\<1\>\/XI2\<1\>\/XI2\<0\>\/XI2\<1\>\/RR2 \
 (  \
 N_SEL2\<1\>_XI2\<1\>\/XI2\<1\>\/XI2\<1\>\/XI2\<0\>\/XI2\<1\>\/XI2\<1\>\/XI2\<0\>\/XI2\<1\>\/RR2_pos \
 N_WLSEL\<1898\>_XI2\<1\>\/XI2\<1\>\/XI2\<1\>\/XI2\<0\>\/XI2\<1\>\/XI2\<1\>\/XI2\<0\>\/XI2\<1\>\/RR2_neg \
 ) R_1X_LL w=1e-07 l=1e-07   res=0.149966
XXI2\<1\>\/XI2\<1\>\/XI2\<1\>\/XI2\<0\>\/XI2\<1\>\/XI2\<1\>\/XI2\<0\>\/XI2\<1\>\/RR3 \
 (  \
 N_SEL3\<1\>_XI2\<1\>\/XI2\<1\>\/XI2\<1\>\/XI2\<0\>\/XI2\<1\>\/XI2\<1\>\/XI2\<0\>\/XI2\<1\>\/RR3_pos \
 N_WLSEL\<1899\>_XI2\<1\>\/XI2\<1\>\/XI2\<1\>\/XI2\<0\>\/XI2\<1\>\/XI2\<1\>\/XI2\<0\>\/XI2\<1\>\/RR3_neg \
 ) R_1X_LL w=1e-07 l=1e-07   res=0.149966
XXI2\<1\>\/XI2\<1\>\/XI2\<1\>\/XI2\<0\>\/XI2\<1\>\/XI2\<1\>\/XI2\<0\>\/XI2\<1\>\/RR4 \
 (  \
 N_SEL4\<0\>_XI2\<1\>\/XI2\<1\>\/XI2\<1\>\/XI2\<0\>\/XI2\<1\>\/XI2\<1\>\/XI2\<0\>\/XI2\<1\>\/RR4_pos \
 N_WLSEL\<1900\>_XI2\<1\>\/XI2\<1\>\/XI2\<1\>\/XI2\<0\>\/XI2\<1\>\/XI2\<1\>\/XI2\<0\>\/XI2\<1\>\/RR4_neg \
 ) R_1X_LL w=1e-07 l=1e-07   res=0.149966
XXI2\<1\>\/XI2\<1\>\/XI2\<1\>\/XI2\<0\>\/XI2\<1\>\/XI2\<1\>\/XI2\<0\>\/XI2\<1\>\/RR7 \
 (  \
 N_SEL5\<1\>_XI2\<1\>\/XI2\<1\>\/XI2\<1\>\/XI2\<0\>\/XI2\<1\>\/XI2\<1\>\/XI2\<0\>\/XI2\<1\>\/RR7_pos \
 N_WLSEL\<1901\>_XI2\<1\>\/XI2\<1\>\/XI2\<1\>\/XI2\<0\>\/XI2\<1\>\/XI2\<1\>\/XI2\<0\>\/XI2\<1\>\/RR7_neg \
 ) R_1X_LL w=1e-07 l=1e-07   res=0.149966
XXI2\<1\>\/XI2\<1\>\/XI2\<1\>\/XI2\<0\>\/XI2\<1\>\/XI2\<1\>\/XI2\<0\>\/XI2\<1\>\/RR6 \
 (  \
 N_SEL6\<1\>_XI2\<1\>\/XI2\<1\>\/XI2\<1\>\/XI2\<0\>\/XI2\<1\>\/XI2\<1\>\/XI2\<0\>\/XI2\<1\>\/RR6_pos \
 N_WLSEL\<1902\>_XI2\<1\>\/XI2\<1\>\/XI2\<1\>\/XI2\<0\>\/XI2\<1\>\/XI2\<1\>\/XI2\<0\>\/XI2\<1\>\/RR6_neg \
 ) R_1X_LL w=1e-07 l=1e-07   res=0.149966
XXI2\<1\>\/XI2\<1\>\/XI2\<1\>\/XI2\<0\>\/XI2\<1\>\/XI2\<1\>\/XI2\<0\>\/XI2\<1\>\/RR5 \
 (  \
 N_SEL7\<1\>_XI2\<1\>\/XI2\<1\>\/XI2\<1\>\/XI2\<0\>\/XI2\<1\>\/XI2\<1\>\/XI2\<0\>\/XI2\<1\>\/RR5_pos \
 N_WLSEL\<1903\>_XI2\<1\>\/XI2\<1\>\/XI2\<1\>\/XI2\<0\>\/XI2\<1\>\/XI2\<1\>\/XI2\<0\>\/XI2\<1\>\/RR5_neg \
 ) R_1X_LL w=1e-07 l=1e-07   res=0.149966
XXI2\<1\>\/XI2\<1\>\/XI2\<1\>\/XI2\<0\>\/XI2\<1\>\/XI2\<1\>\/XI2\<1\>\/XI2\<0\>\/RR0 \
 (  \
 N_SEL0\<0\>_XI2\<1\>\/XI2\<1\>\/XI2\<1\>\/XI2\<0\>\/XI2\<1\>\/XI2\<1\>\/XI2\<1\>\/XI2\<0\>\/RR0_pos \
 N_WLSEL\<1904\>_XI2\<1\>\/XI2\<1\>\/XI2\<1\>\/XI2\<0\>\/XI2\<1\>\/XI2\<1\>\/XI2\<1\>\/XI2\<0\>\/RR0_neg \
 ) R_1X_LL w=1e-07 l=1e-07   res=0.149966
XXI2\<1\>\/XI2\<1\>\/XI2\<1\>\/XI2\<0\>\/XI2\<1\>\/XI2\<1\>\/XI2\<1\>\/XI2\<0\>\/RR1 \
 (  \
 N_SEL1\<1\>_XI2\<1\>\/XI2\<1\>\/XI2\<1\>\/XI2\<0\>\/XI2\<1\>\/XI2\<1\>\/XI2\<1\>\/XI2\<0\>\/RR1_pos \
 N_WLSEL\<1905\>_XI2\<1\>\/XI2\<1\>\/XI2\<1\>\/XI2\<0\>\/XI2\<1\>\/XI2\<1\>\/XI2\<1\>\/XI2\<0\>\/RR1_neg \
 ) R_1X_LL w=1e-07 l=1e-07   res=0.149966
XXI2\<1\>\/XI2\<1\>\/XI2\<1\>\/XI2\<0\>\/XI2\<1\>\/XI2\<1\>\/XI2\<1\>\/XI2\<0\>\/RR2 \
 (  \
 N_SEL2\<1\>_XI2\<1\>\/XI2\<1\>\/XI2\<1\>\/XI2\<0\>\/XI2\<1\>\/XI2\<1\>\/XI2\<1\>\/XI2\<0\>\/RR2_pos \
 N_WLSEL\<1906\>_XI2\<1\>\/XI2\<1\>\/XI2\<1\>\/XI2\<0\>\/XI2\<1\>\/XI2\<1\>\/XI2\<1\>\/XI2\<0\>\/RR2_neg \
 ) R_1X_LL w=1e-07 l=1e-07   res=0.149966
XXI2\<1\>\/XI2\<1\>\/XI2\<1\>\/XI2\<0\>\/XI2\<1\>\/XI2\<1\>\/XI2\<1\>\/XI2\<0\>\/RR3 \
 (  \
 N_SEL3\<1\>_XI2\<1\>\/XI2\<1\>\/XI2\<1\>\/XI2\<0\>\/XI2\<1\>\/XI2\<1\>\/XI2\<1\>\/XI2\<0\>\/RR3_pos \
 N_WLSEL\<1907\>_XI2\<1\>\/XI2\<1\>\/XI2\<1\>\/XI2\<0\>\/XI2\<1\>\/XI2\<1\>\/XI2\<1\>\/XI2\<0\>\/RR3_neg \
 ) R_1X_LL w=1e-07 l=1e-07   res=0.149966
XXI2\<1\>\/XI2\<1\>\/XI2\<1\>\/XI2\<0\>\/XI2\<1\>\/XI2\<1\>\/XI2\<1\>\/XI2\<0\>\/RR4 \
 (  \
 N_SEL4\<0\>_XI2\<1\>\/XI2\<1\>\/XI2\<1\>\/XI2\<0\>\/XI2\<1\>\/XI2\<1\>\/XI2\<1\>\/XI2\<0\>\/RR4_pos \
 N_WLSEL\<1908\>_XI2\<1\>\/XI2\<1\>\/XI2\<1\>\/XI2\<0\>\/XI2\<1\>\/XI2\<1\>\/XI2\<1\>\/XI2\<0\>\/RR4_neg \
 ) R_1X_LL w=1e-07 l=1e-07   res=0.149966
XXI2\<1\>\/XI2\<1\>\/XI2\<1\>\/XI2\<0\>\/XI2\<1\>\/XI2\<1\>\/XI2\<1\>\/XI2\<0\>\/RR7 \
 (  \
 N_SEL5\<1\>_XI2\<1\>\/XI2\<1\>\/XI2\<1\>\/XI2\<0\>\/XI2\<1\>\/XI2\<1\>\/XI2\<1\>\/XI2\<0\>\/RR7_pos \
 N_WLSEL\<1909\>_XI2\<1\>\/XI2\<1\>\/XI2\<1\>\/XI2\<0\>\/XI2\<1\>\/XI2\<1\>\/XI2\<1\>\/XI2\<0\>\/RR7_neg \
 ) R_1X_LL w=1e-07 l=1e-07   res=0.149966
XXI2\<1\>\/XI2\<1\>\/XI2\<1\>\/XI2\<0\>\/XI2\<1\>\/XI2\<1\>\/XI2\<1\>\/XI2\<0\>\/RR6 \
 (  \
 N_SEL6\<1\>_XI2\<1\>\/XI2\<1\>\/XI2\<1\>\/XI2\<0\>\/XI2\<1\>\/XI2\<1\>\/XI2\<1\>\/XI2\<0\>\/RR6_pos \
 N_WLSEL\<1910\>_XI2\<1\>\/XI2\<1\>\/XI2\<1\>\/XI2\<0\>\/XI2\<1\>\/XI2\<1\>\/XI2\<1\>\/XI2\<0\>\/RR6_neg \
 ) R_1X_LL w=1e-07 l=1e-07   res=0.149966
XXI2\<1\>\/XI2\<1\>\/XI2\<1\>\/XI2\<0\>\/XI2\<1\>\/XI2\<1\>\/XI2\<1\>\/XI2\<0\>\/RR5 \
 (  \
 N_SEL7\<1\>_XI2\<1\>\/XI2\<1\>\/XI2\<1\>\/XI2\<0\>\/XI2\<1\>\/XI2\<1\>\/XI2\<1\>\/XI2\<0\>\/RR5_pos \
 N_WLSEL\<1911\>_XI2\<1\>\/XI2\<1\>\/XI2\<1\>\/XI2\<0\>\/XI2\<1\>\/XI2\<1\>\/XI2\<1\>\/XI2\<0\>\/RR5_neg \
 ) R_1X_LL w=1e-07 l=1e-07   res=0.149966
XXI2\<1\>\/XI2\<1\>\/XI2\<1\>\/XI2\<0\>\/XI2\<1\>\/XI2\<1\>\/XI2\<1\>\/XI2\<1\>\/RR0 \
 (  \
 N_SEL0\<1\>_XI2\<1\>\/XI2\<1\>\/XI2\<1\>\/XI2\<0\>\/XI2\<1\>\/XI2\<1\>\/XI2\<1\>\/XI2\<1\>\/RR0_pos \
 N_WLSEL\<1912\>_XI2\<1\>\/XI2\<1\>\/XI2\<1\>\/XI2\<0\>\/XI2\<1\>\/XI2\<1\>\/XI2\<1\>\/XI2\<1\>\/RR0_neg \
 ) R_1X_LL w=1e-07 l=1e-07   res=0.149966
XXI2\<1\>\/XI2\<1\>\/XI2\<1\>\/XI2\<0\>\/XI2\<1\>\/XI2\<1\>\/XI2\<1\>\/XI2\<1\>\/RR1 \
 (  \
 N_SEL1\<1\>_XI2\<1\>\/XI2\<1\>\/XI2\<1\>\/XI2\<0\>\/XI2\<1\>\/XI2\<1\>\/XI2\<1\>\/XI2\<1\>\/RR1_pos \
 N_WLSEL\<1913\>_XI2\<1\>\/XI2\<1\>\/XI2\<1\>\/XI2\<0\>\/XI2\<1\>\/XI2\<1\>\/XI2\<1\>\/XI2\<1\>\/RR1_neg \
 ) R_1X_LL w=1e-07 l=1e-07   res=0.149966
XXI2\<1\>\/XI2\<1\>\/XI2\<1\>\/XI2\<0\>\/XI2\<1\>\/XI2\<1\>\/XI2\<1\>\/XI2\<1\>\/RR2 \
 (  \
 N_SEL2\<1\>_XI2\<1\>\/XI2\<1\>\/XI2\<1\>\/XI2\<0\>\/XI2\<1\>\/XI2\<1\>\/XI2\<1\>\/XI2\<1\>\/RR2_pos \
 N_WLSEL\<1914\>_XI2\<1\>\/XI2\<1\>\/XI2\<1\>\/XI2\<0\>\/XI2\<1\>\/XI2\<1\>\/XI2\<1\>\/XI2\<1\>\/RR2_neg \
 ) R_1X_LL w=1e-07 l=1e-07   res=0.149966
XXI2\<1\>\/XI2\<1\>\/XI2\<1\>\/XI2\<0\>\/XI2\<1\>\/XI2\<1\>\/XI2\<1\>\/XI2\<1\>\/RR3 \
 (  \
 N_SEL3\<1\>_XI2\<1\>\/XI2\<1\>\/XI2\<1\>\/XI2\<0\>\/XI2\<1\>\/XI2\<1\>\/XI2\<1\>\/XI2\<1\>\/RR3_pos \
 N_WLSEL\<1915\>_XI2\<1\>\/XI2\<1\>\/XI2\<1\>\/XI2\<0\>\/XI2\<1\>\/XI2\<1\>\/XI2\<1\>\/XI2\<1\>\/RR3_neg \
 ) R_1X_LL w=1e-07 l=1e-07   res=0.149966
XXI2\<1\>\/XI2\<1\>\/XI2\<1\>\/XI2\<0\>\/XI2\<1\>\/XI2\<1\>\/XI2\<1\>\/XI2\<1\>\/RR4 \
 (  \
 N_SEL4\<0\>_XI2\<1\>\/XI2\<1\>\/XI2\<1\>\/XI2\<0\>\/XI2\<1\>\/XI2\<1\>\/XI2\<1\>\/XI2\<1\>\/RR4_pos \
 N_WLSEL\<1916\>_XI2\<1\>\/XI2\<1\>\/XI2\<1\>\/XI2\<0\>\/XI2\<1\>\/XI2\<1\>\/XI2\<1\>\/XI2\<1\>\/RR4_neg \
 ) R_1X_LL w=1e-07 l=1e-07   res=0.149966
XXI2\<1\>\/XI2\<1\>\/XI2\<1\>\/XI2\<0\>\/XI2\<1\>\/XI2\<1\>\/XI2\<1\>\/XI2\<1\>\/RR7 \
 (  \
 N_SEL5\<1\>_XI2\<1\>\/XI2\<1\>\/XI2\<1\>\/XI2\<0\>\/XI2\<1\>\/XI2\<1\>\/XI2\<1\>\/XI2\<1\>\/RR7_pos \
 N_WLSEL\<1917\>_XI2\<1\>\/XI2\<1\>\/XI2\<1\>\/XI2\<0\>\/XI2\<1\>\/XI2\<1\>\/XI2\<1\>\/XI2\<1\>\/RR7_neg \
 ) R_1X_LL w=1e-07 l=1e-07   res=0.149966
XXI2\<1\>\/XI2\<1\>\/XI2\<1\>\/XI2\<0\>\/XI2\<1\>\/XI2\<1\>\/XI2\<1\>\/XI2\<1\>\/RR6 \
 (  \
 N_SEL6\<1\>_XI2\<1\>\/XI2\<1\>\/XI2\<1\>\/XI2\<0\>\/XI2\<1\>\/XI2\<1\>\/XI2\<1\>\/XI2\<1\>\/RR6_pos \
 N_WLSEL\<1918\>_XI2\<1\>\/XI2\<1\>\/XI2\<1\>\/XI2\<0\>\/XI2\<1\>\/XI2\<1\>\/XI2\<1\>\/XI2\<1\>\/RR6_neg \
 ) R_1X_LL w=1e-07 l=1e-07   res=0.149966
XXI2\<1\>\/XI2\<1\>\/XI2\<1\>\/XI2\<0\>\/XI2\<1\>\/XI2\<1\>\/XI2\<1\>\/XI2\<1\>\/RR5 \
 (  \
 N_SEL7\<1\>_XI2\<1\>\/XI2\<1\>\/XI2\<1\>\/XI2\<0\>\/XI2\<1\>\/XI2\<1\>\/XI2\<1\>\/XI2\<1\>\/RR5_pos \
 N_WLSEL\<1919\>_XI2\<1\>\/XI2\<1\>\/XI2\<1\>\/XI2\<0\>\/XI2\<1\>\/XI2\<1\>\/XI2\<1\>\/XI2\<1\>\/RR5_neg \
 ) R_1X_LL w=1e-07 l=1e-07   res=0.149966
XXI2\<1\>\/XI2\<1\>\/XI2\<1\>\/XI2\<1\>\/XI2\<0\>\/XI2\<0\>\/XI2\<0\>\/XI2\<0\>\/RR0 \
 (  \
 N_SEL0\<0\>_XI2\<1\>\/XI2\<1\>\/XI2\<1\>\/XI2\<1\>\/XI2\<0\>\/XI2\<0\>\/XI2\<0\>\/XI2\<0\>\/RR0_pos \
 N_WLSEL\<1920\>_XI2\<1\>\/XI2\<1\>\/XI2\<1\>\/XI2\<1\>\/XI2\<0\>\/XI2\<0\>\/XI2\<0\>\/XI2\<0\>\/RR0_neg \
 ) R_1X_LL w=1e-07 l=1e-07   res=0.149966
XXI2\<1\>\/XI2\<1\>\/XI2\<1\>\/XI2\<1\>\/XI2\<0\>\/XI2\<0\>\/XI2\<0\>\/XI2\<0\>\/RR1 \
 (  \
 N_SEL1\<0\>_XI2\<1\>\/XI2\<1\>\/XI2\<1\>\/XI2\<1\>\/XI2\<0\>\/XI2\<0\>\/XI2\<0\>\/XI2\<0\>\/RR1_pos \
 N_WLSEL\<1921\>_XI2\<1\>\/XI2\<1\>\/XI2\<1\>\/XI2\<1\>\/XI2\<0\>\/XI2\<0\>\/XI2\<0\>\/XI2\<0\>\/RR1_neg \
 ) R_1X_LL w=1e-07 l=1e-07   res=0.149966
XXI2\<1\>\/XI2\<1\>\/XI2\<1\>\/XI2\<1\>\/XI2\<0\>\/XI2\<0\>\/XI2\<0\>\/XI2\<0\>\/RR2 \
 (  \
 N_SEL2\<0\>_XI2\<1\>\/XI2\<1\>\/XI2\<1\>\/XI2\<1\>\/XI2\<0\>\/XI2\<0\>\/XI2\<0\>\/XI2\<0\>\/RR2_pos \
 N_WLSEL\<1922\>_XI2\<1\>\/XI2\<1\>\/XI2\<1\>\/XI2\<1\>\/XI2\<0\>\/XI2\<0\>\/XI2\<0\>\/XI2\<0\>\/RR2_neg \
 ) R_1X_LL w=1e-07 l=1e-07   res=0.149966
XXI2\<1\>\/XI2\<1\>\/XI2\<1\>\/XI2\<1\>\/XI2\<0\>\/XI2\<0\>\/XI2\<0\>\/XI2\<0\>\/RR3 \
 (  \
 N_SEL3\<0\>_XI2\<1\>\/XI2\<1\>\/XI2\<1\>\/XI2\<1\>\/XI2\<0\>\/XI2\<0\>\/XI2\<0\>\/XI2\<0\>\/RR3_pos \
 N_WLSEL\<1923\>_XI2\<1\>\/XI2\<1\>\/XI2\<1\>\/XI2\<1\>\/XI2\<0\>\/XI2\<0\>\/XI2\<0\>\/XI2\<0\>\/RR3_neg \
 ) R_1X_LL w=1e-07 l=1e-07   res=0.149966
XXI2\<1\>\/XI2\<1\>\/XI2\<1\>\/XI2\<1\>\/XI2\<0\>\/XI2\<0\>\/XI2\<0\>\/XI2\<0\>\/RR4 \
 (  \
 N_SEL4\<1\>_XI2\<1\>\/XI2\<1\>\/XI2\<1\>\/XI2\<1\>\/XI2\<0\>\/XI2\<0\>\/XI2\<0\>\/XI2\<0\>\/RR4_pos \
 N_WLSEL\<1924\>_XI2\<1\>\/XI2\<1\>\/XI2\<1\>\/XI2\<1\>\/XI2\<0\>\/XI2\<0\>\/XI2\<0\>\/XI2\<0\>\/RR4_neg \
 ) R_1X_LL w=1e-07 l=1e-07   res=0.149966
XXI2\<1\>\/XI2\<1\>\/XI2\<1\>\/XI2\<1\>\/XI2\<0\>\/XI2\<0\>\/XI2\<0\>\/XI2\<0\>\/RR7 \
 (  \
 N_SEL5\<1\>_XI2\<1\>\/XI2\<1\>\/XI2\<1\>\/XI2\<1\>\/XI2\<0\>\/XI2\<0\>\/XI2\<0\>\/XI2\<0\>\/RR7_pos \
 N_WLSEL\<1925\>_XI2\<1\>\/XI2\<1\>\/XI2\<1\>\/XI2\<1\>\/XI2\<0\>\/XI2\<0\>\/XI2\<0\>\/XI2\<0\>\/RR7_neg \
 ) R_1X_LL w=1e-07 l=1e-07   res=0.149966
XXI2\<1\>\/XI2\<1\>\/XI2\<1\>\/XI2\<1\>\/XI2\<0\>\/XI2\<0\>\/XI2\<0\>\/XI2\<0\>\/RR6 \
 (  \
 N_SEL6\<1\>_XI2\<1\>\/XI2\<1\>\/XI2\<1\>\/XI2\<1\>\/XI2\<0\>\/XI2\<0\>\/XI2\<0\>\/XI2\<0\>\/RR6_pos \
 N_WLSEL\<1926\>_XI2\<1\>\/XI2\<1\>\/XI2\<1\>\/XI2\<1\>\/XI2\<0\>\/XI2\<0\>\/XI2\<0\>\/XI2\<0\>\/RR6_neg \
 ) R_1X_LL w=1e-07 l=1e-07   res=0.149966
XXI2\<1\>\/XI2\<1\>\/XI2\<1\>\/XI2\<1\>\/XI2\<0\>\/XI2\<0\>\/XI2\<0\>\/XI2\<0\>\/RR5 \
 (  \
 N_SEL7\<1\>_XI2\<1\>\/XI2\<1\>\/XI2\<1\>\/XI2\<1\>\/XI2\<0\>\/XI2\<0\>\/XI2\<0\>\/XI2\<0\>\/RR5_pos \
 N_WLSEL\<1927\>_XI2\<1\>\/XI2\<1\>\/XI2\<1\>\/XI2\<1\>\/XI2\<0\>\/XI2\<0\>\/XI2\<0\>\/XI2\<0\>\/RR5_neg \
 ) R_1X_LL w=1e-07 l=1e-07   res=0.149966
XXI2\<1\>\/XI2\<1\>\/XI2\<1\>\/XI2\<1\>\/XI2\<0\>\/XI2\<0\>\/XI2\<0\>\/XI2\<1\>\/RR0 \
 (  \
 N_SEL0\<1\>_XI2\<1\>\/XI2\<1\>\/XI2\<1\>\/XI2\<1\>\/XI2\<0\>\/XI2\<0\>\/XI2\<0\>\/XI2\<1\>\/RR0_pos \
 N_WLSEL\<1928\>_XI2\<1\>\/XI2\<1\>\/XI2\<1\>\/XI2\<1\>\/XI2\<0\>\/XI2\<0\>\/XI2\<0\>\/XI2\<1\>\/RR0_neg \
 ) R_1X_LL w=1e-07 l=1e-07   res=0.149966
XXI2\<1\>\/XI2\<1\>\/XI2\<1\>\/XI2\<1\>\/XI2\<0\>\/XI2\<0\>\/XI2\<0\>\/XI2\<1\>\/RR1 \
 (  \
 N_SEL1\<0\>_XI2\<1\>\/XI2\<1\>\/XI2\<1\>\/XI2\<1\>\/XI2\<0\>\/XI2\<0\>\/XI2\<0\>\/XI2\<1\>\/RR1_pos \
 N_WLSEL\<1929\>_XI2\<1\>\/XI2\<1\>\/XI2\<1\>\/XI2\<1\>\/XI2\<0\>\/XI2\<0\>\/XI2\<0\>\/XI2\<1\>\/RR1_neg \
 ) R_1X_LL w=1e-07 l=1e-07   res=0.149966
XXI2\<1\>\/XI2\<1\>\/XI2\<1\>\/XI2\<1\>\/XI2\<0\>\/XI2\<0\>\/XI2\<0\>\/XI2\<1\>\/RR2 \
 (  \
 N_SEL2\<0\>_XI2\<1\>\/XI2\<1\>\/XI2\<1\>\/XI2\<1\>\/XI2\<0\>\/XI2\<0\>\/XI2\<0\>\/XI2\<1\>\/RR2_pos \
 N_WLSEL\<1930\>_XI2\<1\>\/XI2\<1\>\/XI2\<1\>\/XI2\<1\>\/XI2\<0\>\/XI2\<0\>\/XI2\<0\>\/XI2\<1\>\/RR2_neg \
 ) R_1X_LL w=1e-07 l=1e-07   res=0.149966
XXI2\<1\>\/XI2\<1\>\/XI2\<1\>\/XI2\<1\>\/XI2\<0\>\/XI2\<0\>\/XI2\<0\>\/XI2\<1\>\/RR3 \
 (  \
 N_SEL3\<0\>_XI2\<1\>\/XI2\<1\>\/XI2\<1\>\/XI2\<1\>\/XI2\<0\>\/XI2\<0\>\/XI2\<0\>\/XI2\<1\>\/RR3_pos \
 N_WLSEL\<1931\>_XI2\<1\>\/XI2\<1\>\/XI2\<1\>\/XI2\<1\>\/XI2\<0\>\/XI2\<0\>\/XI2\<0\>\/XI2\<1\>\/RR3_neg \
 ) R_1X_LL w=1e-07 l=1e-07   res=0.149966
XXI2\<1\>\/XI2\<1\>\/XI2\<1\>\/XI2\<1\>\/XI2\<0\>\/XI2\<0\>\/XI2\<0\>\/XI2\<1\>\/RR4 \
 (  \
 N_SEL4\<1\>_XI2\<1\>\/XI2\<1\>\/XI2\<1\>\/XI2\<1\>\/XI2\<0\>\/XI2\<0\>\/XI2\<0\>\/XI2\<1\>\/RR4_pos \
 N_WLSEL\<1932\>_XI2\<1\>\/XI2\<1\>\/XI2\<1\>\/XI2\<1\>\/XI2\<0\>\/XI2\<0\>\/XI2\<0\>\/XI2\<1\>\/RR4_neg \
 ) R_1X_LL w=1e-07 l=1e-07   res=0.149966
XXI2\<1\>\/XI2\<1\>\/XI2\<1\>\/XI2\<1\>\/XI2\<0\>\/XI2\<0\>\/XI2\<0\>\/XI2\<1\>\/RR7 \
 (  \
 N_SEL5\<1\>_XI2\<1\>\/XI2\<1\>\/XI2\<1\>\/XI2\<1\>\/XI2\<0\>\/XI2\<0\>\/XI2\<0\>\/XI2\<1\>\/RR7_pos \
 N_WLSEL\<1933\>_XI2\<1\>\/XI2\<1\>\/XI2\<1\>\/XI2\<1\>\/XI2\<0\>\/XI2\<0\>\/XI2\<0\>\/XI2\<1\>\/RR7_neg \
 ) R_1X_LL w=1e-07 l=1e-07   res=0.149966
XXI2\<1\>\/XI2\<1\>\/XI2\<1\>\/XI2\<1\>\/XI2\<0\>\/XI2\<0\>\/XI2\<0\>\/XI2\<1\>\/RR6 \
 (  \
 N_SEL6\<1\>_XI2\<1\>\/XI2\<1\>\/XI2\<1\>\/XI2\<1\>\/XI2\<0\>\/XI2\<0\>\/XI2\<0\>\/XI2\<1\>\/RR6_pos \
 N_WLSEL\<1934\>_XI2\<1\>\/XI2\<1\>\/XI2\<1\>\/XI2\<1\>\/XI2\<0\>\/XI2\<0\>\/XI2\<0\>\/XI2\<1\>\/RR6_neg \
 ) R_1X_LL w=1e-07 l=1e-07   res=0.149966
XXI2\<1\>\/XI2\<1\>\/XI2\<1\>\/XI2\<1\>\/XI2\<0\>\/XI2\<0\>\/XI2\<0\>\/XI2\<1\>\/RR5 \
 (  \
 N_SEL7\<1\>_XI2\<1\>\/XI2\<1\>\/XI2\<1\>\/XI2\<1\>\/XI2\<0\>\/XI2\<0\>\/XI2\<0\>\/XI2\<1\>\/RR5_pos \
 N_WLSEL\<1935\>_XI2\<1\>\/XI2\<1\>\/XI2\<1\>\/XI2\<1\>\/XI2\<0\>\/XI2\<0\>\/XI2\<0\>\/XI2\<1\>\/RR5_neg \
 ) R_1X_LL w=1e-07 l=1e-07   res=0.149966
XXI2\<1\>\/XI2\<1\>\/XI2\<1\>\/XI2\<1\>\/XI2\<0\>\/XI2\<0\>\/XI2\<1\>\/XI2\<0\>\/RR0 \
 (  \
 N_SEL0\<0\>_XI2\<1\>\/XI2\<1\>\/XI2\<1\>\/XI2\<1\>\/XI2\<0\>\/XI2\<0\>\/XI2\<1\>\/XI2\<0\>\/RR0_pos \
 N_WLSEL\<1936\>_XI2\<1\>\/XI2\<1\>\/XI2\<1\>\/XI2\<1\>\/XI2\<0\>\/XI2\<0\>\/XI2\<1\>\/XI2\<0\>\/RR0_neg \
 ) R_1X_LL w=1e-07 l=1e-07   res=0.149966
XXI2\<1\>\/XI2\<1\>\/XI2\<1\>\/XI2\<1\>\/XI2\<0\>\/XI2\<0\>\/XI2\<1\>\/XI2\<0\>\/RR1 \
 (  \
 N_SEL1\<1\>_XI2\<1\>\/XI2\<1\>\/XI2\<1\>\/XI2\<1\>\/XI2\<0\>\/XI2\<0\>\/XI2\<1\>\/XI2\<0\>\/RR1_pos \
 N_WLSEL\<1937\>_XI2\<1\>\/XI2\<1\>\/XI2\<1\>\/XI2\<1\>\/XI2\<0\>\/XI2\<0\>\/XI2\<1\>\/XI2\<0\>\/RR1_neg \
 ) R_1X_LL w=1e-07 l=1e-07   res=0.149966
XXI2\<1\>\/XI2\<1\>\/XI2\<1\>\/XI2\<1\>\/XI2\<0\>\/XI2\<0\>\/XI2\<1\>\/XI2\<0\>\/RR2 \
 (  \
 N_SEL2\<0\>_XI2\<1\>\/XI2\<1\>\/XI2\<1\>\/XI2\<1\>\/XI2\<0\>\/XI2\<0\>\/XI2\<1\>\/XI2\<0\>\/RR2_pos \
 N_WLSEL\<1938\>_XI2\<1\>\/XI2\<1\>\/XI2\<1\>\/XI2\<1\>\/XI2\<0\>\/XI2\<0\>\/XI2\<1\>\/XI2\<0\>\/RR2_neg \
 ) R_1X_LL w=1e-07 l=1e-07   res=0.149966
XXI2\<1\>\/XI2\<1\>\/XI2\<1\>\/XI2\<1\>\/XI2\<0\>\/XI2\<0\>\/XI2\<1\>\/XI2\<0\>\/RR3 \
 (  \
 N_SEL3\<0\>_XI2\<1\>\/XI2\<1\>\/XI2\<1\>\/XI2\<1\>\/XI2\<0\>\/XI2\<0\>\/XI2\<1\>\/XI2\<0\>\/RR3_pos \
 N_WLSEL\<1939\>_XI2\<1\>\/XI2\<1\>\/XI2\<1\>\/XI2\<1\>\/XI2\<0\>\/XI2\<0\>\/XI2\<1\>\/XI2\<0\>\/RR3_neg \
 ) R_1X_LL w=1e-07 l=1e-07   res=0.149966
XXI2\<1\>\/XI2\<1\>\/XI2\<1\>\/XI2\<1\>\/XI2\<0\>\/XI2\<0\>\/XI2\<1\>\/XI2\<0\>\/RR4 \
 (  \
 N_SEL4\<1\>_XI2\<1\>\/XI2\<1\>\/XI2\<1\>\/XI2\<1\>\/XI2\<0\>\/XI2\<0\>\/XI2\<1\>\/XI2\<0\>\/RR4_pos \
 N_WLSEL\<1940\>_XI2\<1\>\/XI2\<1\>\/XI2\<1\>\/XI2\<1\>\/XI2\<0\>\/XI2\<0\>\/XI2\<1\>\/XI2\<0\>\/RR4_neg \
 ) R_1X_LL w=1e-07 l=1e-07   res=0.149966
XXI2\<1\>\/XI2\<1\>\/XI2\<1\>\/XI2\<1\>\/XI2\<0\>\/XI2\<0\>\/XI2\<1\>\/XI2\<0\>\/RR7 \
 (  \
 N_SEL5\<1\>_XI2\<1\>\/XI2\<1\>\/XI2\<1\>\/XI2\<1\>\/XI2\<0\>\/XI2\<0\>\/XI2\<1\>\/XI2\<0\>\/RR7_pos \
 N_WLSEL\<1941\>_XI2\<1\>\/XI2\<1\>\/XI2\<1\>\/XI2\<1\>\/XI2\<0\>\/XI2\<0\>\/XI2\<1\>\/XI2\<0\>\/RR7_neg \
 ) R_1X_LL w=1e-07 l=1e-07   res=0.149966
XXI2\<1\>\/XI2\<1\>\/XI2\<1\>\/XI2\<1\>\/XI2\<0\>\/XI2\<0\>\/XI2\<1\>\/XI2\<0\>\/RR6 \
 (  \
 N_SEL6\<1\>_XI2\<1\>\/XI2\<1\>\/XI2\<1\>\/XI2\<1\>\/XI2\<0\>\/XI2\<0\>\/XI2\<1\>\/XI2\<0\>\/RR6_pos \
 N_WLSEL\<1942\>_XI2\<1\>\/XI2\<1\>\/XI2\<1\>\/XI2\<1\>\/XI2\<0\>\/XI2\<0\>\/XI2\<1\>\/XI2\<0\>\/RR6_neg \
 ) R_1X_LL w=1e-07 l=1e-07   res=0.149966
XXI2\<1\>\/XI2\<1\>\/XI2\<1\>\/XI2\<1\>\/XI2\<0\>\/XI2\<0\>\/XI2\<1\>\/XI2\<0\>\/RR5 \
 (  \
 N_SEL7\<1\>_XI2\<1\>\/XI2\<1\>\/XI2\<1\>\/XI2\<1\>\/XI2\<0\>\/XI2\<0\>\/XI2\<1\>\/XI2\<0\>\/RR5_pos \
 N_WLSEL\<1943\>_XI2\<1\>\/XI2\<1\>\/XI2\<1\>\/XI2\<1\>\/XI2\<0\>\/XI2\<0\>\/XI2\<1\>\/XI2\<0\>\/RR5_neg \
 ) R_1X_LL w=1e-07 l=1e-07   res=0.149966
XXI2\<1\>\/XI2\<1\>\/XI2\<1\>\/XI2\<1\>\/XI2\<0\>\/XI2\<0\>\/XI2\<1\>\/XI2\<1\>\/RR0 \
 (  \
 N_SEL0\<1\>_XI2\<1\>\/XI2\<1\>\/XI2\<1\>\/XI2\<1\>\/XI2\<0\>\/XI2\<0\>\/XI2\<1\>\/XI2\<1\>\/RR0_pos \
 N_WLSEL\<1944\>_XI2\<1\>\/XI2\<1\>\/XI2\<1\>\/XI2\<1\>\/XI2\<0\>\/XI2\<0\>\/XI2\<1\>\/XI2\<1\>\/RR0_neg \
 ) R_1X_LL w=1e-07 l=1e-07   res=0.149966
XXI2\<1\>\/XI2\<1\>\/XI2\<1\>\/XI2\<1\>\/XI2\<0\>\/XI2\<0\>\/XI2\<1\>\/XI2\<1\>\/RR1 \
 (  \
 N_SEL1\<1\>_XI2\<1\>\/XI2\<1\>\/XI2\<1\>\/XI2\<1\>\/XI2\<0\>\/XI2\<0\>\/XI2\<1\>\/XI2\<1\>\/RR1_pos \
 N_WLSEL\<1945\>_XI2\<1\>\/XI2\<1\>\/XI2\<1\>\/XI2\<1\>\/XI2\<0\>\/XI2\<0\>\/XI2\<1\>\/XI2\<1\>\/RR1_neg \
 ) R_1X_LL w=1e-07 l=1e-07   res=0.149966
XXI2\<1\>\/XI2\<1\>\/XI2\<1\>\/XI2\<1\>\/XI2\<0\>\/XI2\<0\>\/XI2\<1\>\/XI2\<1\>\/RR2 \
 (  \
 N_SEL2\<0\>_XI2\<1\>\/XI2\<1\>\/XI2\<1\>\/XI2\<1\>\/XI2\<0\>\/XI2\<0\>\/XI2\<1\>\/XI2\<1\>\/RR2_pos \
 N_WLSEL\<1946\>_XI2\<1\>\/XI2\<1\>\/XI2\<1\>\/XI2\<1\>\/XI2\<0\>\/XI2\<0\>\/XI2\<1\>\/XI2\<1\>\/RR2_neg \
 ) R_1X_LL w=1e-07 l=1e-07   res=0.149966
XXI2\<1\>\/XI2\<1\>\/XI2\<1\>\/XI2\<1\>\/XI2\<0\>\/XI2\<0\>\/XI2\<1\>\/XI2\<1\>\/RR3 \
 (  \
 N_SEL3\<0\>_XI2\<1\>\/XI2\<1\>\/XI2\<1\>\/XI2\<1\>\/XI2\<0\>\/XI2\<0\>\/XI2\<1\>\/XI2\<1\>\/RR3_pos \
 N_WLSEL\<1947\>_XI2\<1\>\/XI2\<1\>\/XI2\<1\>\/XI2\<1\>\/XI2\<0\>\/XI2\<0\>\/XI2\<1\>\/XI2\<1\>\/RR3_neg \
 ) R_1X_LL w=1e-07 l=1e-07   res=0.149966
XXI2\<1\>\/XI2\<1\>\/XI2\<1\>\/XI2\<1\>\/XI2\<0\>\/XI2\<0\>\/XI2\<1\>\/XI2\<1\>\/RR4 \
 (  \
 N_SEL4\<1\>_XI2\<1\>\/XI2\<1\>\/XI2\<1\>\/XI2\<1\>\/XI2\<0\>\/XI2\<0\>\/XI2\<1\>\/XI2\<1\>\/RR4_pos \
 N_WLSEL\<1948\>_XI2\<1\>\/XI2\<1\>\/XI2\<1\>\/XI2\<1\>\/XI2\<0\>\/XI2\<0\>\/XI2\<1\>\/XI2\<1\>\/RR4_neg \
 ) R_1X_LL w=1e-07 l=1e-07   res=0.149966
XXI2\<1\>\/XI2\<1\>\/XI2\<1\>\/XI2\<1\>\/XI2\<0\>\/XI2\<0\>\/XI2\<1\>\/XI2\<1\>\/RR7 \
 (  \
 N_SEL5\<1\>_XI2\<1\>\/XI2\<1\>\/XI2\<1\>\/XI2\<1\>\/XI2\<0\>\/XI2\<0\>\/XI2\<1\>\/XI2\<1\>\/RR7_pos \
 N_WLSEL\<1949\>_XI2\<1\>\/XI2\<1\>\/XI2\<1\>\/XI2\<1\>\/XI2\<0\>\/XI2\<0\>\/XI2\<1\>\/XI2\<1\>\/RR7_neg \
 ) R_1X_LL w=1e-07 l=1e-07   res=0.149966
XXI2\<1\>\/XI2\<1\>\/XI2\<1\>\/XI2\<1\>\/XI2\<0\>\/XI2\<0\>\/XI2\<1\>\/XI2\<1\>\/RR6 \
 (  \
 N_SEL6\<1\>_XI2\<1\>\/XI2\<1\>\/XI2\<1\>\/XI2\<1\>\/XI2\<0\>\/XI2\<0\>\/XI2\<1\>\/XI2\<1\>\/RR6_pos \
 N_WLSEL\<1950\>_XI2\<1\>\/XI2\<1\>\/XI2\<1\>\/XI2\<1\>\/XI2\<0\>\/XI2\<0\>\/XI2\<1\>\/XI2\<1\>\/RR6_neg \
 ) R_1X_LL w=1e-07 l=1e-07   res=0.149966
XXI2\<1\>\/XI2\<1\>\/XI2\<1\>\/XI2\<1\>\/XI2\<0\>\/XI2\<0\>\/XI2\<1\>\/XI2\<1\>\/RR5 \
 (  \
 N_SEL7\<1\>_XI2\<1\>\/XI2\<1\>\/XI2\<1\>\/XI2\<1\>\/XI2\<0\>\/XI2\<0\>\/XI2\<1\>\/XI2\<1\>\/RR5_pos \
 N_WLSEL\<1951\>_XI2\<1\>\/XI2\<1\>\/XI2\<1\>\/XI2\<1\>\/XI2\<0\>\/XI2\<0\>\/XI2\<1\>\/XI2\<1\>\/RR5_neg \
 ) R_1X_LL w=1e-07 l=1e-07   res=0.149966
XXI2\<1\>\/XI2\<1\>\/XI2\<1\>\/XI2\<1\>\/XI2\<0\>\/XI2\<1\>\/XI2\<0\>\/XI2\<0\>\/RR0 \
 (  \
 N_SEL0\<0\>_XI2\<1\>\/XI2\<1\>\/XI2\<1\>\/XI2\<1\>\/XI2\<0\>\/XI2\<1\>\/XI2\<0\>\/XI2\<0\>\/RR0_pos \
 N_WLSEL\<1952\>_XI2\<1\>\/XI2\<1\>\/XI2\<1\>\/XI2\<1\>\/XI2\<0\>\/XI2\<1\>\/XI2\<0\>\/XI2\<0\>\/RR0_neg \
 ) R_1X_LL w=1e-07 l=1e-07   res=0.149966
XXI2\<1\>\/XI2\<1\>\/XI2\<1\>\/XI2\<1\>\/XI2\<0\>\/XI2\<1\>\/XI2\<0\>\/XI2\<0\>\/RR1 \
 (  \
 N_SEL1\<0\>_XI2\<1\>\/XI2\<1\>\/XI2\<1\>\/XI2\<1\>\/XI2\<0\>\/XI2\<1\>\/XI2\<0\>\/XI2\<0\>\/RR1_pos \
 N_WLSEL\<1953\>_XI2\<1\>\/XI2\<1\>\/XI2\<1\>\/XI2\<1\>\/XI2\<0\>\/XI2\<1\>\/XI2\<0\>\/XI2\<0\>\/RR1_neg \
 ) R_1X_LL w=1e-07 l=1e-07   res=0.149966
XXI2\<1\>\/XI2\<1\>\/XI2\<1\>\/XI2\<1\>\/XI2\<0\>\/XI2\<1\>\/XI2\<0\>\/XI2\<0\>\/RR2 \
 (  \
 N_SEL2\<1\>_XI2\<1\>\/XI2\<1\>\/XI2\<1\>\/XI2\<1\>\/XI2\<0\>\/XI2\<1\>\/XI2\<0\>\/XI2\<0\>\/RR2_pos \
 N_WLSEL\<1954\>_XI2\<1\>\/XI2\<1\>\/XI2\<1\>\/XI2\<1\>\/XI2\<0\>\/XI2\<1\>\/XI2\<0\>\/XI2\<0\>\/RR2_neg \
 ) R_1X_LL w=1e-07 l=1e-07   res=0.149966
XXI2\<1\>\/XI2\<1\>\/XI2\<1\>\/XI2\<1\>\/XI2\<0\>\/XI2\<1\>\/XI2\<0\>\/XI2\<0\>\/RR3 \
 (  \
 N_SEL3\<0\>_XI2\<1\>\/XI2\<1\>\/XI2\<1\>\/XI2\<1\>\/XI2\<0\>\/XI2\<1\>\/XI2\<0\>\/XI2\<0\>\/RR3_pos \
 N_WLSEL\<1955\>_XI2\<1\>\/XI2\<1\>\/XI2\<1\>\/XI2\<1\>\/XI2\<0\>\/XI2\<1\>\/XI2\<0\>\/XI2\<0\>\/RR3_neg \
 ) R_1X_LL w=1e-07 l=1e-07   res=0.149966
XXI2\<1\>\/XI2\<1\>\/XI2\<1\>\/XI2\<1\>\/XI2\<0\>\/XI2\<1\>\/XI2\<0\>\/XI2\<0\>\/RR4 \
 (  \
 N_SEL4\<1\>_XI2\<1\>\/XI2\<1\>\/XI2\<1\>\/XI2\<1\>\/XI2\<0\>\/XI2\<1\>\/XI2\<0\>\/XI2\<0\>\/RR4_pos \
 N_WLSEL\<1956\>_XI2\<1\>\/XI2\<1\>\/XI2\<1\>\/XI2\<1\>\/XI2\<0\>\/XI2\<1\>\/XI2\<0\>\/XI2\<0\>\/RR4_neg \
 ) R_1X_LL w=1e-07 l=1e-07   res=0.149966
XXI2\<1\>\/XI2\<1\>\/XI2\<1\>\/XI2\<1\>\/XI2\<0\>\/XI2\<1\>\/XI2\<0\>\/XI2\<0\>\/RR7 \
 (  \
 N_SEL5\<1\>_XI2\<1\>\/XI2\<1\>\/XI2\<1\>\/XI2\<1\>\/XI2\<0\>\/XI2\<1\>\/XI2\<0\>\/XI2\<0\>\/RR7_pos \
 N_WLSEL\<1957\>_XI2\<1\>\/XI2\<1\>\/XI2\<1\>\/XI2\<1\>\/XI2\<0\>\/XI2\<1\>\/XI2\<0\>\/XI2\<0\>\/RR7_neg \
 ) R_1X_LL w=1e-07 l=1e-07   res=0.149966
XXI2\<1\>\/XI2\<1\>\/XI2\<1\>\/XI2\<1\>\/XI2\<0\>\/XI2\<1\>\/XI2\<0\>\/XI2\<0\>\/RR6 \
 (  \
 N_SEL6\<1\>_XI2\<1\>\/XI2\<1\>\/XI2\<1\>\/XI2\<1\>\/XI2\<0\>\/XI2\<1\>\/XI2\<0\>\/XI2\<0\>\/RR6_pos \
 N_WLSEL\<1958\>_XI2\<1\>\/XI2\<1\>\/XI2\<1\>\/XI2\<1\>\/XI2\<0\>\/XI2\<1\>\/XI2\<0\>\/XI2\<0\>\/RR6_neg \
 ) R_1X_LL w=1e-07 l=1e-07   res=0.149966
XXI2\<1\>\/XI2\<1\>\/XI2\<1\>\/XI2\<1\>\/XI2\<0\>\/XI2\<1\>\/XI2\<0\>\/XI2\<0\>\/RR5 \
 (  \
 N_SEL7\<1\>_XI2\<1\>\/XI2\<1\>\/XI2\<1\>\/XI2\<1\>\/XI2\<0\>\/XI2\<1\>\/XI2\<0\>\/XI2\<0\>\/RR5_pos \
 N_WLSEL\<1959\>_XI2\<1\>\/XI2\<1\>\/XI2\<1\>\/XI2\<1\>\/XI2\<0\>\/XI2\<1\>\/XI2\<0\>\/XI2\<0\>\/RR5_neg \
 ) R_1X_LL w=1e-07 l=1e-07   res=0.149966
XXI2\<1\>\/XI2\<1\>\/XI2\<1\>\/XI2\<1\>\/XI2\<0\>\/XI2\<1\>\/XI2\<0\>\/XI2\<1\>\/RR0 \
 (  \
 N_SEL0\<1\>_XI2\<1\>\/XI2\<1\>\/XI2\<1\>\/XI2\<1\>\/XI2\<0\>\/XI2\<1\>\/XI2\<0\>\/XI2\<1\>\/RR0_pos \
 N_WLSEL\<1960\>_XI2\<1\>\/XI2\<1\>\/XI2\<1\>\/XI2\<1\>\/XI2\<0\>\/XI2\<1\>\/XI2\<0\>\/XI2\<1\>\/RR0_neg \
 ) R_1X_LL w=1e-07 l=1e-07   res=0.149966
XXI2\<1\>\/XI2\<1\>\/XI2\<1\>\/XI2\<1\>\/XI2\<0\>\/XI2\<1\>\/XI2\<0\>\/XI2\<1\>\/RR1 \
 (  \
 N_SEL1\<0\>_XI2\<1\>\/XI2\<1\>\/XI2\<1\>\/XI2\<1\>\/XI2\<0\>\/XI2\<1\>\/XI2\<0\>\/XI2\<1\>\/RR1_pos \
 N_WLSEL\<1961\>_XI2\<1\>\/XI2\<1\>\/XI2\<1\>\/XI2\<1\>\/XI2\<0\>\/XI2\<1\>\/XI2\<0\>\/XI2\<1\>\/RR1_neg \
 ) R_1X_LL w=1e-07 l=1e-07   res=0.149966
XXI2\<1\>\/XI2\<1\>\/XI2\<1\>\/XI2\<1\>\/XI2\<0\>\/XI2\<1\>\/XI2\<0\>\/XI2\<1\>\/RR2 \
 (  \
 N_SEL2\<1\>_XI2\<1\>\/XI2\<1\>\/XI2\<1\>\/XI2\<1\>\/XI2\<0\>\/XI2\<1\>\/XI2\<0\>\/XI2\<1\>\/RR2_pos \
 N_WLSEL\<1962\>_XI2\<1\>\/XI2\<1\>\/XI2\<1\>\/XI2\<1\>\/XI2\<0\>\/XI2\<1\>\/XI2\<0\>\/XI2\<1\>\/RR2_neg \
 ) R_1X_LL w=1e-07 l=1e-07   res=0.149966
XXI2\<1\>\/XI2\<1\>\/XI2\<1\>\/XI2\<1\>\/XI2\<0\>\/XI2\<1\>\/XI2\<0\>\/XI2\<1\>\/RR3 \
 (  \
 N_SEL3\<0\>_XI2\<1\>\/XI2\<1\>\/XI2\<1\>\/XI2\<1\>\/XI2\<0\>\/XI2\<1\>\/XI2\<0\>\/XI2\<1\>\/RR3_pos \
 N_WLSEL\<1963\>_XI2\<1\>\/XI2\<1\>\/XI2\<1\>\/XI2\<1\>\/XI2\<0\>\/XI2\<1\>\/XI2\<0\>\/XI2\<1\>\/RR3_neg \
 ) R_1X_LL w=1e-07 l=1e-07   res=0.149966
XXI2\<1\>\/XI2\<1\>\/XI2\<1\>\/XI2\<1\>\/XI2\<0\>\/XI2\<1\>\/XI2\<0\>\/XI2\<1\>\/RR4 \
 (  \
 N_SEL4\<1\>_XI2\<1\>\/XI2\<1\>\/XI2\<1\>\/XI2\<1\>\/XI2\<0\>\/XI2\<1\>\/XI2\<0\>\/XI2\<1\>\/RR4_pos \
 N_WLSEL\<1964\>_XI2\<1\>\/XI2\<1\>\/XI2\<1\>\/XI2\<1\>\/XI2\<0\>\/XI2\<1\>\/XI2\<0\>\/XI2\<1\>\/RR4_neg \
 ) R_1X_LL w=1e-07 l=1e-07   res=0.149966
XXI2\<1\>\/XI2\<1\>\/XI2\<1\>\/XI2\<1\>\/XI2\<0\>\/XI2\<1\>\/XI2\<0\>\/XI2\<1\>\/RR7 \
 (  \
 N_SEL5\<1\>_XI2\<1\>\/XI2\<1\>\/XI2\<1\>\/XI2\<1\>\/XI2\<0\>\/XI2\<1\>\/XI2\<0\>\/XI2\<1\>\/RR7_pos \
 N_WLSEL\<1965\>_XI2\<1\>\/XI2\<1\>\/XI2\<1\>\/XI2\<1\>\/XI2\<0\>\/XI2\<1\>\/XI2\<0\>\/XI2\<1\>\/RR7_neg \
 ) R_1X_LL w=1e-07 l=1e-07   res=0.149966
XXI2\<1\>\/XI2\<1\>\/XI2\<1\>\/XI2\<1\>\/XI2\<0\>\/XI2\<1\>\/XI2\<0\>\/XI2\<1\>\/RR6 \
 (  \
 N_SEL6\<1\>_XI2\<1\>\/XI2\<1\>\/XI2\<1\>\/XI2\<1\>\/XI2\<0\>\/XI2\<1\>\/XI2\<0\>\/XI2\<1\>\/RR6_pos \
 N_WLSEL\<1966\>_XI2\<1\>\/XI2\<1\>\/XI2\<1\>\/XI2\<1\>\/XI2\<0\>\/XI2\<1\>\/XI2\<0\>\/XI2\<1\>\/RR6_neg \
 ) R_1X_LL w=1e-07 l=1e-07   res=0.149966
XXI2\<1\>\/XI2\<0\>\/XI2\<1\>\/XI2\<0\>\/XI2\<1\>\/XI2\<0\>\/XI2\<1\>\/XI2\<1\>\/RR5 \
 (  \
 N_SEL7\<1\>_XI2\<1\>\/XI2\<0\>\/XI2\<1\>\/XI2\<0\>\/XI2\<1\>\/XI2\<0\>\/XI2\<1\>\/XI2\<1\>\/RR5_pos \
 N_WLSEL\<1375\>_XI2\<1\>\/XI2\<0\>\/XI2\<1\>\/XI2\<0\>\/XI2\<1\>\/XI2\<0\>\/XI2\<1\>\/XI2\<1\>\/RR5_neg \
 ) R_1X_LL w=1e-07 l=1e-07   res=0.149966
XXI2\<1\>\/XI2\<0\>\/XI2\<1\>\/XI2\<0\>\/XI2\<1\>\/XI2\<1\>\/XI2\<0\>\/XI2\<0\>\/RR0 \
 (  \
 N_SEL0\<0\>_XI2\<1\>\/XI2\<0\>\/XI2\<1\>\/XI2\<0\>\/XI2\<1\>\/XI2\<1\>\/XI2\<0\>\/XI2\<0\>\/RR0_pos \
 N_WLSEL\<1376\>_XI2\<1\>\/XI2\<0\>\/XI2\<1\>\/XI2\<0\>\/XI2\<1\>\/XI2\<1\>\/XI2\<0\>\/XI2\<0\>\/RR0_neg \
 ) R_1X_LL w=1e-07 l=1e-07   res=0.149966
XXI2\<1\>\/XI2\<0\>\/XI2\<1\>\/XI2\<0\>\/XI2\<1\>\/XI2\<1\>\/XI2\<0\>\/XI2\<0\>\/RR1 \
 (  \
 N_SEL1\<0\>_XI2\<1\>\/XI2\<0\>\/XI2\<1\>\/XI2\<0\>\/XI2\<1\>\/XI2\<1\>\/XI2\<0\>\/XI2\<0\>\/RR1_pos \
 N_WLSEL\<1377\>_XI2\<1\>\/XI2\<0\>\/XI2\<1\>\/XI2\<0\>\/XI2\<1\>\/XI2\<1\>\/XI2\<0\>\/XI2\<0\>\/RR1_neg \
 ) R_1X_LL w=1e-07 l=1e-07   res=0.149966
XXI2\<1\>\/XI2\<0\>\/XI2\<1\>\/XI2\<0\>\/XI2\<1\>\/XI2\<1\>\/XI2\<0\>\/XI2\<0\>\/RR2 \
 (  \
 N_SEL2\<1\>_XI2\<1\>\/XI2\<0\>\/XI2\<1\>\/XI2\<0\>\/XI2\<1\>\/XI2\<1\>\/XI2\<0\>\/XI2\<0\>\/RR2_pos \
 N_WLSEL\<1378\>_XI2\<1\>\/XI2\<0\>\/XI2\<1\>\/XI2\<0\>\/XI2\<1\>\/XI2\<1\>\/XI2\<0\>\/XI2\<0\>\/RR2_neg \
 ) R_1X_LL w=1e-07 l=1e-07   res=0.149966
XXI2\<1\>\/XI2\<0\>\/XI2\<1\>\/XI2\<0\>\/XI2\<1\>\/XI2\<1\>\/XI2\<0\>\/XI2\<0\>\/RR3 \
 (  \
 N_SEL3\<1\>_XI2\<1\>\/XI2\<0\>\/XI2\<1\>\/XI2\<0\>\/XI2\<1\>\/XI2\<1\>\/XI2\<0\>\/XI2\<0\>\/RR3_pos \
 N_WLSEL\<1379\>_XI2\<1\>\/XI2\<0\>\/XI2\<1\>\/XI2\<0\>\/XI2\<1\>\/XI2\<1\>\/XI2\<0\>\/XI2\<0\>\/RR3_neg \
 ) R_1X_LL w=1e-07 l=1e-07   res=0.149966
XXI2\<1\>\/XI2\<0\>\/XI2\<1\>\/XI2\<0\>\/XI2\<1\>\/XI2\<1\>\/XI2\<0\>\/XI2\<0\>\/RR4 \
 (  \
 N_SEL4\<0\>_XI2\<1\>\/XI2\<0\>\/XI2\<1\>\/XI2\<0\>\/XI2\<1\>\/XI2\<1\>\/XI2\<0\>\/XI2\<0\>\/RR4_pos \
 N_WLSEL\<1380\>_XI2\<1\>\/XI2\<0\>\/XI2\<1\>\/XI2\<0\>\/XI2\<1\>\/XI2\<1\>\/XI2\<0\>\/XI2\<0\>\/RR4_neg \
 ) R_1X_LL w=1e-07 l=1e-07   res=0.149966
XXI2\<1\>\/XI2\<0\>\/XI2\<1\>\/XI2\<0\>\/XI2\<1\>\/XI2\<1\>\/XI2\<0\>\/XI2\<0\>\/RR7 \
 (  \
 N_SEL5\<1\>_XI2\<1\>\/XI2\<0\>\/XI2\<1\>\/XI2\<0\>\/XI2\<1\>\/XI2\<1\>\/XI2\<0\>\/XI2\<0\>\/RR7_pos \
 N_WLSEL\<1381\>_XI2\<1\>\/XI2\<0\>\/XI2\<1\>\/XI2\<0\>\/XI2\<1\>\/XI2\<1\>\/XI2\<0\>\/XI2\<0\>\/RR7_neg \
 ) R_1X_LL w=1e-07 l=1e-07   res=0.149966
XXI2\<1\>\/XI2\<0\>\/XI2\<1\>\/XI2\<0\>\/XI2\<1\>\/XI2\<1\>\/XI2\<0\>\/XI2\<0\>\/RR6 \
 (  \
 N_SEL6\<0\>_XI2\<1\>\/XI2\<0\>\/XI2\<1\>\/XI2\<0\>\/XI2\<1\>\/XI2\<1\>\/XI2\<0\>\/XI2\<0\>\/RR6_pos \
 N_WLSEL\<1382\>_XI2\<1\>\/XI2\<0\>\/XI2\<1\>\/XI2\<0\>\/XI2\<1\>\/XI2\<1\>\/XI2\<0\>\/XI2\<0\>\/RR6_neg \
 ) R_1X_LL w=1e-07 l=1e-07   res=0.149966
XXI2\<1\>\/XI2\<0\>\/XI2\<1\>\/XI2\<0\>\/XI2\<1\>\/XI2\<1\>\/XI2\<0\>\/XI2\<0\>\/RR5 \
 (  \
 N_SEL7\<1\>_XI2\<1\>\/XI2\<0\>\/XI2\<1\>\/XI2\<0\>\/XI2\<1\>\/XI2\<1\>\/XI2\<0\>\/XI2\<0\>\/RR5_pos \
 N_WLSEL\<1383\>_XI2\<1\>\/XI2\<0\>\/XI2\<1\>\/XI2\<0\>\/XI2\<1\>\/XI2\<1\>\/XI2\<0\>\/XI2\<0\>\/RR5_neg \
 ) R_1X_LL w=1e-07 l=1e-07   res=0.149966
XXI2\<1\>\/XI2\<0\>\/XI2\<1\>\/XI2\<0\>\/XI2\<1\>\/XI2\<1\>\/XI2\<0\>\/XI2\<1\>\/RR0 \
 (  \
 N_SEL0\<1\>_XI2\<1\>\/XI2\<0\>\/XI2\<1\>\/XI2\<0\>\/XI2\<1\>\/XI2\<1\>\/XI2\<0\>\/XI2\<1\>\/RR0_pos \
 N_WLSEL\<1384\>_XI2\<1\>\/XI2\<0\>\/XI2\<1\>\/XI2\<0\>\/XI2\<1\>\/XI2\<1\>\/XI2\<0\>\/XI2\<1\>\/RR0_neg \
 ) R_1X_LL w=1e-07 l=1e-07   res=0.149966
XXI2\<1\>\/XI2\<0\>\/XI2\<1\>\/XI2\<0\>\/XI2\<1\>\/XI2\<1\>\/XI2\<0\>\/XI2\<1\>\/RR1 \
 (  \
 N_SEL1\<0\>_XI2\<1\>\/XI2\<0\>\/XI2\<1\>\/XI2\<0\>\/XI2\<1\>\/XI2\<1\>\/XI2\<0\>\/XI2\<1\>\/RR1_pos \
 N_WLSEL\<1385\>_XI2\<1\>\/XI2\<0\>\/XI2\<1\>\/XI2\<0\>\/XI2\<1\>\/XI2\<1\>\/XI2\<0\>\/XI2\<1\>\/RR1_neg \
 ) R_1X_LL w=1e-07 l=1e-07   res=0.149966
XXI2\<1\>\/XI2\<0\>\/XI2\<1\>\/XI2\<0\>\/XI2\<1\>\/XI2\<1\>\/XI2\<0\>\/XI2\<1\>\/RR2 \
 (  \
 N_SEL2\<1\>_XI2\<1\>\/XI2\<0\>\/XI2\<1\>\/XI2\<0\>\/XI2\<1\>\/XI2\<1\>\/XI2\<0\>\/XI2\<1\>\/RR2_pos \
 N_WLSEL\<1386\>_XI2\<1\>\/XI2\<0\>\/XI2\<1\>\/XI2\<0\>\/XI2\<1\>\/XI2\<1\>\/XI2\<0\>\/XI2\<1\>\/RR2_neg \
 ) R_1X_LL w=1e-07 l=1e-07   res=0.149966
XXI2\<1\>\/XI2\<0\>\/XI2\<1\>\/XI2\<0\>\/XI2\<1\>\/XI2\<1\>\/XI2\<0\>\/XI2\<1\>\/RR3 \
 (  \
 N_SEL3\<1\>_XI2\<1\>\/XI2\<0\>\/XI2\<1\>\/XI2\<0\>\/XI2\<1\>\/XI2\<1\>\/XI2\<0\>\/XI2\<1\>\/RR3_pos \
 N_WLSEL\<1387\>_XI2\<1\>\/XI2\<0\>\/XI2\<1\>\/XI2\<0\>\/XI2\<1\>\/XI2\<1\>\/XI2\<0\>\/XI2\<1\>\/RR3_neg \
 ) R_1X_LL w=1e-07 l=1e-07   res=0.149966
XXI2\<1\>\/XI2\<0\>\/XI2\<1\>\/XI2\<0\>\/XI2\<1\>\/XI2\<1\>\/XI2\<0\>\/XI2\<1\>\/RR4 \
 (  \
 N_SEL4\<0\>_XI2\<1\>\/XI2\<0\>\/XI2\<1\>\/XI2\<0\>\/XI2\<1\>\/XI2\<1\>\/XI2\<0\>\/XI2\<1\>\/RR4_pos \
 N_WLSEL\<1388\>_XI2\<1\>\/XI2\<0\>\/XI2\<1\>\/XI2\<0\>\/XI2\<1\>\/XI2\<1\>\/XI2\<0\>\/XI2\<1\>\/RR4_neg \
 ) R_1X_LL w=1e-07 l=1e-07   res=0.149966
XXI2\<1\>\/XI2\<0\>\/XI2\<1\>\/XI2\<0\>\/XI2\<1\>\/XI2\<1\>\/XI2\<0\>\/XI2\<1\>\/RR7 \
 (  \
 N_SEL5\<1\>_XI2\<1\>\/XI2\<0\>\/XI2\<1\>\/XI2\<0\>\/XI2\<1\>\/XI2\<1\>\/XI2\<0\>\/XI2\<1\>\/RR7_pos \
 N_WLSEL\<1389\>_XI2\<1\>\/XI2\<0\>\/XI2\<1\>\/XI2\<0\>\/XI2\<1\>\/XI2\<1\>\/XI2\<0\>\/XI2\<1\>\/RR7_neg \
 ) R_1X_LL w=1e-07 l=1e-07   res=0.149966
XXI2\<1\>\/XI2\<0\>\/XI2\<1\>\/XI2\<0\>\/XI2\<1\>\/XI2\<1\>\/XI2\<0\>\/XI2\<1\>\/RR6 \
 (  \
 N_SEL6\<0\>_XI2\<1\>\/XI2\<0\>\/XI2\<1\>\/XI2\<0\>\/XI2\<1\>\/XI2\<1\>\/XI2\<0\>\/XI2\<1\>\/RR6_pos \
 N_WLSEL\<1390\>_XI2\<1\>\/XI2\<0\>\/XI2\<1\>\/XI2\<0\>\/XI2\<1\>\/XI2\<1\>\/XI2\<0\>\/XI2\<1\>\/RR6_neg \
 ) R_1X_LL w=1e-07 l=1e-07   res=0.149966
XXI2\<1\>\/XI2\<0\>\/XI2\<1\>\/XI2\<0\>\/XI2\<1\>\/XI2\<1\>\/XI2\<0\>\/XI2\<1\>\/RR5 \
 (  \
 N_SEL7\<1\>_XI2\<1\>\/XI2\<0\>\/XI2\<1\>\/XI2\<0\>\/XI2\<1\>\/XI2\<1\>\/XI2\<0\>\/XI2\<1\>\/RR5_pos \
 N_WLSEL\<1391\>_XI2\<1\>\/XI2\<0\>\/XI2\<1\>\/XI2\<0\>\/XI2\<1\>\/XI2\<1\>\/XI2\<0\>\/XI2\<1\>\/RR5_neg \
 ) R_1X_LL w=1e-07 l=1e-07   res=0.149966
XXI2\<1\>\/XI2\<0\>\/XI2\<1\>\/XI2\<0\>\/XI2\<1\>\/XI2\<1\>\/XI2\<1\>\/XI2\<0\>\/RR0 \
 (  \
 N_SEL0\<0\>_XI2\<1\>\/XI2\<0\>\/XI2\<1\>\/XI2\<0\>\/XI2\<1\>\/XI2\<1\>\/XI2\<1\>\/XI2\<0\>\/RR0_pos \
 N_WLSEL\<1392\>_XI2\<1\>\/XI2\<0\>\/XI2\<1\>\/XI2\<0\>\/XI2\<1\>\/XI2\<1\>\/XI2\<1\>\/XI2\<0\>\/RR0_neg \
 ) R_1X_LL w=1e-07 l=1e-07   res=0.149966
XXI2\<1\>\/XI2\<0\>\/XI2\<1\>\/XI2\<0\>\/XI2\<1\>\/XI2\<1\>\/XI2\<1\>\/XI2\<0\>\/RR1 \
 (  \
 N_SEL1\<1\>_XI2\<1\>\/XI2\<0\>\/XI2\<1\>\/XI2\<0\>\/XI2\<1\>\/XI2\<1\>\/XI2\<1\>\/XI2\<0\>\/RR1_pos \
 N_WLSEL\<1393\>_XI2\<1\>\/XI2\<0\>\/XI2\<1\>\/XI2\<0\>\/XI2\<1\>\/XI2\<1\>\/XI2\<1\>\/XI2\<0\>\/RR1_neg \
 ) R_1X_LL w=1e-07 l=1e-07   res=0.149966
XXI2\<1\>\/XI2\<0\>\/XI2\<1\>\/XI2\<0\>\/XI2\<1\>\/XI2\<1\>\/XI2\<1\>\/XI2\<0\>\/RR2 \
 (  \
 N_SEL2\<1\>_XI2\<1\>\/XI2\<0\>\/XI2\<1\>\/XI2\<0\>\/XI2\<1\>\/XI2\<1\>\/XI2\<1\>\/XI2\<0\>\/RR2_pos \
 N_WLSEL\<1394\>_XI2\<1\>\/XI2\<0\>\/XI2\<1\>\/XI2\<0\>\/XI2\<1\>\/XI2\<1\>\/XI2\<1\>\/XI2\<0\>\/RR2_neg \
 ) R_1X_LL w=1e-07 l=1e-07   res=0.149966
XXI2\<1\>\/XI2\<0\>\/XI2\<1\>\/XI2\<0\>\/XI2\<1\>\/XI2\<1\>\/XI2\<1\>\/XI2\<0\>\/RR3 \
 (  \
 N_SEL3\<1\>_XI2\<1\>\/XI2\<0\>\/XI2\<1\>\/XI2\<0\>\/XI2\<1\>\/XI2\<1\>\/XI2\<1\>\/XI2\<0\>\/RR3_pos \
 N_WLSEL\<1395\>_XI2\<1\>\/XI2\<0\>\/XI2\<1\>\/XI2\<0\>\/XI2\<1\>\/XI2\<1\>\/XI2\<1\>\/XI2\<0\>\/RR3_neg \
 ) R_1X_LL w=1e-07 l=1e-07   res=0.149966
XXI2\<1\>\/XI2\<0\>\/XI2\<1\>\/XI2\<0\>\/XI2\<1\>\/XI2\<1\>\/XI2\<1\>\/XI2\<0\>\/RR4 \
 (  \
 N_SEL4\<0\>_XI2\<1\>\/XI2\<0\>\/XI2\<1\>\/XI2\<0\>\/XI2\<1\>\/XI2\<1\>\/XI2\<1\>\/XI2\<0\>\/RR4_pos \
 N_WLSEL\<1396\>_XI2\<1\>\/XI2\<0\>\/XI2\<1\>\/XI2\<0\>\/XI2\<1\>\/XI2\<1\>\/XI2\<1\>\/XI2\<0\>\/RR4_neg \
 ) R_1X_LL w=1e-07 l=1e-07   res=0.149966
XXI2\<1\>\/XI2\<0\>\/XI2\<1\>\/XI2\<0\>\/XI2\<1\>\/XI2\<1\>\/XI2\<1\>\/XI2\<0\>\/RR7 \
 (  \
 N_SEL5\<1\>_XI2\<1\>\/XI2\<0\>\/XI2\<1\>\/XI2\<0\>\/XI2\<1\>\/XI2\<1\>\/XI2\<1\>\/XI2\<0\>\/RR7_pos \
 N_WLSEL\<1397\>_XI2\<1\>\/XI2\<0\>\/XI2\<1\>\/XI2\<0\>\/XI2\<1\>\/XI2\<1\>\/XI2\<1\>\/XI2\<0\>\/RR7_neg \
 ) R_1X_LL w=1e-07 l=1e-07   res=0.149966
XXI2\<1\>\/XI2\<0\>\/XI2\<1\>\/XI2\<0\>\/XI2\<1\>\/XI2\<1\>\/XI2\<1\>\/XI2\<0\>\/RR6 \
 (  \
 N_SEL6\<0\>_XI2\<1\>\/XI2\<0\>\/XI2\<1\>\/XI2\<0\>\/XI2\<1\>\/XI2\<1\>\/XI2\<1\>\/XI2\<0\>\/RR6_pos \
 N_WLSEL\<1398\>_XI2\<1\>\/XI2\<0\>\/XI2\<1\>\/XI2\<0\>\/XI2\<1\>\/XI2\<1\>\/XI2\<1\>\/XI2\<0\>\/RR6_neg \
 ) R_1X_LL w=1e-07 l=1e-07   res=0.149966
XXI2\<1\>\/XI2\<0\>\/XI2\<1\>\/XI2\<0\>\/XI2\<1\>\/XI2\<1\>\/XI2\<1\>\/XI2\<0\>\/RR5 \
 (  \
 N_SEL7\<1\>_XI2\<1\>\/XI2\<0\>\/XI2\<1\>\/XI2\<0\>\/XI2\<1\>\/XI2\<1\>\/XI2\<1\>\/XI2\<0\>\/RR5_pos \
 N_WLSEL\<1399\>_XI2\<1\>\/XI2\<0\>\/XI2\<1\>\/XI2\<0\>\/XI2\<1\>\/XI2\<1\>\/XI2\<1\>\/XI2\<0\>\/RR5_neg \
 ) R_1X_LL w=1e-07 l=1e-07   res=0.149966
XXI2\<1\>\/XI2\<0\>\/XI2\<1\>\/XI2\<0\>\/XI2\<1\>\/XI2\<1\>\/XI2\<1\>\/XI2\<1\>\/RR0 \
 (  \
 N_SEL0\<1\>_XI2\<1\>\/XI2\<0\>\/XI2\<1\>\/XI2\<0\>\/XI2\<1\>\/XI2\<1\>\/XI2\<1\>\/XI2\<1\>\/RR0_pos \
 N_WLSEL\<1400\>_XI2\<1\>\/XI2\<0\>\/XI2\<1\>\/XI2\<0\>\/XI2\<1\>\/XI2\<1\>\/XI2\<1\>\/XI2\<1\>\/RR0_neg \
 ) R_1X_LL w=1e-07 l=1e-07   res=0.149966
XXI2\<1\>\/XI2\<0\>\/XI2\<1\>\/XI2\<0\>\/XI2\<1\>\/XI2\<1\>\/XI2\<1\>\/XI2\<1\>\/RR1 \
 (  \
 N_SEL1\<1\>_XI2\<1\>\/XI2\<0\>\/XI2\<1\>\/XI2\<0\>\/XI2\<1\>\/XI2\<1\>\/XI2\<1\>\/XI2\<1\>\/RR1_pos \
 N_WLSEL\<1401\>_XI2\<1\>\/XI2\<0\>\/XI2\<1\>\/XI2\<0\>\/XI2\<1\>\/XI2\<1\>\/XI2\<1\>\/XI2\<1\>\/RR1_neg \
 ) R_1X_LL w=1e-07 l=1e-07   res=0.149966
XXI2\<1\>\/XI2\<0\>\/XI2\<1\>\/XI2\<0\>\/XI2\<1\>\/XI2\<1\>\/XI2\<1\>\/XI2\<1\>\/RR2 \
 (  \
 N_SEL2\<1\>_XI2\<1\>\/XI2\<0\>\/XI2\<1\>\/XI2\<0\>\/XI2\<1\>\/XI2\<1\>\/XI2\<1\>\/XI2\<1\>\/RR2_pos \
 N_WLSEL\<1402\>_XI2\<1\>\/XI2\<0\>\/XI2\<1\>\/XI2\<0\>\/XI2\<1\>\/XI2\<1\>\/XI2\<1\>\/XI2\<1\>\/RR2_neg \
 ) R_1X_LL w=1e-07 l=1e-07   res=0.149966
XXI2\<1\>\/XI2\<0\>\/XI2\<1\>\/XI2\<0\>\/XI2\<1\>\/XI2\<1\>\/XI2\<1\>\/XI2\<1\>\/RR3 \
 (  \
 N_SEL3\<1\>_XI2\<1\>\/XI2\<0\>\/XI2\<1\>\/XI2\<0\>\/XI2\<1\>\/XI2\<1\>\/XI2\<1\>\/XI2\<1\>\/RR3_pos \
 N_WLSEL\<1403\>_XI2\<1\>\/XI2\<0\>\/XI2\<1\>\/XI2\<0\>\/XI2\<1\>\/XI2\<1\>\/XI2\<1\>\/XI2\<1\>\/RR3_neg \
 ) R_1X_LL w=1e-07 l=1e-07   res=0.149966
XXI2\<1\>\/XI2\<0\>\/XI2\<1\>\/XI2\<0\>\/XI2\<1\>\/XI2\<1\>\/XI2\<1\>\/XI2\<1\>\/RR4 \
 (  \
 N_SEL4\<0\>_XI2\<1\>\/XI2\<0\>\/XI2\<1\>\/XI2\<0\>\/XI2\<1\>\/XI2\<1\>\/XI2\<1\>\/XI2\<1\>\/RR4_pos \
 N_WLSEL\<1404\>_XI2\<1\>\/XI2\<0\>\/XI2\<1\>\/XI2\<0\>\/XI2\<1\>\/XI2\<1\>\/XI2\<1\>\/XI2\<1\>\/RR4_neg \
 ) R_1X_LL w=1e-07 l=1e-07   res=0.149966
XXI2\<1\>\/XI2\<0\>\/XI2\<1\>\/XI2\<0\>\/XI2\<1\>\/XI2\<1\>\/XI2\<1\>\/XI2\<1\>\/RR7 \
 (  \
 N_SEL5\<1\>_XI2\<1\>\/XI2\<0\>\/XI2\<1\>\/XI2\<0\>\/XI2\<1\>\/XI2\<1\>\/XI2\<1\>\/XI2\<1\>\/RR7_pos \
 N_WLSEL\<1405\>_XI2\<1\>\/XI2\<0\>\/XI2\<1\>\/XI2\<0\>\/XI2\<1\>\/XI2\<1\>\/XI2\<1\>\/XI2\<1\>\/RR7_neg \
 ) R_1X_LL w=1e-07 l=1e-07   res=0.149966
XXI2\<1\>\/XI2\<0\>\/XI2\<1\>\/XI2\<0\>\/XI2\<1\>\/XI2\<1\>\/XI2\<1\>\/XI2\<1\>\/RR6 \
 (  \
 N_SEL6\<0\>_XI2\<1\>\/XI2\<0\>\/XI2\<1\>\/XI2\<0\>\/XI2\<1\>\/XI2\<1\>\/XI2\<1\>\/XI2\<1\>\/RR6_pos \
 N_WLSEL\<1406\>_XI2\<1\>\/XI2\<0\>\/XI2\<1\>\/XI2\<0\>\/XI2\<1\>\/XI2\<1\>\/XI2\<1\>\/XI2\<1\>\/RR6_neg \
 ) R_1X_LL w=1e-07 l=1e-07   res=0.149966
XXI2\<1\>\/XI2\<0\>\/XI2\<1\>\/XI2\<0\>\/XI2\<1\>\/XI2\<1\>\/XI2\<1\>\/XI2\<1\>\/RR5 \
 (  \
 N_SEL7\<1\>_XI2\<1\>\/XI2\<0\>\/XI2\<1\>\/XI2\<0\>\/XI2\<1\>\/XI2\<1\>\/XI2\<1\>\/XI2\<1\>\/RR5_pos \
 N_WLSEL\<1407\>_XI2\<1\>\/XI2\<0\>\/XI2\<1\>\/XI2\<0\>\/XI2\<1\>\/XI2\<1\>\/XI2\<1\>\/XI2\<1\>\/RR5_neg \
 ) R_1X_LL w=1e-07 l=1e-07   res=0.149966
XXI2\<1\>\/XI2\<0\>\/XI2\<1\>\/XI2\<1\>\/XI2\<0\>\/XI2\<0\>\/XI2\<0\>\/XI2\<0\>\/RR0 \
 (  \
 N_SEL0\<0\>_XI2\<1\>\/XI2\<0\>\/XI2\<1\>\/XI2\<1\>\/XI2\<0\>\/XI2\<0\>\/XI2\<0\>\/XI2\<0\>\/RR0_pos \
 N_WLSEL\<1408\>_XI2\<1\>\/XI2\<0\>\/XI2\<1\>\/XI2\<1\>\/XI2\<0\>\/XI2\<0\>\/XI2\<0\>\/XI2\<0\>\/RR0_neg \
 ) R_1X_LL w=1e-07 l=1e-07   res=0.149966
XXI2\<1\>\/XI2\<0\>\/XI2\<1\>\/XI2\<1\>\/XI2\<0\>\/XI2\<0\>\/XI2\<0\>\/XI2\<0\>\/RR1 \
 (  \
 N_SEL1\<0\>_XI2\<1\>\/XI2\<0\>\/XI2\<1\>\/XI2\<1\>\/XI2\<0\>\/XI2\<0\>\/XI2\<0\>\/XI2\<0\>\/RR1_pos \
 N_WLSEL\<1409\>_XI2\<1\>\/XI2\<0\>\/XI2\<1\>\/XI2\<1\>\/XI2\<0\>\/XI2\<0\>\/XI2\<0\>\/XI2\<0\>\/RR1_neg \
 ) R_1X_LL w=1e-07 l=1e-07   res=0.149966
XXI2\<1\>\/XI2\<0\>\/XI2\<1\>\/XI2\<1\>\/XI2\<0\>\/XI2\<0\>\/XI2\<0\>\/XI2\<0\>\/RR2 \
 (  \
 N_SEL2\<0\>_XI2\<1\>\/XI2\<0\>\/XI2\<1\>\/XI2\<1\>\/XI2\<0\>\/XI2\<0\>\/XI2\<0\>\/XI2\<0\>\/RR2_pos \
 N_WLSEL\<1410\>_XI2\<1\>\/XI2\<0\>\/XI2\<1\>\/XI2\<1\>\/XI2\<0\>\/XI2\<0\>\/XI2\<0\>\/XI2\<0\>\/RR2_neg \
 ) R_1X_LL w=1e-07 l=1e-07   res=0.149966
XXI2\<1\>\/XI2\<0\>\/XI2\<1\>\/XI2\<1\>\/XI2\<0\>\/XI2\<0\>\/XI2\<0\>\/XI2\<0\>\/RR3 \
 (  \
 N_SEL3\<0\>_XI2\<1\>\/XI2\<0\>\/XI2\<1\>\/XI2\<1\>\/XI2\<0\>\/XI2\<0\>\/XI2\<0\>\/XI2\<0\>\/RR3_pos \
 N_WLSEL\<1411\>_XI2\<1\>\/XI2\<0\>\/XI2\<1\>\/XI2\<1\>\/XI2\<0\>\/XI2\<0\>\/XI2\<0\>\/XI2\<0\>\/RR3_neg \
 ) R_1X_LL w=1e-07 l=1e-07   res=0.149966
XXI2\<1\>\/XI2\<0\>\/XI2\<1\>\/XI2\<1\>\/XI2\<0\>\/XI2\<0\>\/XI2\<0\>\/XI2\<0\>\/RR4 \
 (  \
 N_SEL4\<1\>_XI2\<1\>\/XI2\<0\>\/XI2\<1\>\/XI2\<1\>\/XI2\<0\>\/XI2\<0\>\/XI2\<0\>\/XI2\<0\>\/RR4_pos \
 N_WLSEL\<1412\>_XI2\<1\>\/XI2\<0\>\/XI2\<1\>\/XI2\<1\>\/XI2\<0\>\/XI2\<0\>\/XI2\<0\>\/XI2\<0\>\/RR4_neg \
 ) R_1X_LL w=1e-07 l=1e-07   res=0.149966
XXI2\<1\>\/XI2\<0\>\/XI2\<1\>\/XI2\<1\>\/XI2\<0\>\/XI2\<0\>\/XI2\<0\>\/XI2\<0\>\/RR7 \
 (  \
 N_SEL5\<1\>_XI2\<1\>\/XI2\<0\>\/XI2\<1\>\/XI2\<1\>\/XI2\<0\>\/XI2\<0\>\/XI2\<0\>\/XI2\<0\>\/RR7_pos \
 N_WLSEL\<1413\>_XI2\<1\>\/XI2\<0\>\/XI2\<1\>\/XI2\<1\>\/XI2\<0\>\/XI2\<0\>\/XI2\<0\>\/XI2\<0\>\/RR7_neg \
 ) R_1X_LL w=1e-07 l=1e-07   res=0.149966
XXI2\<1\>\/XI2\<0\>\/XI2\<1\>\/XI2\<1\>\/XI2\<0\>\/XI2\<0\>\/XI2\<0\>\/XI2\<0\>\/RR6 \
 (  \
 N_SEL6\<0\>_XI2\<1\>\/XI2\<0\>\/XI2\<1\>\/XI2\<1\>\/XI2\<0\>\/XI2\<0\>\/XI2\<0\>\/XI2\<0\>\/RR6_pos \
 N_WLSEL\<1414\>_XI2\<1\>\/XI2\<0\>\/XI2\<1\>\/XI2\<1\>\/XI2\<0\>\/XI2\<0\>\/XI2\<0\>\/XI2\<0\>\/RR6_neg \
 ) R_1X_LL w=1e-07 l=1e-07   res=0.149966
XXI2\<1\>\/XI2\<0\>\/XI2\<1\>\/XI2\<1\>\/XI2\<0\>\/XI2\<0\>\/XI2\<0\>\/XI2\<0\>\/RR5 \
 (  \
 N_SEL7\<1\>_XI2\<1\>\/XI2\<0\>\/XI2\<1\>\/XI2\<1\>\/XI2\<0\>\/XI2\<0\>\/XI2\<0\>\/XI2\<0\>\/RR5_pos \
 N_WLSEL\<1415\>_XI2\<1\>\/XI2\<0\>\/XI2\<1\>\/XI2\<1\>\/XI2\<0\>\/XI2\<0\>\/XI2\<0\>\/XI2\<0\>\/RR5_neg \
 ) R_1X_LL w=1e-07 l=1e-07   res=0.149966
XXI2\<1\>\/XI2\<0\>\/XI2\<1\>\/XI2\<1\>\/XI2\<0\>\/XI2\<0\>\/XI2\<0\>\/XI2\<1\>\/RR0 \
 (  \
 N_SEL0\<1\>_XI2\<1\>\/XI2\<0\>\/XI2\<1\>\/XI2\<1\>\/XI2\<0\>\/XI2\<0\>\/XI2\<0\>\/XI2\<1\>\/RR0_pos \
 N_WLSEL\<1416\>_XI2\<1\>\/XI2\<0\>\/XI2\<1\>\/XI2\<1\>\/XI2\<0\>\/XI2\<0\>\/XI2\<0\>\/XI2\<1\>\/RR0_neg \
 ) R_1X_LL w=1e-07 l=1e-07   res=0.149966
XXI2\<1\>\/XI2\<0\>\/XI2\<1\>\/XI2\<1\>\/XI2\<0\>\/XI2\<0\>\/XI2\<0\>\/XI2\<1\>\/RR1 \
 (  \
 N_SEL1\<0\>_XI2\<1\>\/XI2\<0\>\/XI2\<1\>\/XI2\<1\>\/XI2\<0\>\/XI2\<0\>\/XI2\<0\>\/XI2\<1\>\/RR1_pos \
 N_WLSEL\<1417\>_XI2\<1\>\/XI2\<0\>\/XI2\<1\>\/XI2\<1\>\/XI2\<0\>\/XI2\<0\>\/XI2\<0\>\/XI2\<1\>\/RR1_neg \
 ) R_1X_LL w=1e-07 l=1e-07   res=0.149966
XXI2\<1\>\/XI2\<0\>\/XI2\<1\>\/XI2\<1\>\/XI2\<0\>\/XI2\<0\>\/XI2\<0\>\/XI2\<1\>\/RR2 \
 (  \
 N_SEL2\<0\>_XI2\<1\>\/XI2\<0\>\/XI2\<1\>\/XI2\<1\>\/XI2\<0\>\/XI2\<0\>\/XI2\<0\>\/XI2\<1\>\/RR2_pos \
 N_WLSEL\<1418\>_XI2\<1\>\/XI2\<0\>\/XI2\<1\>\/XI2\<1\>\/XI2\<0\>\/XI2\<0\>\/XI2\<0\>\/XI2\<1\>\/RR2_neg \
 ) R_1X_LL w=1e-07 l=1e-07   res=0.149966
XXI2\<1\>\/XI2\<0\>\/XI2\<1\>\/XI2\<1\>\/XI2\<0\>\/XI2\<0\>\/XI2\<0\>\/XI2\<1\>\/RR3 \
 (  \
 N_SEL3\<0\>_XI2\<1\>\/XI2\<0\>\/XI2\<1\>\/XI2\<1\>\/XI2\<0\>\/XI2\<0\>\/XI2\<0\>\/XI2\<1\>\/RR3_pos \
 N_WLSEL\<1419\>_XI2\<1\>\/XI2\<0\>\/XI2\<1\>\/XI2\<1\>\/XI2\<0\>\/XI2\<0\>\/XI2\<0\>\/XI2\<1\>\/RR3_neg \
 ) R_1X_LL w=1e-07 l=1e-07   res=0.149966
XXI2\<1\>\/XI2\<0\>\/XI2\<1\>\/XI2\<1\>\/XI2\<0\>\/XI2\<0\>\/XI2\<0\>\/XI2\<1\>\/RR4 \
 (  \
 N_SEL4\<1\>_XI2\<1\>\/XI2\<0\>\/XI2\<1\>\/XI2\<1\>\/XI2\<0\>\/XI2\<0\>\/XI2\<0\>\/XI2\<1\>\/RR4_pos \
 N_WLSEL\<1420\>_XI2\<1\>\/XI2\<0\>\/XI2\<1\>\/XI2\<1\>\/XI2\<0\>\/XI2\<0\>\/XI2\<0\>\/XI2\<1\>\/RR4_neg \
 ) R_1X_LL w=1e-07 l=1e-07   res=0.149966
XXI2\<1\>\/XI2\<0\>\/XI2\<1\>\/XI2\<1\>\/XI2\<0\>\/XI2\<0\>\/XI2\<0\>\/XI2\<1\>\/RR7 \
 (  \
 N_SEL5\<1\>_XI2\<1\>\/XI2\<0\>\/XI2\<1\>\/XI2\<1\>\/XI2\<0\>\/XI2\<0\>\/XI2\<0\>\/XI2\<1\>\/RR7_pos \
 N_WLSEL\<1421\>_XI2\<1\>\/XI2\<0\>\/XI2\<1\>\/XI2\<1\>\/XI2\<0\>\/XI2\<0\>\/XI2\<0\>\/XI2\<1\>\/RR7_neg \
 ) R_1X_LL w=1e-07 l=1e-07   res=0.149966
XXI2\<1\>\/XI2\<0\>\/XI2\<1\>\/XI2\<1\>\/XI2\<0\>\/XI2\<0\>\/XI2\<0\>\/XI2\<1\>\/RR6 \
 (  \
 N_SEL6\<0\>_XI2\<1\>\/XI2\<0\>\/XI2\<1\>\/XI2\<1\>\/XI2\<0\>\/XI2\<0\>\/XI2\<0\>\/XI2\<1\>\/RR6_pos \
 N_WLSEL\<1422\>_XI2\<1\>\/XI2\<0\>\/XI2\<1\>\/XI2\<1\>\/XI2\<0\>\/XI2\<0\>\/XI2\<0\>\/XI2\<1\>\/RR6_neg \
 ) R_1X_LL w=1e-07 l=1e-07   res=0.149966
XXI2\<1\>\/XI2\<0\>\/XI2\<1\>\/XI2\<1\>\/XI2\<0\>\/XI2\<0\>\/XI2\<0\>\/XI2\<1\>\/RR5 \
 (  \
 N_SEL7\<1\>_XI2\<1\>\/XI2\<0\>\/XI2\<1\>\/XI2\<1\>\/XI2\<0\>\/XI2\<0\>\/XI2\<0\>\/XI2\<1\>\/RR5_pos \
 N_WLSEL\<1423\>_XI2\<1\>\/XI2\<0\>\/XI2\<1\>\/XI2\<1\>\/XI2\<0\>\/XI2\<0\>\/XI2\<0\>\/XI2\<1\>\/RR5_neg \
 ) R_1X_LL w=1e-07 l=1e-07   res=0.149966
XXI2\<1\>\/XI2\<0\>\/XI2\<1\>\/XI2\<1\>\/XI2\<0\>\/XI2\<0\>\/XI2\<1\>\/XI2\<0\>\/RR0 \
 (  \
 N_SEL0\<0\>_XI2\<1\>\/XI2\<0\>\/XI2\<1\>\/XI2\<1\>\/XI2\<0\>\/XI2\<0\>\/XI2\<1\>\/XI2\<0\>\/RR0_pos \
 N_WLSEL\<1424\>_XI2\<1\>\/XI2\<0\>\/XI2\<1\>\/XI2\<1\>\/XI2\<0\>\/XI2\<0\>\/XI2\<1\>\/XI2\<0\>\/RR0_neg \
 ) R_1X_LL w=1e-07 l=1e-07   res=0.149966
XXI2\<1\>\/XI2\<0\>\/XI2\<1\>\/XI2\<1\>\/XI2\<0\>\/XI2\<0\>\/XI2\<1\>\/XI2\<0\>\/RR1 \
 (  \
 N_SEL1\<1\>_XI2\<1\>\/XI2\<0\>\/XI2\<1\>\/XI2\<1\>\/XI2\<0\>\/XI2\<0\>\/XI2\<1\>\/XI2\<0\>\/RR1_pos \
 N_WLSEL\<1425\>_XI2\<1\>\/XI2\<0\>\/XI2\<1\>\/XI2\<1\>\/XI2\<0\>\/XI2\<0\>\/XI2\<1\>\/XI2\<0\>\/RR1_neg \
 ) R_1X_LL w=1e-07 l=1e-07   res=0.149966
XXI2\<1\>\/XI2\<0\>\/XI2\<1\>\/XI2\<1\>\/XI2\<0\>\/XI2\<0\>\/XI2\<1\>\/XI2\<0\>\/RR2 \
 (  \
 N_SEL2\<0\>_XI2\<1\>\/XI2\<0\>\/XI2\<1\>\/XI2\<1\>\/XI2\<0\>\/XI2\<0\>\/XI2\<1\>\/XI2\<0\>\/RR2_pos \
 N_WLSEL\<1426\>_XI2\<1\>\/XI2\<0\>\/XI2\<1\>\/XI2\<1\>\/XI2\<0\>\/XI2\<0\>\/XI2\<1\>\/XI2\<0\>\/RR2_neg \
 ) R_1X_LL w=1e-07 l=1e-07   res=0.149966
XXI2\<1\>\/XI2\<0\>\/XI2\<1\>\/XI2\<1\>\/XI2\<0\>\/XI2\<0\>\/XI2\<1\>\/XI2\<0\>\/RR3 \
 (  \
 N_SEL3\<0\>_XI2\<1\>\/XI2\<0\>\/XI2\<1\>\/XI2\<1\>\/XI2\<0\>\/XI2\<0\>\/XI2\<1\>\/XI2\<0\>\/RR3_pos \
 N_WLSEL\<1427\>_XI2\<1\>\/XI2\<0\>\/XI2\<1\>\/XI2\<1\>\/XI2\<0\>\/XI2\<0\>\/XI2\<1\>\/XI2\<0\>\/RR3_neg \
 ) R_1X_LL w=1e-07 l=1e-07   res=0.149966
XXI2\<1\>\/XI2\<0\>\/XI2\<1\>\/XI2\<1\>\/XI2\<0\>\/XI2\<0\>\/XI2\<1\>\/XI2\<0\>\/RR4 \
 (  \
 N_SEL4\<1\>_XI2\<1\>\/XI2\<0\>\/XI2\<1\>\/XI2\<1\>\/XI2\<0\>\/XI2\<0\>\/XI2\<1\>\/XI2\<0\>\/RR4_pos \
 N_WLSEL\<1428\>_XI2\<1\>\/XI2\<0\>\/XI2\<1\>\/XI2\<1\>\/XI2\<0\>\/XI2\<0\>\/XI2\<1\>\/XI2\<0\>\/RR4_neg \
 ) R_1X_LL w=1e-07 l=1e-07   res=0.149966
XXI2\<1\>\/XI2\<0\>\/XI2\<1\>\/XI2\<1\>\/XI2\<0\>\/XI2\<0\>\/XI2\<1\>\/XI2\<0\>\/RR7 \
 (  \
 N_SEL5\<1\>_XI2\<1\>\/XI2\<0\>\/XI2\<1\>\/XI2\<1\>\/XI2\<0\>\/XI2\<0\>\/XI2\<1\>\/XI2\<0\>\/RR7_pos \
 N_WLSEL\<1429\>_XI2\<1\>\/XI2\<0\>\/XI2\<1\>\/XI2\<1\>\/XI2\<0\>\/XI2\<0\>\/XI2\<1\>\/XI2\<0\>\/RR7_neg \
 ) R_1X_LL w=1e-07 l=1e-07   res=0.149966
XXI2\<1\>\/XI2\<0\>\/XI2\<1\>\/XI2\<1\>\/XI2\<0\>\/XI2\<0\>\/XI2\<1\>\/XI2\<0\>\/RR6 \
 (  \
 N_SEL6\<0\>_XI2\<1\>\/XI2\<0\>\/XI2\<1\>\/XI2\<1\>\/XI2\<0\>\/XI2\<0\>\/XI2\<1\>\/XI2\<0\>\/RR6_pos \
 N_WLSEL\<1430\>_XI2\<1\>\/XI2\<0\>\/XI2\<1\>\/XI2\<1\>\/XI2\<0\>\/XI2\<0\>\/XI2\<1\>\/XI2\<0\>\/RR6_neg \
 ) R_1X_LL w=1e-07 l=1e-07   res=0.149966
XXI2\<1\>\/XI2\<0\>\/XI2\<1\>\/XI2\<1\>\/XI2\<0\>\/XI2\<0\>\/XI2\<1\>\/XI2\<0\>\/RR5 \
 (  \
 N_SEL7\<1\>_XI2\<1\>\/XI2\<0\>\/XI2\<1\>\/XI2\<1\>\/XI2\<0\>\/XI2\<0\>\/XI2\<1\>\/XI2\<0\>\/RR5_pos \
 N_WLSEL\<1431\>_XI2\<1\>\/XI2\<0\>\/XI2\<1\>\/XI2\<1\>\/XI2\<0\>\/XI2\<0\>\/XI2\<1\>\/XI2\<0\>\/RR5_neg \
 ) R_1X_LL w=1e-07 l=1e-07   res=0.149966
XXI2\<1\>\/XI2\<0\>\/XI2\<1\>\/XI2\<1\>\/XI2\<0\>\/XI2\<0\>\/XI2\<1\>\/XI2\<1\>\/RR0 \
 (  \
 N_SEL0\<1\>_XI2\<1\>\/XI2\<0\>\/XI2\<1\>\/XI2\<1\>\/XI2\<0\>\/XI2\<0\>\/XI2\<1\>\/XI2\<1\>\/RR0_pos \
 N_WLSEL\<1432\>_XI2\<1\>\/XI2\<0\>\/XI2\<1\>\/XI2\<1\>\/XI2\<0\>\/XI2\<0\>\/XI2\<1\>\/XI2\<1\>\/RR0_neg \
 ) R_1X_LL w=1e-07 l=1e-07   res=0.149966
XXI2\<1\>\/XI2\<0\>\/XI2\<1\>\/XI2\<1\>\/XI2\<0\>\/XI2\<0\>\/XI2\<1\>\/XI2\<1\>\/RR1 \
 (  \
 N_SEL1\<1\>_XI2\<1\>\/XI2\<0\>\/XI2\<1\>\/XI2\<1\>\/XI2\<0\>\/XI2\<0\>\/XI2\<1\>\/XI2\<1\>\/RR1_pos \
 N_WLSEL\<1433\>_XI2\<1\>\/XI2\<0\>\/XI2\<1\>\/XI2\<1\>\/XI2\<0\>\/XI2\<0\>\/XI2\<1\>\/XI2\<1\>\/RR1_neg \
 ) R_1X_LL w=1e-07 l=1e-07   res=0.149966
XXI2\<1\>\/XI2\<0\>\/XI2\<1\>\/XI2\<1\>\/XI2\<0\>\/XI2\<0\>\/XI2\<1\>\/XI2\<1\>\/RR2 \
 (  \
 N_SEL2\<0\>_XI2\<1\>\/XI2\<0\>\/XI2\<1\>\/XI2\<1\>\/XI2\<0\>\/XI2\<0\>\/XI2\<1\>\/XI2\<1\>\/RR2_pos \
 N_WLSEL\<1434\>_XI2\<1\>\/XI2\<0\>\/XI2\<1\>\/XI2\<1\>\/XI2\<0\>\/XI2\<0\>\/XI2\<1\>\/XI2\<1\>\/RR2_neg \
 ) R_1X_LL w=1e-07 l=1e-07   res=0.149966
XXI2\<1\>\/XI2\<0\>\/XI2\<1\>\/XI2\<1\>\/XI2\<0\>\/XI2\<0\>\/XI2\<1\>\/XI2\<1\>\/RR3 \
 (  \
 N_SEL3\<0\>_XI2\<1\>\/XI2\<0\>\/XI2\<1\>\/XI2\<1\>\/XI2\<0\>\/XI2\<0\>\/XI2\<1\>\/XI2\<1\>\/RR3_pos \
 N_WLSEL\<1435\>_XI2\<1\>\/XI2\<0\>\/XI2\<1\>\/XI2\<1\>\/XI2\<0\>\/XI2\<0\>\/XI2\<1\>\/XI2\<1\>\/RR3_neg \
 ) R_1X_LL w=1e-07 l=1e-07   res=0.149966
XXI2\<1\>\/XI2\<0\>\/XI2\<1\>\/XI2\<1\>\/XI2\<0\>\/XI2\<0\>\/XI2\<1\>\/XI2\<1\>\/RR4 \
 (  \
 N_SEL4\<1\>_XI2\<1\>\/XI2\<0\>\/XI2\<1\>\/XI2\<1\>\/XI2\<0\>\/XI2\<0\>\/XI2\<1\>\/XI2\<1\>\/RR4_pos \
 N_WLSEL\<1436\>_XI2\<1\>\/XI2\<0\>\/XI2\<1\>\/XI2\<1\>\/XI2\<0\>\/XI2\<0\>\/XI2\<1\>\/XI2\<1\>\/RR4_neg \
 ) R_1X_LL w=1e-07 l=1e-07   res=0.149966
XXI2\<1\>\/XI2\<0\>\/XI2\<1\>\/XI2\<1\>\/XI2\<0\>\/XI2\<0\>\/XI2\<1\>\/XI2\<1\>\/RR7 \
 (  \
 N_SEL5\<1\>_XI2\<1\>\/XI2\<0\>\/XI2\<1\>\/XI2\<1\>\/XI2\<0\>\/XI2\<0\>\/XI2\<1\>\/XI2\<1\>\/RR7_pos \
 N_WLSEL\<1437\>_XI2\<1\>\/XI2\<0\>\/XI2\<1\>\/XI2\<1\>\/XI2\<0\>\/XI2\<0\>\/XI2\<1\>\/XI2\<1\>\/RR7_neg \
 ) R_1X_LL w=1e-07 l=1e-07   res=0.149966
XXI2\<1\>\/XI2\<0\>\/XI2\<1\>\/XI2\<1\>\/XI2\<0\>\/XI2\<0\>\/XI2\<1\>\/XI2\<1\>\/RR6 \
 (  \
 N_SEL6\<0\>_XI2\<1\>\/XI2\<0\>\/XI2\<1\>\/XI2\<1\>\/XI2\<0\>\/XI2\<0\>\/XI2\<1\>\/XI2\<1\>\/RR6_pos \
 N_WLSEL\<1438\>_XI2\<1\>\/XI2\<0\>\/XI2\<1\>\/XI2\<1\>\/XI2\<0\>\/XI2\<0\>\/XI2\<1\>\/XI2\<1\>\/RR6_neg \
 ) R_1X_LL w=1e-07 l=1e-07   res=0.149966
XXI2\<1\>\/XI2\<0\>\/XI2\<1\>\/XI2\<1\>\/XI2\<0\>\/XI2\<0\>\/XI2\<1\>\/XI2\<1\>\/RR5 \
 (  \
 N_SEL7\<1\>_XI2\<1\>\/XI2\<0\>\/XI2\<1\>\/XI2\<1\>\/XI2\<0\>\/XI2\<0\>\/XI2\<1\>\/XI2\<1\>\/RR5_pos \
 N_WLSEL\<1439\>_XI2\<1\>\/XI2\<0\>\/XI2\<1\>\/XI2\<1\>\/XI2\<0\>\/XI2\<0\>\/XI2\<1\>\/XI2\<1\>\/RR5_neg \
 ) R_1X_LL w=1e-07 l=1e-07   res=0.149966
XXI2\<1\>\/XI2\<0\>\/XI2\<1\>\/XI2\<1\>\/XI2\<0\>\/XI2\<1\>\/XI2\<0\>\/XI2\<0\>\/RR0 \
 (  \
 N_SEL0\<0\>_XI2\<1\>\/XI2\<0\>\/XI2\<1\>\/XI2\<1\>\/XI2\<0\>\/XI2\<1\>\/XI2\<0\>\/XI2\<0\>\/RR0_pos \
 N_WLSEL\<1440\>_XI2\<1\>\/XI2\<0\>\/XI2\<1\>\/XI2\<1\>\/XI2\<0\>\/XI2\<1\>\/XI2\<0\>\/XI2\<0\>\/RR0_neg \
 ) R_1X_LL w=1e-07 l=1e-07   res=0.149966
XXI2\<1\>\/XI2\<0\>\/XI2\<1\>\/XI2\<1\>\/XI2\<0\>\/XI2\<1\>\/XI2\<0\>\/XI2\<0\>\/RR1 \
 (  \
 N_SEL1\<0\>_XI2\<1\>\/XI2\<0\>\/XI2\<1\>\/XI2\<1\>\/XI2\<0\>\/XI2\<1\>\/XI2\<0\>\/XI2\<0\>\/RR1_pos \
 N_WLSEL\<1441\>_XI2\<1\>\/XI2\<0\>\/XI2\<1\>\/XI2\<1\>\/XI2\<0\>\/XI2\<1\>\/XI2\<0\>\/XI2\<0\>\/RR1_neg \
 ) R_1X_LL w=1e-07 l=1e-07   res=0.149966
XXI2\<1\>\/XI2\<0\>\/XI2\<1\>\/XI2\<1\>\/XI2\<0\>\/XI2\<1\>\/XI2\<0\>\/XI2\<0\>\/RR2 \
 (  \
 N_SEL2\<1\>_XI2\<1\>\/XI2\<0\>\/XI2\<1\>\/XI2\<1\>\/XI2\<0\>\/XI2\<1\>\/XI2\<0\>\/XI2\<0\>\/RR2_pos \
 N_WLSEL\<1442\>_XI2\<1\>\/XI2\<0\>\/XI2\<1\>\/XI2\<1\>\/XI2\<0\>\/XI2\<1\>\/XI2\<0\>\/XI2\<0\>\/RR2_neg \
 ) R_1X_LL w=1e-07 l=1e-07   res=0.149966
XXI2\<1\>\/XI2\<0\>\/XI2\<1\>\/XI2\<1\>\/XI2\<0\>\/XI2\<1\>\/XI2\<0\>\/XI2\<0\>\/RR3 \
 (  \
 N_SEL3\<0\>_XI2\<1\>\/XI2\<0\>\/XI2\<1\>\/XI2\<1\>\/XI2\<0\>\/XI2\<1\>\/XI2\<0\>\/XI2\<0\>\/RR3_pos \
 N_WLSEL\<1443\>_XI2\<1\>\/XI2\<0\>\/XI2\<1\>\/XI2\<1\>\/XI2\<0\>\/XI2\<1\>\/XI2\<0\>\/XI2\<0\>\/RR3_neg \
 ) R_1X_LL w=1e-07 l=1e-07   res=0.149966
XXI2\<1\>\/XI2\<0\>\/XI2\<1\>\/XI2\<1\>\/XI2\<0\>\/XI2\<1\>\/XI2\<0\>\/XI2\<0\>\/RR4 \
 (  \
 N_SEL4\<1\>_XI2\<1\>\/XI2\<0\>\/XI2\<1\>\/XI2\<1\>\/XI2\<0\>\/XI2\<1\>\/XI2\<0\>\/XI2\<0\>\/RR4_pos \
 N_WLSEL\<1444\>_XI2\<1\>\/XI2\<0\>\/XI2\<1\>\/XI2\<1\>\/XI2\<0\>\/XI2\<1\>\/XI2\<0\>\/XI2\<0\>\/RR4_neg \
 ) R_1X_LL w=1e-07 l=1e-07   res=0.149966
XXI2\<1\>\/XI2\<0\>\/XI2\<1\>\/XI2\<1\>\/XI2\<0\>\/XI2\<1\>\/XI2\<0\>\/XI2\<0\>\/RR7 \
 (  \
 N_SEL5\<1\>_XI2\<1\>\/XI2\<0\>\/XI2\<1\>\/XI2\<1\>\/XI2\<0\>\/XI2\<1\>\/XI2\<0\>\/XI2\<0\>\/RR7_pos \
 N_WLSEL\<1445\>_XI2\<1\>\/XI2\<0\>\/XI2\<1\>\/XI2\<1\>\/XI2\<0\>\/XI2\<1\>\/XI2\<0\>\/XI2\<0\>\/RR7_neg \
 ) R_1X_LL w=1e-07 l=1e-07   res=0.149966
XXI2\<1\>\/XI2\<0\>\/XI2\<1\>\/XI2\<1\>\/XI2\<0\>\/XI2\<1\>\/XI2\<0\>\/XI2\<0\>\/RR6 \
 (  \
 N_SEL6\<0\>_XI2\<1\>\/XI2\<0\>\/XI2\<1\>\/XI2\<1\>\/XI2\<0\>\/XI2\<1\>\/XI2\<0\>\/XI2\<0\>\/RR6_pos \
 N_WLSEL\<1446\>_XI2\<1\>\/XI2\<0\>\/XI2\<1\>\/XI2\<1\>\/XI2\<0\>\/XI2\<1\>\/XI2\<0\>\/XI2\<0\>\/RR6_neg \
 ) R_1X_LL w=1e-07 l=1e-07   res=0.149966
XXI2\<1\>\/XI2\<0\>\/XI2\<1\>\/XI2\<1\>\/XI2\<0\>\/XI2\<1\>\/XI2\<0\>\/XI2\<0\>\/RR5 \
 (  \
 N_SEL7\<1\>_XI2\<1\>\/XI2\<0\>\/XI2\<1\>\/XI2\<1\>\/XI2\<0\>\/XI2\<1\>\/XI2\<0\>\/XI2\<0\>\/RR5_pos \
 N_WLSEL\<1447\>_XI2\<1\>\/XI2\<0\>\/XI2\<1\>\/XI2\<1\>\/XI2\<0\>\/XI2\<1\>\/XI2\<0\>\/XI2\<0\>\/RR5_neg \
 ) R_1X_LL w=1e-07 l=1e-07   res=0.149966
XXI2\<1\>\/XI2\<0\>\/XI2\<1\>\/XI2\<1\>\/XI2\<0\>\/XI2\<1\>\/XI2\<0\>\/XI2\<1\>\/RR0 \
 (  \
 N_SEL0\<1\>_XI2\<1\>\/XI2\<0\>\/XI2\<1\>\/XI2\<1\>\/XI2\<0\>\/XI2\<1\>\/XI2\<0\>\/XI2\<1\>\/RR0_pos \
 N_WLSEL\<1448\>_XI2\<1\>\/XI2\<0\>\/XI2\<1\>\/XI2\<1\>\/XI2\<0\>\/XI2\<1\>\/XI2\<0\>\/XI2\<1\>\/RR0_neg \
 ) R_1X_LL w=1e-07 l=1e-07   res=0.149966
XXI2\<1\>\/XI2\<0\>\/XI2\<1\>\/XI2\<1\>\/XI2\<0\>\/XI2\<1\>\/XI2\<0\>\/XI2\<1\>\/RR1 \
 (  \
 N_SEL1\<0\>_XI2\<1\>\/XI2\<0\>\/XI2\<1\>\/XI2\<1\>\/XI2\<0\>\/XI2\<1\>\/XI2\<0\>\/XI2\<1\>\/RR1_pos \
 N_WLSEL\<1449\>_XI2\<1\>\/XI2\<0\>\/XI2\<1\>\/XI2\<1\>\/XI2\<0\>\/XI2\<1\>\/XI2\<0\>\/XI2\<1\>\/RR1_neg \
 ) R_1X_LL w=1e-07 l=1e-07   res=0.149966
XXI2\<1\>\/XI2\<0\>\/XI2\<1\>\/XI2\<1\>\/XI2\<0\>\/XI2\<1\>\/XI2\<0\>\/XI2\<1\>\/RR2 \
 (  \
 N_SEL2\<1\>_XI2\<1\>\/XI2\<0\>\/XI2\<1\>\/XI2\<1\>\/XI2\<0\>\/XI2\<1\>\/XI2\<0\>\/XI2\<1\>\/RR2_pos \
 N_WLSEL\<1450\>_XI2\<1\>\/XI2\<0\>\/XI2\<1\>\/XI2\<1\>\/XI2\<0\>\/XI2\<1\>\/XI2\<0\>\/XI2\<1\>\/RR2_neg \
 ) R_1X_LL w=1e-07 l=1e-07   res=0.149966
XXI2\<1\>\/XI2\<0\>\/XI2\<1\>\/XI2\<1\>\/XI2\<0\>\/XI2\<1\>\/XI2\<0\>\/XI2\<1\>\/RR3 \
 (  \
 N_SEL3\<0\>_XI2\<1\>\/XI2\<0\>\/XI2\<1\>\/XI2\<1\>\/XI2\<0\>\/XI2\<1\>\/XI2\<0\>\/XI2\<1\>\/RR3_pos \
 N_WLSEL\<1451\>_XI2\<1\>\/XI2\<0\>\/XI2\<1\>\/XI2\<1\>\/XI2\<0\>\/XI2\<1\>\/XI2\<0\>\/XI2\<1\>\/RR3_neg \
 ) R_1X_LL w=1e-07 l=1e-07   res=0.149966
XXI2\<1\>\/XI2\<0\>\/XI2\<1\>\/XI2\<1\>\/XI2\<0\>\/XI2\<1\>\/XI2\<0\>\/XI2\<1\>\/RR4 \
 (  \
 N_SEL4\<1\>_XI2\<1\>\/XI2\<0\>\/XI2\<1\>\/XI2\<1\>\/XI2\<0\>\/XI2\<1\>\/XI2\<0\>\/XI2\<1\>\/RR4_pos \
 N_WLSEL\<1452\>_XI2\<1\>\/XI2\<0\>\/XI2\<1\>\/XI2\<1\>\/XI2\<0\>\/XI2\<1\>\/XI2\<0\>\/XI2\<1\>\/RR4_neg \
 ) R_1X_LL w=1e-07 l=1e-07   res=0.149966
XXI2\<1\>\/XI2\<0\>\/XI2\<1\>\/XI2\<1\>\/XI2\<0\>\/XI2\<1\>\/XI2\<0\>\/XI2\<1\>\/RR7 \
 (  \
 N_SEL5\<1\>_XI2\<1\>\/XI2\<0\>\/XI2\<1\>\/XI2\<1\>\/XI2\<0\>\/XI2\<1\>\/XI2\<0\>\/XI2\<1\>\/RR7_pos \
 N_WLSEL\<1453\>_XI2\<1\>\/XI2\<0\>\/XI2\<1\>\/XI2\<1\>\/XI2\<0\>\/XI2\<1\>\/XI2\<0\>\/XI2\<1\>\/RR7_neg \
 ) R_1X_LL w=1e-07 l=1e-07   res=0.149966
XXI2\<1\>\/XI2\<0\>\/XI2\<1\>\/XI2\<1\>\/XI2\<0\>\/XI2\<1\>\/XI2\<0\>\/XI2\<1\>\/RR6 \
 (  \
 N_SEL6\<0\>_XI2\<1\>\/XI2\<0\>\/XI2\<1\>\/XI2\<1\>\/XI2\<0\>\/XI2\<1\>\/XI2\<0\>\/XI2\<1\>\/RR6_pos \
 N_WLSEL\<1454\>_XI2\<1\>\/XI2\<0\>\/XI2\<1\>\/XI2\<1\>\/XI2\<0\>\/XI2\<1\>\/XI2\<0\>\/XI2\<1\>\/RR6_neg \
 ) R_1X_LL w=1e-07 l=1e-07   res=0.149966
XXI2\<0\>\/XI2\<1\>\/XI2\<1\>\/XI2\<0\>\/XI2\<1\>\/XI2\<0\>\/XI2\<1\>\/XI2\<1\>\/RR5 \
 (  \
 N_SEL7\<0\>_XI2\<0\>\/XI2\<1\>\/XI2\<1\>\/XI2\<0\>\/XI2\<1\>\/XI2\<0\>\/XI2\<1\>\/XI2\<1\>\/RR5_pos \
 N_WLSEL\<863\>_XI2\<0\>\/XI2\<1\>\/XI2\<1\>\/XI2\<0\>\/XI2\<1\>\/XI2\<0\>\/XI2\<1\>\/XI2\<1\>\/RR5_neg \
 ) R_1X_LL w=1e-07 l=1e-07   res=0.149966
XXI2\<0\>\/XI2\<1\>\/XI2\<1\>\/XI2\<0\>\/XI2\<1\>\/XI2\<1\>\/XI2\<0\>\/XI2\<0\>\/RR0 \
 (  \
 N_SEL0\<0\>_XI2\<0\>\/XI2\<1\>\/XI2\<1\>\/XI2\<0\>\/XI2\<1\>\/XI2\<1\>\/XI2\<0\>\/XI2\<0\>\/RR0_pos \
 N_WLSEL\<864\>_XI2\<0\>\/XI2\<1\>\/XI2\<1\>\/XI2\<0\>\/XI2\<1\>\/XI2\<1\>\/XI2\<0\>\/XI2\<0\>\/RR0_neg \
 ) R_1X_LL w=1e-07 l=1e-07   res=0.149966
XXI2\<0\>\/XI2\<1\>\/XI2\<1\>\/XI2\<0\>\/XI2\<1\>\/XI2\<1\>\/XI2\<0\>\/XI2\<0\>\/RR1 \
 (  \
 N_SEL1\<0\>_XI2\<0\>\/XI2\<1\>\/XI2\<1\>\/XI2\<0\>\/XI2\<1\>\/XI2\<1\>\/XI2\<0\>\/XI2\<0\>\/RR1_pos \
 N_WLSEL\<865\>_XI2\<0\>\/XI2\<1\>\/XI2\<1\>\/XI2\<0\>\/XI2\<1\>\/XI2\<1\>\/XI2\<0\>\/XI2\<0\>\/RR1_neg \
 ) R_1X_LL w=1e-07 l=1e-07   res=0.149966
XXI2\<0\>\/XI2\<1\>\/XI2\<1\>\/XI2\<0\>\/XI2\<1\>\/XI2\<1\>\/XI2\<0\>\/XI2\<0\>\/RR2 \
 (  \
 N_SEL2\<1\>_XI2\<0\>\/XI2\<1\>\/XI2\<1\>\/XI2\<0\>\/XI2\<1\>\/XI2\<1\>\/XI2\<0\>\/XI2\<0\>\/RR2_pos \
 N_WLSEL\<866\>_XI2\<0\>\/XI2\<1\>\/XI2\<1\>\/XI2\<0\>\/XI2\<1\>\/XI2\<1\>\/XI2\<0\>\/XI2\<0\>\/RR2_neg \
 ) R_1X_LL w=1e-07 l=1e-07   res=0.149966
XXI2\<0\>\/XI2\<1\>\/XI2\<1\>\/XI2\<0\>\/XI2\<1\>\/XI2\<1\>\/XI2\<0\>\/XI2\<0\>\/RR3 \
 (  \
 N_SEL3\<1\>_XI2\<0\>\/XI2\<1\>\/XI2\<1\>\/XI2\<0\>\/XI2\<1\>\/XI2\<1\>\/XI2\<0\>\/XI2\<0\>\/RR3_pos \
 N_WLSEL\<867\>_XI2\<0\>\/XI2\<1\>\/XI2\<1\>\/XI2\<0\>\/XI2\<1\>\/XI2\<1\>\/XI2\<0\>\/XI2\<0\>\/RR3_neg \
 ) R_1X_LL w=1e-07 l=1e-07   res=0.149966
XXI2\<0\>\/XI2\<1\>\/XI2\<1\>\/XI2\<0\>\/XI2\<1\>\/XI2\<1\>\/XI2\<0\>\/XI2\<0\>\/RR4 \
 (  \
 N_SEL4\<0\>_XI2\<0\>\/XI2\<1\>\/XI2\<1\>\/XI2\<0\>\/XI2\<1\>\/XI2\<1\>\/XI2\<0\>\/XI2\<0\>\/RR4_pos \
 N_WLSEL\<868\>_XI2\<0\>\/XI2\<1\>\/XI2\<1\>\/XI2\<0\>\/XI2\<1\>\/XI2\<1\>\/XI2\<0\>\/XI2\<0\>\/RR4_neg \
 ) R_1X_LL w=1e-07 l=1e-07   res=0.149966
XXI2\<0\>\/XI2\<1\>\/XI2\<1\>\/XI2\<0\>\/XI2\<1\>\/XI2\<1\>\/XI2\<0\>\/XI2\<0\>\/RR7 \
 (  \
 N_SEL5\<1\>_XI2\<0\>\/XI2\<1\>\/XI2\<1\>\/XI2\<0\>\/XI2\<1\>\/XI2\<1\>\/XI2\<0\>\/XI2\<0\>\/RR7_pos \
 N_WLSEL\<869\>_XI2\<0\>\/XI2\<1\>\/XI2\<1\>\/XI2\<0\>\/XI2\<1\>\/XI2\<1\>\/XI2\<0\>\/XI2\<0\>\/RR7_neg \
 ) R_1X_LL w=1e-07 l=1e-07   res=0.149966
XXI2\<0\>\/XI2\<1\>\/XI2\<1\>\/XI2\<0\>\/XI2\<1\>\/XI2\<1\>\/XI2\<0\>\/XI2\<0\>\/RR6 \
 (  \
 N_SEL6\<1\>_XI2\<0\>\/XI2\<1\>\/XI2\<1\>\/XI2\<0\>\/XI2\<1\>\/XI2\<1\>\/XI2\<0\>\/XI2\<0\>\/RR6_pos \
 N_WLSEL\<870\>_XI2\<0\>\/XI2\<1\>\/XI2\<1\>\/XI2\<0\>\/XI2\<1\>\/XI2\<1\>\/XI2\<0\>\/XI2\<0\>\/RR6_neg \
 ) R_1X_LL w=1e-07 l=1e-07   res=0.149966
XXI2\<0\>\/XI2\<1\>\/XI2\<1\>\/XI2\<0\>\/XI2\<1\>\/XI2\<1\>\/XI2\<0\>\/XI2\<0\>\/RR5 \
 (  \
 N_SEL7\<0\>_XI2\<0\>\/XI2\<1\>\/XI2\<1\>\/XI2\<0\>\/XI2\<1\>\/XI2\<1\>\/XI2\<0\>\/XI2\<0\>\/RR5_pos \
 N_WLSEL\<871\>_XI2\<0\>\/XI2\<1\>\/XI2\<1\>\/XI2\<0\>\/XI2\<1\>\/XI2\<1\>\/XI2\<0\>\/XI2\<0\>\/RR5_neg \
 ) R_1X_LL w=1e-07 l=1e-07   res=0.149966
XXI2\<0\>\/XI2\<1\>\/XI2\<1\>\/XI2\<0\>\/XI2\<1\>\/XI2\<1\>\/XI2\<0\>\/XI2\<1\>\/RR0 \
 (  \
 N_SEL0\<1\>_XI2\<0\>\/XI2\<1\>\/XI2\<1\>\/XI2\<0\>\/XI2\<1\>\/XI2\<1\>\/XI2\<0\>\/XI2\<1\>\/RR0_pos \
 N_WLSEL\<872\>_XI2\<0\>\/XI2\<1\>\/XI2\<1\>\/XI2\<0\>\/XI2\<1\>\/XI2\<1\>\/XI2\<0\>\/XI2\<1\>\/RR0_neg \
 ) R_1X_LL w=1e-07 l=1e-07   res=0.149966
XXI2\<0\>\/XI2\<1\>\/XI2\<1\>\/XI2\<0\>\/XI2\<1\>\/XI2\<1\>\/XI2\<0\>\/XI2\<1\>\/RR1 \
 (  \
 N_SEL1\<0\>_XI2\<0\>\/XI2\<1\>\/XI2\<1\>\/XI2\<0\>\/XI2\<1\>\/XI2\<1\>\/XI2\<0\>\/XI2\<1\>\/RR1_pos \
 N_WLSEL\<873\>_XI2\<0\>\/XI2\<1\>\/XI2\<1\>\/XI2\<0\>\/XI2\<1\>\/XI2\<1\>\/XI2\<0\>\/XI2\<1\>\/RR1_neg \
 ) R_1X_LL w=1e-07 l=1e-07   res=0.149966
XXI2\<0\>\/XI2\<1\>\/XI2\<1\>\/XI2\<0\>\/XI2\<1\>\/XI2\<1\>\/XI2\<0\>\/XI2\<1\>\/RR2 \
 (  \
 N_SEL2\<1\>_XI2\<0\>\/XI2\<1\>\/XI2\<1\>\/XI2\<0\>\/XI2\<1\>\/XI2\<1\>\/XI2\<0\>\/XI2\<1\>\/RR2_pos \
 N_WLSEL\<874\>_XI2\<0\>\/XI2\<1\>\/XI2\<1\>\/XI2\<0\>\/XI2\<1\>\/XI2\<1\>\/XI2\<0\>\/XI2\<1\>\/RR2_neg \
 ) R_1X_LL w=1e-07 l=1e-07   res=0.149966
XXI2\<0\>\/XI2\<1\>\/XI2\<1\>\/XI2\<0\>\/XI2\<1\>\/XI2\<1\>\/XI2\<0\>\/XI2\<1\>\/RR3 \
 (  \
 N_SEL3\<1\>_XI2\<0\>\/XI2\<1\>\/XI2\<1\>\/XI2\<0\>\/XI2\<1\>\/XI2\<1\>\/XI2\<0\>\/XI2\<1\>\/RR3_pos \
 N_WLSEL\<875\>_XI2\<0\>\/XI2\<1\>\/XI2\<1\>\/XI2\<0\>\/XI2\<1\>\/XI2\<1\>\/XI2\<0\>\/XI2\<1\>\/RR3_neg \
 ) R_1X_LL w=1e-07 l=1e-07   res=0.149966
XXI2\<0\>\/XI2\<1\>\/XI2\<1\>\/XI2\<0\>\/XI2\<1\>\/XI2\<1\>\/XI2\<0\>\/XI2\<1\>\/RR4 \
 (  \
 N_SEL4\<0\>_XI2\<0\>\/XI2\<1\>\/XI2\<1\>\/XI2\<0\>\/XI2\<1\>\/XI2\<1\>\/XI2\<0\>\/XI2\<1\>\/RR4_pos \
 N_WLSEL\<876\>_XI2\<0\>\/XI2\<1\>\/XI2\<1\>\/XI2\<0\>\/XI2\<1\>\/XI2\<1\>\/XI2\<0\>\/XI2\<1\>\/RR4_neg \
 ) R_1X_LL w=1e-07 l=1e-07   res=0.149966
XXI2\<0\>\/XI2\<1\>\/XI2\<1\>\/XI2\<0\>\/XI2\<1\>\/XI2\<1\>\/XI2\<0\>\/XI2\<1\>\/RR7 \
 (  \
 N_SEL5\<1\>_XI2\<0\>\/XI2\<1\>\/XI2\<1\>\/XI2\<0\>\/XI2\<1\>\/XI2\<1\>\/XI2\<0\>\/XI2\<1\>\/RR7_pos \
 N_WLSEL\<877\>_XI2\<0\>\/XI2\<1\>\/XI2\<1\>\/XI2\<0\>\/XI2\<1\>\/XI2\<1\>\/XI2\<0\>\/XI2\<1\>\/RR7_neg \
 ) R_1X_LL w=1e-07 l=1e-07   res=0.149966
XXI2\<0\>\/XI2\<1\>\/XI2\<1\>\/XI2\<0\>\/XI2\<1\>\/XI2\<1\>\/XI2\<0\>\/XI2\<1\>\/RR6 \
 (  \
 N_SEL6\<1\>_XI2\<0\>\/XI2\<1\>\/XI2\<1\>\/XI2\<0\>\/XI2\<1\>\/XI2\<1\>\/XI2\<0\>\/XI2\<1\>\/RR6_pos \
 N_WLSEL\<878\>_XI2\<0\>\/XI2\<1\>\/XI2\<1\>\/XI2\<0\>\/XI2\<1\>\/XI2\<1\>\/XI2\<0\>\/XI2\<1\>\/RR6_neg \
 ) R_1X_LL w=1e-07 l=1e-07   res=0.149966
XXI2\<0\>\/XI2\<1\>\/XI2\<1\>\/XI2\<0\>\/XI2\<1\>\/XI2\<1\>\/XI2\<0\>\/XI2\<1\>\/RR5 \
 (  \
 N_SEL7\<0\>_XI2\<0\>\/XI2\<1\>\/XI2\<1\>\/XI2\<0\>\/XI2\<1\>\/XI2\<1\>\/XI2\<0\>\/XI2\<1\>\/RR5_pos \
 N_WLSEL\<879\>_XI2\<0\>\/XI2\<1\>\/XI2\<1\>\/XI2\<0\>\/XI2\<1\>\/XI2\<1\>\/XI2\<0\>\/XI2\<1\>\/RR5_neg \
 ) R_1X_LL w=1e-07 l=1e-07   res=0.149966
XXI2\<0\>\/XI2\<1\>\/XI2\<1\>\/XI2\<0\>\/XI2\<1\>\/XI2\<1\>\/XI2\<1\>\/XI2\<0\>\/RR0 \
 (  \
 N_SEL0\<0\>_XI2\<0\>\/XI2\<1\>\/XI2\<1\>\/XI2\<0\>\/XI2\<1\>\/XI2\<1\>\/XI2\<1\>\/XI2\<0\>\/RR0_pos \
 N_WLSEL\<880\>_XI2\<0\>\/XI2\<1\>\/XI2\<1\>\/XI2\<0\>\/XI2\<1\>\/XI2\<1\>\/XI2\<1\>\/XI2\<0\>\/RR0_neg \
 ) R_1X_LL w=1e-07 l=1e-07   res=0.149966
XXI2\<0\>\/XI2\<1\>\/XI2\<1\>\/XI2\<0\>\/XI2\<1\>\/XI2\<1\>\/XI2\<1\>\/XI2\<0\>\/RR1 \
 (  \
 N_SEL1\<1\>_XI2\<0\>\/XI2\<1\>\/XI2\<1\>\/XI2\<0\>\/XI2\<1\>\/XI2\<1\>\/XI2\<1\>\/XI2\<0\>\/RR1_pos \
 N_WLSEL\<881\>_XI2\<0\>\/XI2\<1\>\/XI2\<1\>\/XI2\<0\>\/XI2\<1\>\/XI2\<1\>\/XI2\<1\>\/XI2\<0\>\/RR1_neg \
 ) R_1X_LL w=1e-07 l=1e-07   res=0.149966
XXI2\<0\>\/XI2\<1\>\/XI2\<1\>\/XI2\<0\>\/XI2\<1\>\/XI2\<1\>\/XI2\<1\>\/XI2\<0\>\/RR2 \
 (  \
 N_SEL2\<1\>_XI2\<0\>\/XI2\<1\>\/XI2\<1\>\/XI2\<0\>\/XI2\<1\>\/XI2\<1\>\/XI2\<1\>\/XI2\<0\>\/RR2_pos \
 N_WLSEL\<882\>_XI2\<0\>\/XI2\<1\>\/XI2\<1\>\/XI2\<0\>\/XI2\<1\>\/XI2\<1\>\/XI2\<1\>\/XI2\<0\>\/RR2_neg \
 ) R_1X_LL w=1e-07 l=1e-07   res=0.149966
XXI2\<0\>\/XI2\<1\>\/XI2\<1\>\/XI2\<0\>\/XI2\<1\>\/XI2\<1\>\/XI2\<1\>\/XI2\<0\>\/RR3 \
 (  \
 N_SEL3\<1\>_XI2\<0\>\/XI2\<1\>\/XI2\<1\>\/XI2\<0\>\/XI2\<1\>\/XI2\<1\>\/XI2\<1\>\/XI2\<0\>\/RR3_pos \
 N_WLSEL\<883\>_XI2\<0\>\/XI2\<1\>\/XI2\<1\>\/XI2\<0\>\/XI2\<1\>\/XI2\<1\>\/XI2\<1\>\/XI2\<0\>\/RR3_neg \
 ) R_1X_LL w=1e-07 l=1e-07   res=0.149966
XXI2\<0\>\/XI2\<1\>\/XI2\<1\>\/XI2\<0\>\/XI2\<1\>\/XI2\<1\>\/XI2\<1\>\/XI2\<0\>\/RR4 \
 (  \
 N_SEL4\<0\>_XI2\<0\>\/XI2\<1\>\/XI2\<1\>\/XI2\<0\>\/XI2\<1\>\/XI2\<1\>\/XI2\<1\>\/XI2\<0\>\/RR4_pos \
 N_WLSEL\<884\>_XI2\<0\>\/XI2\<1\>\/XI2\<1\>\/XI2\<0\>\/XI2\<1\>\/XI2\<1\>\/XI2\<1\>\/XI2\<0\>\/RR4_neg \
 ) R_1X_LL w=1e-07 l=1e-07   res=0.149966
XXI2\<0\>\/XI2\<1\>\/XI2\<1\>\/XI2\<0\>\/XI2\<1\>\/XI2\<1\>\/XI2\<1\>\/XI2\<0\>\/RR7 \
 (  \
 N_SEL5\<1\>_XI2\<0\>\/XI2\<1\>\/XI2\<1\>\/XI2\<0\>\/XI2\<1\>\/XI2\<1\>\/XI2\<1\>\/XI2\<0\>\/RR7_pos \
 N_WLSEL\<885\>_XI2\<0\>\/XI2\<1\>\/XI2\<1\>\/XI2\<0\>\/XI2\<1\>\/XI2\<1\>\/XI2\<1\>\/XI2\<0\>\/RR7_neg \
 ) R_1X_LL w=1e-07 l=1e-07   res=0.149966
XXI2\<0\>\/XI2\<1\>\/XI2\<1\>\/XI2\<0\>\/XI2\<1\>\/XI2\<1\>\/XI2\<1\>\/XI2\<0\>\/RR6 \
 (  \
 N_SEL6\<1\>_XI2\<0\>\/XI2\<1\>\/XI2\<1\>\/XI2\<0\>\/XI2\<1\>\/XI2\<1\>\/XI2\<1\>\/XI2\<0\>\/RR6_pos \
 N_WLSEL\<886\>_XI2\<0\>\/XI2\<1\>\/XI2\<1\>\/XI2\<0\>\/XI2\<1\>\/XI2\<1\>\/XI2\<1\>\/XI2\<0\>\/RR6_neg \
 ) R_1X_LL w=1e-07 l=1e-07   res=0.149966
XXI2\<0\>\/XI2\<1\>\/XI2\<1\>\/XI2\<0\>\/XI2\<1\>\/XI2\<1\>\/XI2\<1\>\/XI2\<0\>\/RR5 \
 (  \
 N_SEL7\<0\>_XI2\<0\>\/XI2\<1\>\/XI2\<1\>\/XI2\<0\>\/XI2\<1\>\/XI2\<1\>\/XI2\<1\>\/XI2\<0\>\/RR5_pos \
 N_WLSEL\<887\>_XI2\<0\>\/XI2\<1\>\/XI2\<1\>\/XI2\<0\>\/XI2\<1\>\/XI2\<1\>\/XI2\<1\>\/XI2\<0\>\/RR5_neg \
 ) R_1X_LL w=1e-07 l=1e-07   res=0.149966
XXI2\<0\>\/XI2\<1\>\/XI2\<1\>\/XI2\<0\>\/XI2\<1\>\/XI2\<1\>\/XI2\<1\>\/XI2\<1\>\/RR0 \
 (  \
 N_SEL0\<1\>_XI2\<0\>\/XI2\<1\>\/XI2\<1\>\/XI2\<0\>\/XI2\<1\>\/XI2\<1\>\/XI2\<1\>\/XI2\<1\>\/RR0_pos \
 N_WLSEL\<888\>_XI2\<0\>\/XI2\<1\>\/XI2\<1\>\/XI2\<0\>\/XI2\<1\>\/XI2\<1\>\/XI2\<1\>\/XI2\<1\>\/RR0_neg \
 ) R_1X_LL w=1e-07 l=1e-07   res=0.149966
XXI2\<0\>\/XI2\<1\>\/XI2\<1\>\/XI2\<0\>\/XI2\<1\>\/XI2\<1\>\/XI2\<1\>\/XI2\<1\>\/RR1 \
 (  \
 N_SEL1\<1\>_XI2\<0\>\/XI2\<1\>\/XI2\<1\>\/XI2\<0\>\/XI2\<1\>\/XI2\<1\>\/XI2\<1\>\/XI2\<1\>\/RR1_pos \
 N_WLSEL\<889\>_XI2\<0\>\/XI2\<1\>\/XI2\<1\>\/XI2\<0\>\/XI2\<1\>\/XI2\<1\>\/XI2\<1\>\/XI2\<1\>\/RR1_neg \
 ) R_1X_LL w=1e-07 l=1e-07   res=0.149966
XXI2\<0\>\/XI2\<1\>\/XI2\<1\>\/XI2\<0\>\/XI2\<1\>\/XI2\<1\>\/XI2\<1\>\/XI2\<1\>\/RR2 \
 (  \
 N_SEL2\<1\>_XI2\<0\>\/XI2\<1\>\/XI2\<1\>\/XI2\<0\>\/XI2\<1\>\/XI2\<1\>\/XI2\<1\>\/XI2\<1\>\/RR2_pos \
 N_WLSEL\<890\>_XI2\<0\>\/XI2\<1\>\/XI2\<1\>\/XI2\<0\>\/XI2\<1\>\/XI2\<1\>\/XI2\<1\>\/XI2\<1\>\/RR2_neg \
 ) R_1X_LL w=1e-07 l=1e-07   res=0.149966
XXI2\<0\>\/XI2\<1\>\/XI2\<1\>\/XI2\<0\>\/XI2\<1\>\/XI2\<1\>\/XI2\<1\>\/XI2\<1\>\/RR3 \
 (  \
 N_SEL3\<1\>_XI2\<0\>\/XI2\<1\>\/XI2\<1\>\/XI2\<0\>\/XI2\<1\>\/XI2\<1\>\/XI2\<1\>\/XI2\<1\>\/RR3_pos \
 N_WLSEL\<891\>_XI2\<0\>\/XI2\<1\>\/XI2\<1\>\/XI2\<0\>\/XI2\<1\>\/XI2\<1\>\/XI2\<1\>\/XI2\<1\>\/RR3_neg \
 ) R_1X_LL w=1e-07 l=1e-07   res=0.149966
XXI2\<0\>\/XI2\<1\>\/XI2\<1\>\/XI2\<0\>\/XI2\<1\>\/XI2\<1\>\/XI2\<1\>\/XI2\<1\>\/RR4 \
 (  \
 N_SEL4\<0\>_XI2\<0\>\/XI2\<1\>\/XI2\<1\>\/XI2\<0\>\/XI2\<1\>\/XI2\<1\>\/XI2\<1\>\/XI2\<1\>\/RR4_pos \
 N_WLSEL\<892\>_XI2\<0\>\/XI2\<1\>\/XI2\<1\>\/XI2\<0\>\/XI2\<1\>\/XI2\<1\>\/XI2\<1\>\/XI2\<1\>\/RR4_neg \
 ) R_1X_LL w=1e-07 l=1e-07   res=0.149966
XXI2\<0\>\/XI2\<1\>\/XI2\<1\>\/XI2\<0\>\/XI2\<1\>\/XI2\<1\>\/XI2\<1\>\/XI2\<1\>\/RR7 \
 (  \
 N_SEL5\<1\>_XI2\<0\>\/XI2\<1\>\/XI2\<1\>\/XI2\<0\>\/XI2\<1\>\/XI2\<1\>\/XI2\<1\>\/XI2\<1\>\/RR7_pos \
 N_WLSEL\<893\>_XI2\<0\>\/XI2\<1\>\/XI2\<1\>\/XI2\<0\>\/XI2\<1\>\/XI2\<1\>\/XI2\<1\>\/XI2\<1\>\/RR7_neg \
 ) R_1X_LL w=1e-07 l=1e-07   res=0.149966
XXI2\<0\>\/XI2\<1\>\/XI2\<1\>\/XI2\<0\>\/XI2\<1\>\/XI2\<1\>\/XI2\<1\>\/XI2\<1\>\/RR6 \
 (  \
 N_SEL6\<1\>_XI2\<0\>\/XI2\<1\>\/XI2\<1\>\/XI2\<0\>\/XI2\<1\>\/XI2\<1\>\/XI2\<1\>\/XI2\<1\>\/RR6_pos \
 N_WLSEL\<894\>_XI2\<0\>\/XI2\<1\>\/XI2\<1\>\/XI2\<0\>\/XI2\<1\>\/XI2\<1\>\/XI2\<1\>\/XI2\<1\>\/RR6_neg \
 ) R_1X_LL w=1e-07 l=1e-07   res=0.149966
XXI2\<0\>\/XI2\<1\>\/XI2\<1\>\/XI2\<0\>\/XI2\<1\>\/XI2\<1\>\/XI2\<1\>\/XI2\<1\>\/RR5 \
 (  \
 N_SEL7\<0\>_XI2\<0\>\/XI2\<1\>\/XI2\<1\>\/XI2\<0\>\/XI2\<1\>\/XI2\<1\>\/XI2\<1\>\/XI2\<1\>\/RR5_pos \
 N_WLSEL\<895\>_XI2\<0\>\/XI2\<1\>\/XI2\<1\>\/XI2\<0\>\/XI2\<1\>\/XI2\<1\>\/XI2\<1\>\/XI2\<1\>\/RR5_neg \
 ) R_1X_LL w=1e-07 l=1e-07   res=0.149966
XXI2\<0\>\/XI2\<1\>\/XI2\<1\>\/XI2\<1\>\/XI2\<0\>\/XI2\<0\>\/XI2\<0\>\/XI2\<0\>\/RR0 \
 (  \
 N_SEL0\<0\>_XI2\<0\>\/XI2\<1\>\/XI2\<1\>\/XI2\<1\>\/XI2\<0\>\/XI2\<0\>\/XI2\<0\>\/XI2\<0\>\/RR0_pos \
 N_WLSEL\<896\>_XI2\<0\>\/XI2\<1\>\/XI2\<1\>\/XI2\<1\>\/XI2\<0\>\/XI2\<0\>\/XI2\<0\>\/XI2\<0\>\/RR0_neg \
 ) R_1X_LL w=1e-07 l=1e-07   res=0.149966
XXI2\<0\>\/XI2\<1\>\/XI2\<1\>\/XI2\<1\>\/XI2\<0\>\/XI2\<0\>\/XI2\<0\>\/XI2\<0\>\/RR1 \
 (  \
 N_SEL1\<0\>_XI2\<0\>\/XI2\<1\>\/XI2\<1\>\/XI2\<1\>\/XI2\<0\>\/XI2\<0\>\/XI2\<0\>\/XI2\<0\>\/RR1_pos \
 N_WLSEL\<897\>_XI2\<0\>\/XI2\<1\>\/XI2\<1\>\/XI2\<1\>\/XI2\<0\>\/XI2\<0\>\/XI2\<0\>\/XI2\<0\>\/RR1_neg \
 ) R_1X_LL w=1e-07 l=1e-07   res=0.149966
XXI2\<0\>\/XI2\<1\>\/XI2\<1\>\/XI2\<1\>\/XI2\<0\>\/XI2\<0\>\/XI2\<0\>\/XI2\<0\>\/RR2 \
 (  \
 N_SEL2\<0\>_XI2\<0\>\/XI2\<1\>\/XI2\<1\>\/XI2\<1\>\/XI2\<0\>\/XI2\<0\>\/XI2\<0\>\/XI2\<0\>\/RR2_pos \
 N_WLSEL\<898\>_XI2\<0\>\/XI2\<1\>\/XI2\<1\>\/XI2\<1\>\/XI2\<0\>\/XI2\<0\>\/XI2\<0\>\/XI2\<0\>\/RR2_neg \
 ) R_1X_LL w=1e-07 l=1e-07   res=0.149966
XXI2\<0\>\/XI2\<1\>\/XI2\<1\>\/XI2\<1\>\/XI2\<0\>\/XI2\<0\>\/XI2\<0\>\/XI2\<0\>\/RR3 \
 (  \
 N_SEL3\<0\>_XI2\<0\>\/XI2\<1\>\/XI2\<1\>\/XI2\<1\>\/XI2\<0\>\/XI2\<0\>\/XI2\<0\>\/XI2\<0\>\/RR3_pos \
 N_WLSEL\<899\>_XI2\<0\>\/XI2\<1\>\/XI2\<1\>\/XI2\<1\>\/XI2\<0\>\/XI2\<0\>\/XI2\<0\>\/XI2\<0\>\/RR3_neg \
 ) R_1X_LL w=1e-07 l=1e-07   res=0.149966
XXI2\<0\>\/XI2\<1\>\/XI2\<1\>\/XI2\<1\>\/XI2\<0\>\/XI2\<0\>\/XI2\<0\>\/XI2\<0\>\/RR4 \
 (  \
 N_SEL4\<1\>_XI2\<0\>\/XI2\<1\>\/XI2\<1\>\/XI2\<1\>\/XI2\<0\>\/XI2\<0\>\/XI2\<0\>\/XI2\<0\>\/RR4_pos \
 N_WLSEL\<900\>_XI2\<0\>\/XI2\<1\>\/XI2\<1\>\/XI2\<1\>\/XI2\<0\>\/XI2\<0\>\/XI2\<0\>\/XI2\<0\>\/RR4_neg \
 ) R_1X_LL w=1e-07 l=1e-07   res=0.149966
XXI2\<0\>\/XI2\<1\>\/XI2\<1\>\/XI2\<1\>\/XI2\<0\>\/XI2\<0\>\/XI2\<0\>\/XI2\<0\>\/RR7 \
 (  \
 N_SEL5\<1\>_XI2\<0\>\/XI2\<1\>\/XI2\<1\>\/XI2\<1\>\/XI2\<0\>\/XI2\<0\>\/XI2\<0\>\/XI2\<0\>\/RR7_pos \
 N_WLSEL\<901\>_XI2\<0\>\/XI2\<1\>\/XI2\<1\>\/XI2\<1\>\/XI2\<0\>\/XI2\<0\>\/XI2\<0\>\/XI2\<0\>\/RR7_neg \
 ) R_1X_LL w=1e-07 l=1e-07   res=0.149966
XXI2\<0\>\/XI2\<1\>\/XI2\<1\>\/XI2\<1\>\/XI2\<0\>\/XI2\<0\>\/XI2\<0\>\/XI2\<0\>\/RR6 \
 (  \
 N_SEL6\<1\>_XI2\<0\>\/XI2\<1\>\/XI2\<1\>\/XI2\<1\>\/XI2\<0\>\/XI2\<0\>\/XI2\<0\>\/XI2\<0\>\/RR6_pos \
 N_WLSEL\<902\>_XI2\<0\>\/XI2\<1\>\/XI2\<1\>\/XI2\<1\>\/XI2\<0\>\/XI2\<0\>\/XI2\<0\>\/XI2\<0\>\/RR6_neg \
 ) R_1X_LL w=1e-07 l=1e-07   res=0.149966
XXI2\<0\>\/XI2\<1\>\/XI2\<1\>\/XI2\<1\>\/XI2\<0\>\/XI2\<0\>\/XI2\<0\>\/XI2\<0\>\/RR5 \
 (  \
 N_SEL7\<0\>_XI2\<0\>\/XI2\<1\>\/XI2\<1\>\/XI2\<1\>\/XI2\<0\>\/XI2\<0\>\/XI2\<0\>\/XI2\<0\>\/RR5_pos \
 N_WLSEL\<903\>_XI2\<0\>\/XI2\<1\>\/XI2\<1\>\/XI2\<1\>\/XI2\<0\>\/XI2\<0\>\/XI2\<0\>\/XI2\<0\>\/RR5_neg \
 ) R_1X_LL w=1e-07 l=1e-07   res=0.149966
XXI2\<0\>\/XI2\<1\>\/XI2\<1\>\/XI2\<1\>\/XI2\<0\>\/XI2\<0\>\/XI2\<0\>\/XI2\<1\>\/RR0 \
 (  \
 N_SEL0\<1\>_XI2\<0\>\/XI2\<1\>\/XI2\<1\>\/XI2\<1\>\/XI2\<0\>\/XI2\<0\>\/XI2\<0\>\/XI2\<1\>\/RR0_pos \
 N_WLSEL\<904\>_XI2\<0\>\/XI2\<1\>\/XI2\<1\>\/XI2\<1\>\/XI2\<0\>\/XI2\<0\>\/XI2\<0\>\/XI2\<1\>\/RR0_neg \
 ) R_1X_LL w=1e-07 l=1e-07   res=0.149966
XXI2\<0\>\/XI2\<1\>\/XI2\<1\>\/XI2\<1\>\/XI2\<0\>\/XI2\<0\>\/XI2\<0\>\/XI2\<1\>\/RR1 \
 (  \
 N_SEL1\<0\>_XI2\<0\>\/XI2\<1\>\/XI2\<1\>\/XI2\<1\>\/XI2\<0\>\/XI2\<0\>\/XI2\<0\>\/XI2\<1\>\/RR1_pos \
 N_WLSEL\<905\>_XI2\<0\>\/XI2\<1\>\/XI2\<1\>\/XI2\<1\>\/XI2\<0\>\/XI2\<0\>\/XI2\<0\>\/XI2\<1\>\/RR1_neg \
 ) R_1X_LL w=1e-07 l=1e-07   res=0.149966
XXI2\<0\>\/XI2\<1\>\/XI2\<1\>\/XI2\<1\>\/XI2\<0\>\/XI2\<0\>\/XI2\<0\>\/XI2\<1\>\/RR2 \
 (  \
 N_SEL2\<0\>_XI2\<0\>\/XI2\<1\>\/XI2\<1\>\/XI2\<1\>\/XI2\<0\>\/XI2\<0\>\/XI2\<0\>\/XI2\<1\>\/RR2_pos \
 N_WLSEL\<906\>_XI2\<0\>\/XI2\<1\>\/XI2\<1\>\/XI2\<1\>\/XI2\<0\>\/XI2\<0\>\/XI2\<0\>\/XI2\<1\>\/RR2_neg \
 ) R_1X_LL w=1e-07 l=1e-07   res=0.149966
XXI2\<0\>\/XI2\<1\>\/XI2\<1\>\/XI2\<1\>\/XI2\<0\>\/XI2\<0\>\/XI2\<0\>\/XI2\<1\>\/RR3 \
 (  \
 N_SEL3\<0\>_XI2\<0\>\/XI2\<1\>\/XI2\<1\>\/XI2\<1\>\/XI2\<0\>\/XI2\<0\>\/XI2\<0\>\/XI2\<1\>\/RR3_pos \
 N_WLSEL\<907\>_XI2\<0\>\/XI2\<1\>\/XI2\<1\>\/XI2\<1\>\/XI2\<0\>\/XI2\<0\>\/XI2\<0\>\/XI2\<1\>\/RR3_neg \
 ) R_1X_LL w=1e-07 l=1e-07   res=0.149966
XXI2\<0\>\/XI2\<1\>\/XI2\<1\>\/XI2\<1\>\/XI2\<0\>\/XI2\<0\>\/XI2\<0\>\/XI2\<1\>\/RR4 \
 (  \
 N_SEL4\<1\>_XI2\<0\>\/XI2\<1\>\/XI2\<1\>\/XI2\<1\>\/XI2\<0\>\/XI2\<0\>\/XI2\<0\>\/XI2\<1\>\/RR4_pos \
 N_WLSEL\<908\>_XI2\<0\>\/XI2\<1\>\/XI2\<1\>\/XI2\<1\>\/XI2\<0\>\/XI2\<0\>\/XI2\<0\>\/XI2\<1\>\/RR4_neg \
 ) R_1X_LL w=1e-07 l=1e-07   res=0.149966
XXI2\<0\>\/XI2\<1\>\/XI2\<1\>\/XI2\<1\>\/XI2\<0\>\/XI2\<0\>\/XI2\<0\>\/XI2\<1\>\/RR7 \
 (  \
 N_SEL5\<1\>_XI2\<0\>\/XI2\<1\>\/XI2\<1\>\/XI2\<1\>\/XI2\<0\>\/XI2\<0\>\/XI2\<0\>\/XI2\<1\>\/RR7_pos \
 N_WLSEL\<909\>_XI2\<0\>\/XI2\<1\>\/XI2\<1\>\/XI2\<1\>\/XI2\<0\>\/XI2\<0\>\/XI2\<0\>\/XI2\<1\>\/RR7_neg \
 ) R_1X_LL w=1e-07 l=1e-07   res=0.149966
XXI2\<0\>\/XI2\<1\>\/XI2\<1\>\/XI2\<1\>\/XI2\<0\>\/XI2\<0\>\/XI2\<0\>\/XI2\<1\>\/RR6 \
 (  \
 N_SEL6\<1\>_XI2\<0\>\/XI2\<1\>\/XI2\<1\>\/XI2\<1\>\/XI2\<0\>\/XI2\<0\>\/XI2\<0\>\/XI2\<1\>\/RR6_pos \
 N_WLSEL\<910\>_XI2\<0\>\/XI2\<1\>\/XI2\<1\>\/XI2\<1\>\/XI2\<0\>\/XI2\<0\>\/XI2\<0\>\/XI2\<1\>\/RR6_neg \
 ) R_1X_LL w=1e-07 l=1e-07   res=0.149966
XXI2\<0\>\/XI2\<1\>\/XI2\<1\>\/XI2\<1\>\/XI2\<0\>\/XI2\<0\>\/XI2\<0\>\/XI2\<1\>\/RR5 \
 (  \
 N_SEL7\<0\>_XI2\<0\>\/XI2\<1\>\/XI2\<1\>\/XI2\<1\>\/XI2\<0\>\/XI2\<0\>\/XI2\<0\>\/XI2\<1\>\/RR5_pos \
 N_WLSEL\<911\>_XI2\<0\>\/XI2\<1\>\/XI2\<1\>\/XI2\<1\>\/XI2\<0\>\/XI2\<0\>\/XI2\<0\>\/XI2\<1\>\/RR5_neg \
 ) R_1X_LL w=1e-07 l=1e-07   res=0.149966
XXI2\<0\>\/XI2\<1\>\/XI2\<1\>\/XI2\<1\>\/XI2\<0\>\/XI2\<0\>\/XI2\<1\>\/XI2\<0\>\/RR0 \
 (  \
 N_SEL0\<0\>_XI2\<0\>\/XI2\<1\>\/XI2\<1\>\/XI2\<1\>\/XI2\<0\>\/XI2\<0\>\/XI2\<1\>\/XI2\<0\>\/RR0_pos \
 N_WLSEL\<912\>_XI2\<0\>\/XI2\<1\>\/XI2\<1\>\/XI2\<1\>\/XI2\<0\>\/XI2\<0\>\/XI2\<1\>\/XI2\<0\>\/RR0_neg \
 ) R_1X_LL w=1e-07 l=1e-07   res=0.149966
XXI2\<0\>\/XI2\<1\>\/XI2\<1\>\/XI2\<1\>\/XI2\<0\>\/XI2\<0\>\/XI2\<1\>\/XI2\<0\>\/RR1 \
 (  \
 N_SEL1\<1\>_XI2\<0\>\/XI2\<1\>\/XI2\<1\>\/XI2\<1\>\/XI2\<0\>\/XI2\<0\>\/XI2\<1\>\/XI2\<0\>\/RR1_pos \
 N_WLSEL\<913\>_XI2\<0\>\/XI2\<1\>\/XI2\<1\>\/XI2\<1\>\/XI2\<0\>\/XI2\<0\>\/XI2\<1\>\/XI2\<0\>\/RR1_neg \
 ) R_1X_LL w=1e-07 l=1e-07   res=0.149966
XXI2\<0\>\/XI2\<1\>\/XI2\<1\>\/XI2\<1\>\/XI2\<0\>\/XI2\<0\>\/XI2\<1\>\/XI2\<0\>\/RR2 \
 (  \
 N_SEL2\<0\>_XI2\<0\>\/XI2\<1\>\/XI2\<1\>\/XI2\<1\>\/XI2\<0\>\/XI2\<0\>\/XI2\<1\>\/XI2\<0\>\/RR2_pos \
 N_WLSEL\<914\>_XI2\<0\>\/XI2\<1\>\/XI2\<1\>\/XI2\<1\>\/XI2\<0\>\/XI2\<0\>\/XI2\<1\>\/XI2\<0\>\/RR2_neg \
 ) R_1X_LL w=1e-07 l=1e-07   res=0.149966
XXI2\<0\>\/XI2\<1\>\/XI2\<1\>\/XI2\<1\>\/XI2\<0\>\/XI2\<0\>\/XI2\<1\>\/XI2\<0\>\/RR3 \
 (  \
 N_SEL3\<0\>_XI2\<0\>\/XI2\<1\>\/XI2\<1\>\/XI2\<1\>\/XI2\<0\>\/XI2\<0\>\/XI2\<1\>\/XI2\<0\>\/RR3_pos \
 N_WLSEL\<915\>_XI2\<0\>\/XI2\<1\>\/XI2\<1\>\/XI2\<1\>\/XI2\<0\>\/XI2\<0\>\/XI2\<1\>\/XI2\<0\>\/RR3_neg \
 ) R_1X_LL w=1e-07 l=1e-07   res=0.149966
XXI2\<0\>\/XI2\<1\>\/XI2\<1\>\/XI2\<1\>\/XI2\<0\>\/XI2\<0\>\/XI2\<1\>\/XI2\<0\>\/RR4 \
 (  \
 N_SEL4\<1\>_XI2\<0\>\/XI2\<1\>\/XI2\<1\>\/XI2\<1\>\/XI2\<0\>\/XI2\<0\>\/XI2\<1\>\/XI2\<0\>\/RR4_pos \
 N_WLSEL\<916\>_XI2\<0\>\/XI2\<1\>\/XI2\<1\>\/XI2\<1\>\/XI2\<0\>\/XI2\<0\>\/XI2\<1\>\/XI2\<0\>\/RR4_neg \
 ) R_1X_LL w=1e-07 l=1e-07   res=0.149966
XXI2\<0\>\/XI2\<1\>\/XI2\<1\>\/XI2\<1\>\/XI2\<0\>\/XI2\<0\>\/XI2\<1\>\/XI2\<0\>\/RR7 \
 (  \
 N_SEL5\<1\>_XI2\<0\>\/XI2\<1\>\/XI2\<1\>\/XI2\<1\>\/XI2\<0\>\/XI2\<0\>\/XI2\<1\>\/XI2\<0\>\/RR7_pos \
 N_WLSEL\<917\>_XI2\<0\>\/XI2\<1\>\/XI2\<1\>\/XI2\<1\>\/XI2\<0\>\/XI2\<0\>\/XI2\<1\>\/XI2\<0\>\/RR7_neg \
 ) R_1X_LL w=1e-07 l=1e-07   res=0.149966
XXI2\<0\>\/XI2\<1\>\/XI2\<1\>\/XI2\<1\>\/XI2\<0\>\/XI2\<0\>\/XI2\<1\>\/XI2\<0\>\/RR6 \
 (  \
 N_SEL6\<1\>_XI2\<0\>\/XI2\<1\>\/XI2\<1\>\/XI2\<1\>\/XI2\<0\>\/XI2\<0\>\/XI2\<1\>\/XI2\<0\>\/RR6_pos \
 N_WLSEL\<918\>_XI2\<0\>\/XI2\<1\>\/XI2\<1\>\/XI2\<1\>\/XI2\<0\>\/XI2\<0\>\/XI2\<1\>\/XI2\<0\>\/RR6_neg \
 ) R_1X_LL w=1e-07 l=1e-07   res=0.149966
XXI2\<0\>\/XI2\<1\>\/XI2\<1\>\/XI2\<1\>\/XI2\<0\>\/XI2\<0\>\/XI2\<1\>\/XI2\<0\>\/RR5 \
 (  \
 N_SEL7\<0\>_XI2\<0\>\/XI2\<1\>\/XI2\<1\>\/XI2\<1\>\/XI2\<0\>\/XI2\<0\>\/XI2\<1\>\/XI2\<0\>\/RR5_pos \
 N_WLSEL\<919\>_XI2\<0\>\/XI2\<1\>\/XI2\<1\>\/XI2\<1\>\/XI2\<0\>\/XI2\<0\>\/XI2\<1\>\/XI2\<0\>\/RR5_neg \
 ) R_1X_LL w=1e-07 l=1e-07   res=0.149966
XXI2\<0\>\/XI2\<1\>\/XI2\<1\>\/XI2\<1\>\/XI2\<0\>\/XI2\<0\>\/XI2\<1\>\/XI2\<1\>\/RR0 \
 (  \
 N_SEL0\<1\>_XI2\<0\>\/XI2\<1\>\/XI2\<1\>\/XI2\<1\>\/XI2\<0\>\/XI2\<0\>\/XI2\<1\>\/XI2\<1\>\/RR0_pos \
 N_WLSEL\<920\>_XI2\<0\>\/XI2\<1\>\/XI2\<1\>\/XI2\<1\>\/XI2\<0\>\/XI2\<0\>\/XI2\<1\>\/XI2\<1\>\/RR0_neg \
 ) R_1X_LL w=1e-07 l=1e-07   res=0.149966
XXI2\<0\>\/XI2\<1\>\/XI2\<1\>\/XI2\<1\>\/XI2\<0\>\/XI2\<0\>\/XI2\<1\>\/XI2\<1\>\/RR1 \
 (  \
 N_SEL1\<1\>_XI2\<0\>\/XI2\<1\>\/XI2\<1\>\/XI2\<1\>\/XI2\<0\>\/XI2\<0\>\/XI2\<1\>\/XI2\<1\>\/RR1_pos \
 N_WLSEL\<921\>_XI2\<0\>\/XI2\<1\>\/XI2\<1\>\/XI2\<1\>\/XI2\<0\>\/XI2\<0\>\/XI2\<1\>\/XI2\<1\>\/RR1_neg \
 ) R_1X_LL w=1e-07 l=1e-07   res=0.149966
XXI2\<0\>\/XI2\<1\>\/XI2\<1\>\/XI2\<1\>\/XI2\<0\>\/XI2\<0\>\/XI2\<1\>\/XI2\<1\>\/RR2 \
 (  \
 N_SEL2\<0\>_XI2\<0\>\/XI2\<1\>\/XI2\<1\>\/XI2\<1\>\/XI2\<0\>\/XI2\<0\>\/XI2\<1\>\/XI2\<1\>\/RR2_pos \
 N_WLSEL\<922\>_XI2\<0\>\/XI2\<1\>\/XI2\<1\>\/XI2\<1\>\/XI2\<0\>\/XI2\<0\>\/XI2\<1\>\/XI2\<1\>\/RR2_neg \
 ) R_1X_LL w=1e-07 l=1e-07   res=0.149966
XXI2\<0\>\/XI2\<1\>\/XI2\<1\>\/XI2\<1\>\/XI2\<0\>\/XI2\<0\>\/XI2\<1\>\/XI2\<1\>\/RR3 \
 (  \
 N_SEL3\<0\>_XI2\<0\>\/XI2\<1\>\/XI2\<1\>\/XI2\<1\>\/XI2\<0\>\/XI2\<0\>\/XI2\<1\>\/XI2\<1\>\/RR3_pos \
 N_WLSEL\<923\>_XI2\<0\>\/XI2\<1\>\/XI2\<1\>\/XI2\<1\>\/XI2\<0\>\/XI2\<0\>\/XI2\<1\>\/XI2\<1\>\/RR3_neg \
 ) R_1X_LL w=1e-07 l=1e-07   res=0.149966
XXI2\<0\>\/XI2\<1\>\/XI2\<1\>\/XI2\<1\>\/XI2\<0\>\/XI2\<0\>\/XI2\<1\>\/XI2\<1\>\/RR4 \
 (  \
 N_SEL4\<1\>_XI2\<0\>\/XI2\<1\>\/XI2\<1\>\/XI2\<1\>\/XI2\<0\>\/XI2\<0\>\/XI2\<1\>\/XI2\<1\>\/RR4_pos \
 N_WLSEL\<924\>_XI2\<0\>\/XI2\<1\>\/XI2\<1\>\/XI2\<1\>\/XI2\<0\>\/XI2\<0\>\/XI2\<1\>\/XI2\<1\>\/RR4_neg \
 ) R_1X_LL w=1e-07 l=1e-07   res=0.149966
XXI2\<0\>\/XI2\<1\>\/XI2\<1\>\/XI2\<1\>\/XI2\<0\>\/XI2\<0\>\/XI2\<1\>\/XI2\<1\>\/RR7 \
 (  \
 N_SEL5\<1\>_XI2\<0\>\/XI2\<1\>\/XI2\<1\>\/XI2\<1\>\/XI2\<0\>\/XI2\<0\>\/XI2\<1\>\/XI2\<1\>\/RR7_pos \
 N_WLSEL\<925\>_XI2\<0\>\/XI2\<1\>\/XI2\<1\>\/XI2\<1\>\/XI2\<0\>\/XI2\<0\>\/XI2\<1\>\/XI2\<1\>\/RR7_neg \
 ) R_1X_LL w=1e-07 l=1e-07   res=0.149966
XXI2\<0\>\/XI2\<1\>\/XI2\<1\>\/XI2\<1\>\/XI2\<0\>\/XI2\<0\>\/XI2\<1\>\/XI2\<1\>\/RR6 \
 (  \
 N_SEL6\<1\>_XI2\<0\>\/XI2\<1\>\/XI2\<1\>\/XI2\<1\>\/XI2\<0\>\/XI2\<0\>\/XI2\<1\>\/XI2\<1\>\/RR6_pos \
 N_WLSEL\<926\>_XI2\<0\>\/XI2\<1\>\/XI2\<1\>\/XI2\<1\>\/XI2\<0\>\/XI2\<0\>\/XI2\<1\>\/XI2\<1\>\/RR6_neg \
 ) R_1X_LL w=1e-07 l=1e-07   res=0.149966
XXI2\<0\>\/XI2\<1\>\/XI2\<1\>\/XI2\<1\>\/XI2\<0\>\/XI2\<0\>\/XI2\<1\>\/XI2\<1\>\/RR5 \
 (  \
 N_SEL7\<0\>_XI2\<0\>\/XI2\<1\>\/XI2\<1\>\/XI2\<1\>\/XI2\<0\>\/XI2\<0\>\/XI2\<1\>\/XI2\<1\>\/RR5_pos \
 N_WLSEL\<927\>_XI2\<0\>\/XI2\<1\>\/XI2\<1\>\/XI2\<1\>\/XI2\<0\>\/XI2\<0\>\/XI2\<1\>\/XI2\<1\>\/RR5_neg \
 ) R_1X_LL w=1e-07 l=1e-07   res=0.149966
XXI2\<0\>\/XI2\<1\>\/XI2\<1\>\/XI2\<1\>\/XI2\<0\>\/XI2\<1\>\/XI2\<0\>\/XI2\<0\>\/RR0 \
 (  \
 N_SEL0\<0\>_XI2\<0\>\/XI2\<1\>\/XI2\<1\>\/XI2\<1\>\/XI2\<0\>\/XI2\<1\>\/XI2\<0\>\/XI2\<0\>\/RR0_pos \
 N_WLSEL\<928\>_XI2\<0\>\/XI2\<1\>\/XI2\<1\>\/XI2\<1\>\/XI2\<0\>\/XI2\<1\>\/XI2\<0\>\/XI2\<0\>\/RR0_neg \
 ) R_1X_LL w=1e-07 l=1e-07   res=0.149966
XXI2\<0\>\/XI2\<1\>\/XI2\<1\>\/XI2\<1\>\/XI2\<0\>\/XI2\<1\>\/XI2\<0\>\/XI2\<0\>\/RR1 \
 (  \
 N_SEL1\<0\>_XI2\<0\>\/XI2\<1\>\/XI2\<1\>\/XI2\<1\>\/XI2\<0\>\/XI2\<1\>\/XI2\<0\>\/XI2\<0\>\/RR1_pos \
 N_WLSEL\<929\>_XI2\<0\>\/XI2\<1\>\/XI2\<1\>\/XI2\<1\>\/XI2\<0\>\/XI2\<1\>\/XI2\<0\>\/XI2\<0\>\/RR1_neg \
 ) R_1X_LL w=1e-07 l=1e-07   res=0.149966
XXI2\<0\>\/XI2\<1\>\/XI2\<1\>\/XI2\<1\>\/XI2\<0\>\/XI2\<1\>\/XI2\<0\>\/XI2\<0\>\/RR2 \
 (  \
 N_SEL2\<1\>_XI2\<0\>\/XI2\<1\>\/XI2\<1\>\/XI2\<1\>\/XI2\<0\>\/XI2\<1\>\/XI2\<0\>\/XI2\<0\>\/RR2_pos \
 N_WLSEL\<930\>_XI2\<0\>\/XI2\<1\>\/XI2\<1\>\/XI2\<1\>\/XI2\<0\>\/XI2\<1\>\/XI2\<0\>\/XI2\<0\>\/RR2_neg \
 ) R_1X_LL w=1e-07 l=1e-07   res=0.149966
XXI2\<0\>\/XI2\<1\>\/XI2\<1\>\/XI2\<1\>\/XI2\<0\>\/XI2\<1\>\/XI2\<0\>\/XI2\<0\>\/RR3 \
 (  \
 N_SEL3\<0\>_XI2\<0\>\/XI2\<1\>\/XI2\<1\>\/XI2\<1\>\/XI2\<0\>\/XI2\<1\>\/XI2\<0\>\/XI2\<0\>\/RR3_pos \
 N_WLSEL\<931\>_XI2\<0\>\/XI2\<1\>\/XI2\<1\>\/XI2\<1\>\/XI2\<0\>\/XI2\<1\>\/XI2\<0\>\/XI2\<0\>\/RR3_neg \
 ) R_1X_LL w=1e-07 l=1e-07   res=0.149966
XXI2\<0\>\/XI2\<1\>\/XI2\<1\>\/XI2\<1\>\/XI2\<0\>\/XI2\<1\>\/XI2\<0\>\/XI2\<0\>\/RR4 \
 (  \
 N_SEL4\<1\>_XI2\<0\>\/XI2\<1\>\/XI2\<1\>\/XI2\<1\>\/XI2\<0\>\/XI2\<1\>\/XI2\<0\>\/XI2\<0\>\/RR4_pos \
 N_WLSEL\<932\>_XI2\<0\>\/XI2\<1\>\/XI2\<1\>\/XI2\<1\>\/XI2\<0\>\/XI2\<1\>\/XI2\<0\>\/XI2\<0\>\/RR4_neg \
 ) R_1X_LL w=1e-07 l=1e-07   res=0.149966
XXI2\<0\>\/XI2\<1\>\/XI2\<1\>\/XI2\<1\>\/XI2\<0\>\/XI2\<1\>\/XI2\<0\>\/XI2\<0\>\/RR7 \
 (  \
 N_SEL5\<1\>_XI2\<0\>\/XI2\<1\>\/XI2\<1\>\/XI2\<1\>\/XI2\<0\>\/XI2\<1\>\/XI2\<0\>\/XI2\<0\>\/RR7_pos \
 N_WLSEL\<933\>_XI2\<0\>\/XI2\<1\>\/XI2\<1\>\/XI2\<1\>\/XI2\<0\>\/XI2\<1\>\/XI2\<0\>\/XI2\<0\>\/RR7_neg \
 ) R_1X_LL w=1e-07 l=1e-07   res=0.149966
XXI2\<0\>\/XI2\<1\>\/XI2\<1\>\/XI2\<1\>\/XI2\<0\>\/XI2\<1\>\/XI2\<0\>\/XI2\<0\>\/RR6 \
 (  \
 N_SEL6\<1\>_XI2\<0\>\/XI2\<1\>\/XI2\<1\>\/XI2\<1\>\/XI2\<0\>\/XI2\<1\>\/XI2\<0\>\/XI2\<0\>\/RR6_pos \
 N_WLSEL\<934\>_XI2\<0\>\/XI2\<1\>\/XI2\<1\>\/XI2\<1\>\/XI2\<0\>\/XI2\<1\>\/XI2\<0\>\/XI2\<0\>\/RR6_neg \
 ) R_1X_LL w=1e-07 l=1e-07   res=0.149966
XXI2\<0\>\/XI2\<1\>\/XI2\<1\>\/XI2\<1\>\/XI2\<0\>\/XI2\<1\>\/XI2\<0\>\/XI2\<0\>\/RR5 \
 (  \
 N_SEL7\<0\>_XI2\<0\>\/XI2\<1\>\/XI2\<1\>\/XI2\<1\>\/XI2\<0\>\/XI2\<1\>\/XI2\<0\>\/XI2\<0\>\/RR5_pos \
 N_WLSEL\<935\>_XI2\<0\>\/XI2\<1\>\/XI2\<1\>\/XI2\<1\>\/XI2\<0\>\/XI2\<1\>\/XI2\<0\>\/XI2\<0\>\/RR5_neg \
 ) R_1X_LL w=1e-07 l=1e-07   res=0.149966
XXI2\<0\>\/XI2\<1\>\/XI2\<1\>\/XI2\<1\>\/XI2\<0\>\/XI2\<1\>\/XI2\<0\>\/XI2\<1\>\/RR0 \
 (  \
 N_SEL0\<1\>_XI2\<0\>\/XI2\<1\>\/XI2\<1\>\/XI2\<1\>\/XI2\<0\>\/XI2\<1\>\/XI2\<0\>\/XI2\<1\>\/RR0_pos \
 N_WLSEL\<936\>_XI2\<0\>\/XI2\<1\>\/XI2\<1\>\/XI2\<1\>\/XI2\<0\>\/XI2\<1\>\/XI2\<0\>\/XI2\<1\>\/RR0_neg \
 ) R_1X_LL w=1e-07 l=1e-07   res=0.149966
XXI2\<0\>\/XI2\<1\>\/XI2\<1\>\/XI2\<1\>\/XI2\<0\>\/XI2\<1\>\/XI2\<0\>\/XI2\<1\>\/RR1 \
 (  \
 N_SEL1\<0\>_XI2\<0\>\/XI2\<1\>\/XI2\<1\>\/XI2\<1\>\/XI2\<0\>\/XI2\<1\>\/XI2\<0\>\/XI2\<1\>\/RR1_pos \
 N_WLSEL\<937\>_XI2\<0\>\/XI2\<1\>\/XI2\<1\>\/XI2\<1\>\/XI2\<0\>\/XI2\<1\>\/XI2\<0\>\/XI2\<1\>\/RR1_neg \
 ) R_1X_LL w=1e-07 l=1e-07   res=0.149966
XXI2\<0\>\/XI2\<1\>\/XI2\<1\>\/XI2\<1\>\/XI2\<0\>\/XI2\<1\>\/XI2\<0\>\/XI2\<1\>\/RR2 \
 (  \
 N_SEL2\<1\>_XI2\<0\>\/XI2\<1\>\/XI2\<1\>\/XI2\<1\>\/XI2\<0\>\/XI2\<1\>\/XI2\<0\>\/XI2\<1\>\/RR2_pos \
 N_WLSEL\<938\>_XI2\<0\>\/XI2\<1\>\/XI2\<1\>\/XI2\<1\>\/XI2\<0\>\/XI2\<1\>\/XI2\<0\>\/XI2\<1\>\/RR2_neg \
 ) R_1X_LL w=1e-07 l=1e-07   res=0.149966
XXI2\<0\>\/XI2\<1\>\/XI2\<1\>\/XI2\<1\>\/XI2\<0\>\/XI2\<1\>\/XI2\<0\>\/XI2\<1\>\/RR3 \
 (  \
 N_SEL3\<0\>_XI2\<0\>\/XI2\<1\>\/XI2\<1\>\/XI2\<1\>\/XI2\<0\>\/XI2\<1\>\/XI2\<0\>\/XI2\<1\>\/RR3_pos \
 N_WLSEL\<939\>_XI2\<0\>\/XI2\<1\>\/XI2\<1\>\/XI2\<1\>\/XI2\<0\>\/XI2\<1\>\/XI2\<0\>\/XI2\<1\>\/RR3_neg \
 ) R_1X_LL w=1e-07 l=1e-07   res=0.149966
XXI2\<0\>\/XI2\<1\>\/XI2\<1\>\/XI2\<1\>\/XI2\<0\>\/XI2\<1\>\/XI2\<0\>\/XI2\<1\>\/RR4 \
 (  \
 N_SEL4\<1\>_XI2\<0\>\/XI2\<1\>\/XI2\<1\>\/XI2\<1\>\/XI2\<0\>\/XI2\<1\>\/XI2\<0\>\/XI2\<1\>\/RR4_pos \
 N_WLSEL\<940\>_XI2\<0\>\/XI2\<1\>\/XI2\<1\>\/XI2\<1\>\/XI2\<0\>\/XI2\<1\>\/XI2\<0\>\/XI2\<1\>\/RR4_neg \
 ) R_1X_LL w=1e-07 l=1e-07   res=0.149966
XXI2\<0\>\/XI2\<1\>\/XI2\<1\>\/XI2\<1\>\/XI2\<0\>\/XI2\<1\>\/XI2\<0\>\/XI2\<1\>\/RR7 \
 (  \
 N_SEL5\<1\>_XI2\<0\>\/XI2\<1\>\/XI2\<1\>\/XI2\<1\>\/XI2\<0\>\/XI2\<1\>\/XI2\<0\>\/XI2\<1\>\/RR7_pos \
 N_WLSEL\<941\>_XI2\<0\>\/XI2\<1\>\/XI2\<1\>\/XI2\<1\>\/XI2\<0\>\/XI2\<1\>\/XI2\<0\>\/XI2\<1\>\/RR7_neg \
 ) R_1X_LL w=1e-07 l=1e-07   res=0.149966
XXI2\<0\>\/XI2\<1\>\/XI2\<1\>\/XI2\<1\>\/XI2\<0\>\/XI2\<1\>\/XI2\<0\>\/XI2\<1\>\/RR6 \
 (  \
 N_SEL6\<1\>_XI2\<0\>\/XI2\<1\>\/XI2\<1\>\/XI2\<1\>\/XI2\<0\>\/XI2\<1\>\/XI2\<0\>\/XI2\<1\>\/RR6_pos \
 N_WLSEL\<942\>_XI2\<0\>\/XI2\<1\>\/XI2\<1\>\/XI2\<1\>\/XI2\<0\>\/XI2\<1\>\/XI2\<0\>\/XI2\<1\>\/RR6_neg \
 ) R_1X_LL w=1e-07 l=1e-07   res=0.149966
XXI2\<0\>\/XI2\<0\>\/XI2\<1\>\/XI2\<0\>\/XI2\<1\>\/XI2\<0\>\/XI2\<1\>\/XI2\<1\>\/RR5 \
 (  \
 N_SEL7\<0\>_XI2\<0\>\/XI2\<0\>\/XI2\<1\>\/XI2\<0\>\/XI2\<1\>\/XI2\<0\>\/XI2\<1\>\/XI2\<1\>\/RR5_pos \
 N_WLSEL\<351\>_XI2\<0\>\/XI2\<0\>\/XI2\<1\>\/XI2\<0\>\/XI2\<1\>\/XI2\<0\>\/XI2\<1\>\/XI2\<1\>\/RR5_neg \
 ) R_1X_LL w=1e-07 l=1e-07   res=0.149966
XXI2\<0\>\/XI2\<0\>\/XI2\<1\>\/XI2\<0\>\/XI2\<1\>\/XI2\<1\>\/XI2\<0\>\/XI2\<0\>\/RR0 \
 (  \
 N_SEL0\<0\>_XI2\<0\>\/XI2\<0\>\/XI2\<1\>\/XI2\<0\>\/XI2\<1\>\/XI2\<1\>\/XI2\<0\>\/XI2\<0\>\/RR0_pos \
 N_WLSEL\<352\>_XI2\<0\>\/XI2\<0\>\/XI2\<1\>\/XI2\<0\>\/XI2\<1\>\/XI2\<1\>\/XI2\<0\>\/XI2\<0\>\/RR0_neg \
 ) R_1X_LL w=1e-07 l=1e-07   res=0.149966
XXI2\<0\>\/XI2\<0\>\/XI2\<1\>\/XI2\<0\>\/XI2\<1\>\/XI2\<1\>\/XI2\<0\>\/XI2\<0\>\/RR1 \
 (  \
 N_SEL1\<0\>_XI2\<0\>\/XI2\<0\>\/XI2\<1\>\/XI2\<0\>\/XI2\<1\>\/XI2\<1\>\/XI2\<0\>\/XI2\<0\>\/RR1_pos \
 N_WLSEL\<353\>_XI2\<0\>\/XI2\<0\>\/XI2\<1\>\/XI2\<0\>\/XI2\<1\>\/XI2\<1\>\/XI2\<0\>\/XI2\<0\>\/RR1_neg \
 ) R_1X_LL w=1e-07 l=1e-07   res=0.149966
XXI2\<0\>\/XI2\<0\>\/XI2\<1\>\/XI2\<0\>\/XI2\<1\>\/XI2\<1\>\/XI2\<0\>\/XI2\<0\>\/RR2 \
 (  \
 N_SEL2\<1\>_XI2\<0\>\/XI2\<0\>\/XI2\<1\>\/XI2\<0\>\/XI2\<1\>\/XI2\<1\>\/XI2\<0\>\/XI2\<0\>\/RR2_pos \
 N_WLSEL\<354\>_XI2\<0\>\/XI2\<0\>\/XI2\<1\>\/XI2\<0\>\/XI2\<1\>\/XI2\<1\>\/XI2\<0\>\/XI2\<0\>\/RR2_neg \
 ) R_1X_LL w=1e-07 l=1e-07   res=0.149966
XXI2\<0\>\/XI2\<0\>\/XI2\<1\>\/XI2\<0\>\/XI2\<1\>\/XI2\<1\>\/XI2\<0\>\/XI2\<0\>\/RR3 \
 (  \
 N_SEL3\<1\>_XI2\<0\>\/XI2\<0\>\/XI2\<1\>\/XI2\<0\>\/XI2\<1\>\/XI2\<1\>\/XI2\<0\>\/XI2\<0\>\/RR3_pos \
 N_WLSEL\<355\>_XI2\<0\>\/XI2\<0\>\/XI2\<1\>\/XI2\<0\>\/XI2\<1\>\/XI2\<1\>\/XI2\<0\>\/XI2\<0\>\/RR3_neg \
 ) R_1X_LL w=1e-07 l=1e-07   res=0.149966
XXI2\<0\>\/XI2\<0\>\/XI2\<1\>\/XI2\<0\>\/XI2\<1\>\/XI2\<1\>\/XI2\<0\>\/XI2\<0\>\/RR4 \
 (  \
 N_SEL4\<0\>_XI2\<0\>\/XI2\<0\>\/XI2\<1\>\/XI2\<0\>\/XI2\<1\>\/XI2\<1\>\/XI2\<0\>\/XI2\<0\>\/RR4_pos \
 N_WLSEL\<356\>_XI2\<0\>\/XI2\<0\>\/XI2\<1\>\/XI2\<0\>\/XI2\<1\>\/XI2\<1\>\/XI2\<0\>\/XI2\<0\>\/RR4_neg \
 ) R_1X_LL w=1e-07 l=1e-07   res=0.149966
XXI2\<0\>\/XI2\<0\>\/XI2\<1\>\/XI2\<0\>\/XI2\<1\>\/XI2\<1\>\/XI2\<0\>\/XI2\<0\>\/RR7 \
 (  \
 N_SEL5\<1\>_XI2\<0\>\/XI2\<0\>\/XI2\<1\>\/XI2\<0\>\/XI2\<1\>\/XI2\<1\>\/XI2\<0\>\/XI2\<0\>\/RR7_pos \
 N_WLSEL\<357\>_XI2\<0\>\/XI2\<0\>\/XI2\<1\>\/XI2\<0\>\/XI2\<1\>\/XI2\<1\>\/XI2\<0\>\/XI2\<0\>\/RR7_neg \
 ) R_1X_LL w=1e-07 l=1e-07   res=0.149966
XXI2\<0\>\/XI2\<0\>\/XI2\<1\>\/XI2\<0\>\/XI2\<1\>\/XI2\<1\>\/XI2\<0\>\/XI2\<0\>\/RR6 \
 (  \
 N_SEL6\<0\>_XI2\<0\>\/XI2\<0\>\/XI2\<1\>\/XI2\<0\>\/XI2\<1\>\/XI2\<1\>\/XI2\<0\>\/XI2\<0\>\/RR6_pos \
 N_WLSEL\<358\>_XI2\<0\>\/XI2\<0\>\/XI2\<1\>\/XI2\<0\>\/XI2\<1\>\/XI2\<1\>\/XI2\<0\>\/XI2\<0\>\/RR6_neg \
 ) R_1X_LL w=1e-07 l=1e-07   res=0.149966
XXI2\<0\>\/XI2\<0\>\/XI2\<1\>\/XI2\<0\>\/XI2\<1\>\/XI2\<1\>\/XI2\<0\>\/XI2\<0\>\/RR5 \
 (  \
 N_SEL7\<0\>_XI2\<0\>\/XI2\<0\>\/XI2\<1\>\/XI2\<0\>\/XI2\<1\>\/XI2\<1\>\/XI2\<0\>\/XI2\<0\>\/RR5_pos \
 N_WLSEL\<359\>_XI2\<0\>\/XI2\<0\>\/XI2\<1\>\/XI2\<0\>\/XI2\<1\>\/XI2\<1\>\/XI2\<0\>\/XI2\<0\>\/RR5_neg \
 ) R_1X_LL w=1e-07 l=1e-07   res=0.149966
XXI2\<0\>\/XI2\<0\>\/XI2\<1\>\/XI2\<0\>\/XI2\<1\>\/XI2\<1\>\/XI2\<0\>\/XI2\<1\>\/RR0 \
 (  \
 N_SEL0\<1\>_XI2\<0\>\/XI2\<0\>\/XI2\<1\>\/XI2\<0\>\/XI2\<1\>\/XI2\<1\>\/XI2\<0\>\/XI2\<1\>\/RR0_pos \
 N_WLSEL\<360\>_XI2\<0\>\/XI2\<0\>\/XI2\<1\>\/XI2\<0\>\/XI2\<1\>\/XI2\<1\>\/XI2\<0\>\/XI2\<1\>\/RR0_neg \
 ) R_1X_LL w=1e-07 l=1e-07   res=0.149966
XXI2\<0\>\/XI2\<0\>\/XI2\<1\>\/XI2\<0\>\/XI2\<1\>\/XI2\<1\>\/XI2\<0\>\/XI2\<1\>\/RR1 \
 (  \
 N_SEL1\<0\>_XI2\<0\>\/XI2\<0\>\/XI2\<1\>\/XI2\<0\>\/XI2\<1\>\/XI2\<1\>\/XI2\<0\>\/XI2\<1\>\/RR1_pos \
 N_WLSEL\<361\>_XI2\<0\>\/XI2\<0\>\/XI2\<1\>\/XI2\<0\>\/XI2\<1\>\/XI2\<1\>\/XI2\<0\>\/XI2\<1\>\/RR1_neg \
 ) R_1X_LL w=1e-07 l=1e-07   res=0.149966
XXI2\<0\>\/XI2\<0\>\/XI2\<1\>\/XI2\<0\>\/XI2\<1\>\/XI2\<1\>\/XI2\<0\>\/XI2\<1\>\/RR2 \
 (  \
 N_SEL2\<1\>_XI2\<0\>\/XI2\<0\>\/XI2\<1\>\/XI2\<0\>\/XI2\<1\>\/XI2\<1\>\/XI2\<0\>\/XI2\<1\>\/RR2_pos \
 N_WLSEL\<362\>_XI2\<0\>\/XI2\<0\>\/XI2\<1\>\/XI2\<0\>\/XI2\<1\>\/XI2\<1\>\/XI2\<0\>\/XI2\<1\>\/RR2_neg \
 ) R_1X_LL w=1e-07 l=1e-07   res=0.149966
XXI2\<0\>\/XI2\<0\>\/XI2\<1\>\/XI2\<0\>\/XI2\<1\>\/XI2\<1\>\/XI2\<0\>\/XI2\<1\>\/RR3 \
 (  \
 N_SEL3\<1\>_XI2\<0\>\/XI2\<0\>\/XI2\<1\>\/XI2\<0\>\/XI2\<1\>\/XI2\<1\>\/XI2\<0\>\/XI2\<1\>\/RR3_pos \
 N_WLSEL\<363\>_XI2\<0\>\/XI2\<0\>\/XI2\<1\>\/XI2\<0\>\/XI2\<1\>\/XI2\<1\>\/XI2\<0\>\/XI2\<1\>\/RR3_neg \
 ) R_1X_LL w=1e-07 l=1e-07   res=0.149966
XXI2\<0\>\/XI2\<0\>\/XI2\<1\>\/XI2\<0\>\/XI2\<1\>\/XI2\<1\>\/XI2\<0\>\/XI2\<1\>\/RR4 \
 (  \
 N_SEL4\<0\>_XI2\<0\>\/XI2\<0\>\/XI2\<1\>\/XI2\<0\>\/XI2\<1\>\/XI2\<1\>\/XI2\<0\>\/XI2\<1\>\/RR4_pos \
 N_WLSEL\<364\>_XI2\<0\>\/XI2\<0\>\/XI2\<1\>\/XI2\<0\>\/XI2\<1\>\/XI2\<1\>\/XI2\<0\>\/XI2\<1\>\/RR4_neg \
 ) R_1X_LL w=1e-07 l=1e-07   res=0.149966
XXI2\<0\>\/XI2\<0\>\/XI2\<1\>\/XI2\<0\>\/XI2\<1\>\/XI2\<1\>\/XI2\<0\>\/XI2\<1\>\/RR7 \
 (  \
 N_SEL5\<1\>_XI2\<0\>\/XI2\<0\>\/XI2\<1\>\/XI2\<0\>\/XI2\<1\>\/XI2\<1\>\/XI2\<0\>\/XI2\<1\>\/RR7_pos \
 N_WLSEL\<365\>_XI2\<0\>\/XI2\<0\>\/XI2\<1\>\/XI2\<0\>\/XI2\<1\>\/XI2\<1\>\/XI2\<0\>\/XI2\<1\>\/RR7_neg \
 ) R_1X_LL w=1e-07 l=1e-07   res=0.149966
XXI2\<0\>\/XI2\<0\>\/XI2\<1\>\/XI2\<0\>\/XI2\<1\>\/XI2\<1\>\/XI2\<0\>\/XI2\<1\>\/RR6 \
 (  \
 N_SEL6\<0\>_XI2\<0\>\/XI2\<0\>\/XI2\<1\>\/XI2\<0\>\/XI2\<1\>\/XI2\<1\>\/XI2\<0\>\/XI2\<1\>\/RR6_pos \
 N_WLSEL\<366\>_XI2\<0\>\/XI2\<0\>\/XI2\<1\>\/XI2\<0\>\/XI2\<1\>\/XI2\<1\>\/XI2\<0\>\/XI2\<1\>\/RR6_neg \
 ) R_1X_LL w=1e-07 l=1e-07   res=0.149966
XXI2\<0\>\/XI2\<0\>\/XI2\<1\>\/XI2\<0\>\/XI2\<1\>\/XI2\<1\>\/XI2\<0\>\/XI2\<1\>\/RR5 \
 (  \
 N_SEL7\<0\>_XI2\<0\>\/XI2\<0\>\/XI2\<1\>\/XI2\<0\>\/XI2\<1\>\/XI2\<1\>\/XI2\<0\>\/XI2\<1\>\/RR5_pos \
 N_WLSEL\<367\>_XI2\<0\>\/XI2\<0\>\/XI2\<1\>\/XI2\<0\>\/XI2\<1\>\/XI2\<1\>\/XI2\<0\>\/XI2\<1\>\/RR5_neg \
 ) R_1X_LL w=1e-07 l=1e-07   res=0.149966
XXI2\<0\>\/XI2\<0\>\/XI2\<1\>\/XI2\<0\>\/XI2\<1\>\/XI2\<1\>\/XI2\<1\>\/XI2\<0\>\/RR0 \
 (  \
 N_SEL0\<0\>_XI2\<0\>\/XI2\<0\>\/XI2\<1\>\/XI2\<0\>\/XI2\<1\>\/XI2\<1\>\/XI2\<1\>\/XI2\<0\>\/RR0_pos \
 N_WLSEL\<368\>_XI2\<0\>\/XI2\<0\>\/XI2\<1\>\/XI2\<0\>\/XI2\<1\>\/XI2\<1\>\/XI2\<1\>\/XI2\<0\>\/RR0_neg \
 ) R_1X_LL w=1e-07 l=1e-07   res=0.149966
XXI2\<0\>\/XI2\<0\>\/XI2\<1\>\/XI2\<0\>\/XI2\<1\>\/XI2\<1\>\/XI2\<1\>\/XI2\<0\>\/RR1 \
 (  \
 N_SEL1\<1\>_XI2\<0\>\/XI2\<0\>\/XI2\<1\>\/XI2\<0\>\/XI2\<1\>\/XI2\<1\>\/XI2\<1\>\/XI2\<0\>\/RR1_pos \
 N_WLSEL\<369\>_XI2\<0\>\/XI2\<0\>\/XI2\<1\>\/XI2\<0\>\/XI2\<1\>\/XI2\<1\>\/XI2\<1\>\/XI2\<0\>\/RR1_neg \
 ) R_1X_LL w=1e-07 l=1e-07   res=0.149966
XXI2\<0\>\/XI2\<0\>\/XI2\<1\>\/XI2\<0\>\/XI2\<1\>\/XI2\<1\>\/XI2\<1\>\/XI2\<0\>\/RR2 \
 (  \
 N_SEL2\<1\>_XI2\<0\>\/XI2\<0\>\/XI2\<1\>\/XI2\<0\>\/XI2\<1\>\/XI2\<1\>\/XI2\<1\>\/XI2\<0\>\/RR2_pos \
 N_WLSEL\<370\>_XI2\<0\>\/XI2\<0\>\/XI2\<1\>\/XI2\<0\>\/XI2\<1\>\/XI2\<1\>\/XI2\<1\>\/XI2\<0\>\/RR2_neg \
 ) R_1X_LL w=1e-07 l=1e-07   res=0.149966
XXI2\<0\>\/XI2\<0\>\/XI2\<1\>\/XI2\<0\>\/XI2\<1\>\/XI2\<1\>\/XI2\<1\>\/XI2\<0\>\/RR3 \
 (  \
 N_SEL3\<1\>_XI2\<0\>\/XI2\<0\>\/XI2\<1\>\/XI2\<0\>\/XI2\<1\>\/XI2\<1\>\/XI2\<1\>\/XI2\<0\>\/RR3_pos \
 N_WLSEL\<371\>_XI2\<0\>\/XI2\<0\>\/XI2\<1\>\/XI2\<0\>\/XI2\<1\>\/XI2\<1\>\/XI2\<1\>\/XI2\<0\>\/RR3_neg \
 ) R_1X_LL w=1e-07 l=1e-07   res=0.149966
XXI2\<0\>\/XI2\<0\>\/XI2\<1\>\/XI2\<0\>\/XI2\<1\>\/XI2\<1\>\/XI2\<1\>\/XI2\<0\>\/RR4 \
 (  \
 N_SEL4\<0\>_XI2\<0\>\/XI2\<0\>\/XI2\<1\>\/XI2\<0\>\/XI2\<1\>\/XI2\<1\>\/XI2\<1\>\/XI2\<0\>\/RR4_pos \
 N_WLSEL\<372\>_XI2\<0\>\/XI2\<0\>\/XI2\<1\>\/XI2\<0\>\/XI2\<1\>\/XI2\<1\>\/XI2\<1\>\/XI2\<0\>\/RR4_neg \
 ) R_1X_LL w=1e-07 l=1e-07   res=0.149966
XXI2\<0\>\/XI2\<0\>\/XI2\<1\>\/XI2\<0\>\/XI2\<1\>\/XI2\<1\>\/XI2\<1\>\/XI2\<0\>\/RR7 \
 (  \
 N_SEL5\<1\>_XI2\<0\>\/XI2\<0\>\/XI2\<1\>\/XI2\<0\>\/XI2\<1\>\/XI2\<1\>\/XI2\<1\>\/XI2\<0\>\/RR7_pos \
 N_WLSEL\<373\>_XI2\<0\>\/XI2\<0\>\/XI2\<1\>\/XI2\<0\>\/XI2\<1\>\/XI2\<1\>\/XI2\<1\>\/XI2\<0\>\/RR7_neg \
 ) R_1X_LL w=1e-07 l=1e-07   res=0.149966
XXI2\<0\>\/XI2\<0\>\/XI2\<1\>\/XI2\<0\>\/XI2\<1\>\/XI2\<1\>\/XI2\<1\>\/XI2\<0\>\/RR6 \
 (  \
 N_SEL6\<0\>_XI2\<0\>\/XI2\<0\>\/XI2\<1\>\/XI2\<0\>\/XI2\<1\>\/XI2\<1\>\/XI2\<1\>\/XI2\<0\>\/RR6_pos \
 N_WLSEL\<374\>_XI2\<0\>\/XI2\<0\>\/XI2\<1\>\/XI2\<0\>\/XI2\<1\>\/XI2\<1\>\/XI2\<1\>\/XI2\<0\>\/RR6_neg \
 ) R_1X_LL w=1e-07 l=1e-07   res=0.149966
XXI2\<0\>\/XI2\<0\>\/XI2\<1\>\/XI2\<0\>\/XI2\<1\>\/XI2\<1\>\/XI2\<1\>\/XI2\<0\>\/RR5 \
 (  \
 N_SEL7\<0\>_XI2\<0\>\/XI2\<0\>\/XI2\<1\>\/XI2\<0\>\/XI2\<1\>\/XI2\<1\>\/XI2\<1\>\/XI2\<0\>\/RR5_pos \
 N_WLSEL\<375\>_XI2\<0\>\/XI2\<0\>\/XI2\<1\>\/XI2\<0\>\/XI2\<1\>\/XI2\<1\>\/XI2\<1\>\/XI2\<0\>\/RR5_neg \
 ) R_1X_LL w=1e-07 l=1e-07   res=0.149966
XXI2\<0\>\/XI2\<0\>\/XI2\<1\>\/XI2\<0\>\/XI2\<1\>\/XI2\<1\>\/XI2\<1\>\/XI2\<1\>\/RR0 \
 (  \
 N_SEL0\<1\>_XI2\<0\>\/XI2\<0\>\/XI2\<1\>\/XI2\<0\>\/XI2\<1\>\/XI2\<1\>\/XI2\<1\>\/XI2\<1\>\/RR0_pos \
 N_WLSEL\<376\>_XI2\<0\>\/XI2\<0\>\/XI2\<1\>\/XI2\<0\>\/XI2\<1\>\/XI2\<1\>\/XI2\<1\>\/XI2\<1\>\/RR0_neg \
 ) R_1X_LL w=1e-07 l=1e-07   res=0.149966
XXI2\<0\>\/XI2\<0\>\/XI2\<1\>\/XI2\<0\>\/XI2\<1\>\/XI2\<1\>\/XI2\<1\>\/XI2\<1\>\/RR1 \
 (  \
 N_SEL1\<1\>_XI2\<0\>\/XI2\<0\>\/XI2\<1\>\/XI2\<0\>\/XI2\<1\>\/XI2\<1\>\/XI2\<1\>\/XI2\<1\>\/RR1_pos \
 N_WLSEL\<377\>_XI2\<0\>\/XI2\<0\>\/XI2\<1\>\/XI2\<0\>\/XI2\<1\>\/XI2\<1\>\/XI2\<1\>\/XI2\<1\>\/RR1_neg \
 ) R_1X_LL w=1e-07 l=1e-07   res=0.149966
XXI2\<0\>\/XI2\<0\>\/XI2\<1\>\/XI2\<0\>\/XI2\<1\>\/XI2\<1\>\/XI2\<1\>\/XI2\<1\>\/RR2 \
 (  \
 N_SEL2\<1\>_XI2\<0\>\/XI2\<0\>\/XI2\<1\>\/XI2\<0\>\/XI2\<1\>\/XI2\<1\>\/XI2\<1\>\/XI2\<1\>\/RR2_pos \
 N_WLSEL\<378\>_XI2\<0\>\/XI2\<0\>\/XI2\<1\>\/XI2\<0\>\/XI2\<1\>\/XI2\<1\>\/XI2\<1\>\/XI2\<1\>\/RR2_neg \
 ) R_1X_LL w=1e-07 l=1e-07   res=0.149966
XXI2\<0\>\/XI2\<0\>\/XI2\<1\>\/XI2\<0\>\/XI2\<1\>\/XI2\<1\>\/XI2\<1\>\/XI2\<1\>\/RR3 \
 (  \
 N_SEL3\<1\>_XI2\<0\>\/XI2\<0\>\/XI2\<1\>\/XI2\<0\>\/XI2\<1\>\/XI2\<1\>\/XI2\<1\>\/XI2\<1\>\/RR3_pos \
 N_WLSEL\<379\>_XI2\<0\>\/XI2\<0\>\/XI2\<1\>\/XI2\<0\>\/XI2\<1\>\/XI2\<1\>\/XI2\<1\>\/XI2\<1\>\/RR3_neg \
 ) R_1X_LL w=1e-07 l=1e-07   res=0.149966
XXI2\<0\>\/XI2\<0\>\/XI2\<1\>\/XI2\<0\>\/XI2\<1\>\/XI2\<1\>\/XI2\<1\>\/XI2\<1\>\/RR4 \
 (  \
 N_SEL4\<0\>_XI2\<0\>\/XI2\<0\>\/XI2\<1\>\/XI2\<0\>\/XI2\<1\>\/XI2\<1\>\/XI2\<1\>\/XI2\<1\>\/RR4_pos \
 N_WLSEL\<380\>_XI2\<0\>\/XI2\<0\>\/XI2\<1\>\/XI2\<0\>\/XI2\<1\>\/XI2\<1\>\/XI2\<1\>\/XI2\<1\>\/RR4_neg \
 ) R_1X_LL w=1e-07 l=1e-07   res=0.149966
XXI2\<0\>\/XI2\<0\>\/XI2\<1\>\/XI2\<0\>\/XI2\<1\>\/XI2\<1\>\/XI2\<1\>\/XI2\<1\>\/RR7 \
 (  \
 N_SEL5\<1\>_XI2\<0\>\/XI2\<0\>\/XI2\<1\>\/XI2\<0\>\/XI2\<1\>\/XI2\<1\>\/XI2\<1\>\/XI2\<1\>\/RR7_pos \
 N_WLSEL\<381\>_XI2\<0\>\/XI2\<0\>\/XI2\<1\>\/XI2\<0\>\/XI2\<1\>\/XI2\<1\>\/XI2\<1\>\/XI2\<1\>\/RR7_neg \
 ) R_1X_LL w=1e-07 l=1e-07   res=0.149966
XXI2\<0\>\/XI2\<0\>\/XI2\<1\>\/XI2\<0\>\/XI2\<1\>\/XI2\<1\>\/XI2\<1\>\/XI2\<1\>\/RR6 \
 (  \
 N_SEL6\<0\>_XI2\<0\>\/XI2\<0\>\/XI2\<1\>\/XI2\<0\>\/XI2\<1\>\/XI2\<1\>\/XI2\<1\>\/XI2\<1\>\/RR6_pos \
 N_WLSEL\<382\>_XI2\<0\>\/XI2\<0\>\/XI2\<1\>\/XI2\<0\>\/XI2\<1\>\/XI2\<1\>\/XI2\<1\>\/XI2\<1\>\/RR6_neg \
 ) R_1X_LL w=1e-07 l=1e-07   res=0.149966
XXI2\<0\>\/XI2\<0\>\/XI2\<1\>\/XI2\<0\>\/XI2\<1\>\/XI2\<1\>\/XI2\<1\>\/XI2\<1\>\/RR5 \
 (  \
 N_SEL7\<0\>_XI2\<0\>\/XI2\<0\>\/XI2\<1\>\/XI2\<0\>\/XI2\<1\>\/XI2\<1\>\/XI2\<1\>\/XI2\<1\>\/RR5_pos \
 N_WLSEL\<383\>_XI2\<0\>\/XI2\<0\>\/XI2\<1\>\/XI2\<0\>\/XI2\<1\>\/XI2\<1\>\/XI2\<1\>\/XI2\<1\>\/RR5_neg \
 ) R_1X_LL w=1e-07 l=1e-07   res=0.149966
XXI2\<0\>\/XI2\<0\>\/XI2\<1\>\/XI2\<1\>\/XI2\<0\>\/XI2\<0\>\/XI2\<0\>\/XI2\<0\>\/RR0 \
 (  \
 N_SEL0\<0\>_XI2\<0\>\/XI2\<0\>\/XI2\<1\>\/XI2\<1\>\/XI2\<0\>\/XI2\<0\>\/XI2\<0\>\/XI2\<0\>\/RR0_pos \
 N_WLSEL\<384\>_XI2\<0\>\/XI2\<0\>\/XI2\<1\>\/XI2\<1\>\/XI2\<0\>\/XI2\<0\>\/XI2\<0\>\/XI2\<0\>\/RR0_neg \
 ) R_1X_LL w=1e-07 l=1e-07   res=0.149966
XXI2\<0\>\/XI2\<0\>\/XI2\<1\>\/XI2\<1\>\/XI2\<0\>\/XI2\<0\>\/XI2\<0\>\/XI2\<0\>\/RR1 \
 (  \
 N_SEL1\<0\>_XI2\<0\>\/XI2\<0\>\/XI2\<1\>\/XI2\<1\>\/XI2\<0\>\/XI2\<0\>\/XI2\<0\>\/XI2\<0\>\/RR1_pos \
 N_WLSEL\<385\>_XI2\<0\>\/XI2\<0\>\/XI2\<1\>\/XI2\<1\>\/XI2\<0\>\/XI2\<0\>\/XI2\<0\>\/XI2\<0\>\/RR1_neg \
 ) R_1X_LL w=1e-07 l=1e-07   res=0.149966
XXI2\<0\>\/XI2\<0\>\/XI2\<1\>\/XI2\<1\>\/XI2\<0\>\/XI2\<0\>\/XI2\<0\>\/XI2\<0\>\/RR2 \
 (  \
 N_SEL2\<0\>_XI2\<0\>\/XI2\<0\>\/XI2\<1\>\/XI2\<1\>\/XI2\<0\>\/XI2\<0\>\/XI2\<0\>\/XI2\<0\>\/RR2_pos \
 N_WLSEL\<386\>_XI2\<0\>\/XI2\<0\>\/XI2\<1\>\/XI2\<1\>\/XI2\<0\>\/XI2\<0\>\/XI2\<0\>\/XI2\<0\>\/RR2_neg \
 ) R_1X_LL w=1e-07 l=1e-07   res=0.149966
XXI2\<0\>\/XI2\<0\>\/XI2\<1\>\/XI2\<1\>\/XI2\<0\>\/XI2\<0\>\/XI2\<0\>\/XI2\<0\>\/RR3 \
 (  \
 N_SEL3\<0\>_XI2\<0\>\/XI2\<0\>\/XI2\<1\>\/XI2\<1\>\/XI2\<0\>\/XI2\<0\>\/XI2\<0\>\/XI2\<0\>\/RR3_pos \
 N_WLSEL\<387\>_XI2\<0\>\/XI2\<0\>\/XI2\<1\>\/XI2\<1\>\/XI2\<0\>\/XI2\<0\>\/XI2\<0\>\/XI2\<0\>\/RR3_neg \
 ) R_1X_LL w=1e-07 l=1e-07   res=0.149966
XXI2\<0\>\/XI2\<0\>\/XI2\<1\>\/XI2\<1\>\/XI2\<0\>\/XI2\<0\>\/XI2\<0\>\/XI2\<0\>\/RR4 \
 (  \
 N_SEL4\<1\>_XI2\<0\>\/XI2\<0\>\/XI2\<1\>\/XI2\<1\>\/XI2\<0\>\/XI2\<0\>\/XI2\<0\>\/XI2\<0\>\/RR4_pos \
 N_WLSEL\<388\>_XI2\<0\>\/XI2\<0\>\/XI2\<1\>\/XI2\<1\>\/XI2\<0\>\/XI2\<0\>\/XI2\<0\>\/XI2\<0\>\/RR4_neg \
 ) R_1X_LL w=1e-07 l=1e-07   res=0.149966
XXI2\<0\>\/XI2\<0\>\/XI2\<1\>\/XI2\<1\>\/XI2\<0\>\/XI2\<0\>\/XI2\<0\>\/XI2\<0\>\/RR7 \
 (  \
 N_SEL5\<1\>_XI2\<0\>\/XI2\<0\>\/XI2\<1\>\/XI2\<1\>\/XI2\<0\>\/XI2\<0\>\/XI2\<0\>\/XI2\<0\>\/RR7_pos \
 N_WLSEL\<389\>_XI2\<0\>\/XI2\<0\>\/XI2\<1\>\/XI2\<1\>\/XI2\<0\>\/XI2\<0\>\/XI2\<0\>\/XI2\<0\>\/RR7_neg \
 ) R_1X_LL w=1e-07 l=1e-07   res=0.149966
XXI2\<0\>\/XI2\<0\>\/XI2\<1\>\/XI2\<1\>\/XI2\<0\>\/XI2\<0\>\/XI2\<0\>\/XI2\<0\>\/RR6 \
 (  \
 N_SEL6\<0\>_XI2\<0\>\/XI2\<0\>\/XI2\<1\>\/XI2\<1\>\/XI2\<0\>\/XI2\<0\>\/XI2\<0\>\/XI2\<0\>\/RR6_pos \
 N_WLSEL\<390\>_XI2\<0\>\/XI2\<0\>\/XI2\<1\>\/XI2\<1\>\/XI2\<0\>\/XI2\<0\>\/XI2\<0\>\/XI2\<0\>\/RR6_neg \
 ) R_1X_LL w=1e-07 l=1e-07   res=0.149966
XXI2\<0\>\/XI2\<0\>\/XI2\<1\>\/XI2\<1\>\/XI2\<0\>\/XI2\<0\>\/XI2\<0\>\/XI2\<0\>\/RR5 \
 (  \
 N_SEL7\<0\>_XI2\<0\>\/XI2\<0\>\/XI2\<1\>\/XI2\<1\>\/XI2\<0\>\/XI2\<0\>\/XI2\<0\>\/XI2\<0\>\/RR5_pos \
 N_WLSEL\<391\>_XI2\<0\>\/XI2\<0\>\/XI2\<1\>\/XI2\<1\>\/XI2\<0\>\/XI2\<0\>\/XI2\<0\>\/XI2\<0\>\/RR5_neg \
 ) R_1X_LL w=1e-07 l=1e-07   res=0.149966
XXI2\<0\>\/XI2\<0\>\/XI2\<1\>\/XI2\<1\>\/XI2\<0\>\/XI2\<0\>\/XI2\<0\>\/XI2\<1\>\/RR0 \
 (  \
 N_SEL0\<1\>_XI2\<0\>\/XI2\<0\>\/XI2\<1\>\/XI2\<1\>\/XI2\<0\>\/XI2\<0\>\/XI2\<0\>\/XI2\<1\>\/RR0_pos \
 N_WLSEL\<392\>_XI2\<0\>\/XI2\<0\>\/XI2\<1\>\/XI2\<1\>\/XI2\<0\>\/XI2\<0\>\/XI2\<0\>\/XI2\<1\>\/RR0_neg \
 ) R_1X_LL w=1e-07 l=1e-07   res=0.149966
XXI2\<0\>\/XI2\<0\>\/XI2\<1\>\/XI2\<1\>\/XI2\<0\>\/XI2\<0\>\/XI2\<0\>\/XI2\<1\>\/RR1 \
 (  \
 N_SEL1\<0\>_XI2\<0\>\/XI2\<0\>\/XI2\<1\>\/XI2\<1\>\/XI2\<0\>\/XI2\<0\>\/XI2\<0\>\/XI2\<1\>\/RR1_pos \
 N_WLSEL\<393\>_XI2\<0\>\/XI2\<0\>\/XI2\<1\>\/XI2\<1\>\/XI2\<0\>\/XI2\<0\>\/XI2\<0\>\/XI2\<1\>\/RR1_neg \
 ) R_1X_LL w=1e-07 l=1e-07   res=0.149966
XXI2\<0\>\/XI2\<0\>\/XI2\<1\>\/XI2\<1\>\/XI2\<0\>\/XI2\<0\>\/XI2\<0\>\/XI2\<1\>\/RR2 \
 (  \
 N_SEL2\<0\>_XI2\<0\>\/XI2\<0\>\/XI2\<1\>\/XI2\<1\>\/XI2\<0\>\/XI2\<0\>\/XI2\<0\>\/XI2\<1\>\/RR2_pos \
 N_WLSEL\<394\>_XI2\<0\>\/XI2\<0\>\/XI2\<1\>\/XI2\<1\>\/XI2\<0\>\/XI2\<0\>\/XI2\<0\>\/XI2\<1\>\/RR2_neg \
 ) R_1X_LL w=1e-07 l=1e-07   res=0.149966
XXI2\<0\>\/XI2\<0\>\/XI2\<1\>\/XI2\<1\>\/XI2\<0\>\/XI2\<0\>\/XI2\<0\>\/XI2\<1\>\/RR3 \
 (  \
 N_SEL3\<0\>_XI2\<0\>\/XI2\<0\>\/XI2\<1\>\/XI2\<1\>\/XI2\<0\>\/XI2\<0\>\/XI2\<0\>\/XI2\<1\>\/RR3_pos \
 N_WLSEL\<395\>_XI2\<0\>\/XI2\<0\>\/XI2\<1\>\/XI2\<1\>\/XI2\<0\>\/XI2\<0\>\/XI2\<0\>\/XI2\<1\>\/RR3_neg \
 ) R_1X_LL w=1e-07 l=1e-07   res=0.149966
XXI2\<0\>\/XI2\<0\>\/XI2\<1\>\/XI2\<1\>\/XI2\<0\>\/XI2\<0\>\/XI2\<0\>\/XI2\<1\>\/RR4 \
 (  \
 N_SEL4\<1\>_XI2\<0\>\/XI2\<0\>\/XI2\<1\>\/XI2\<1\>\/XI2\<0\>\/XI2\<0\>\/XI2\<0\>\/XI2\<1\>\/RR4_pos \
 N_WLSEL\<396\>_XI2\<0\>\/XI2\<0\>\/XI2\<1\>\/XI2\<1\>\/XI2\<0\>\/XI2\<0\>\/XI2\<0\>\/XI2\<1\>\/RR4_neg \
 ) R_1X_LL w=1e-07 l=1e-07   res=0.149966
XXI2\<0\>\/XI2\<0\>\/XI2\<1\>\/XI2\<1\>\/XI2\<0\>\/XI2\<0\>\/XI2\<0\>\/XI2\<1\>\/RR7 \
 (  \
 N_SEL5\<1\>_XI2\<0\>\/XI2\<0\>\/XI2\<1\>\/XI2\<1\>\/XI2\<0\>\/XI2\<0\>\/XI2\<0\>\/XI2\<1\>\/RR7_pos \
 N_WLSEL\<397\>_XI2\<0\>\/XI2\<0\>\/XI2\<1\>\/XI2\<1\>\/XI2\<0\>\/XI2\<0\>\/XI2\<0\>\/XI2\<1\>\/RR7_neg \
 ) R_1X_LL w=1e-07 l=1e-07   res=0.149966
XXI2\<0\>\/XI2\<0\>\/XI2\<1\>\/XI2\<1\>\/XI2\<0\>\/XI2\<0\>\/XI2\<0\>\/XI2\<1\>\/RR6 \
 (  \
 N_SEL6\<0\>_XI2\<0\>\/XI2\<0\>\/XI2\<1\>\/XI2\<1\>\/XI2\<0\>\/XI2\<0\>\/XI2\<0\>\/XI2\<1\>\/RR6_pos \
 N_WLSEL\<398\>_XI2\<0\>\/XI2\<0\>\/XI2\<1\>\/XI2\<1\>\/XI2\<0\>\/XI2\<0\>\/XI2\<0\>\/XI2\<1\>\/RR6_neg \
 ) R_1X_LL w=1e-07 l=1e-07   res=0.149966
XXI2\<0\>\/XI2\<0\>\/XI2\<1\>\/XI2\<1\>\/XI2\<0\>\/XI2\<0\>\/XI2\<0\>\/XI2\<1\>\/RR5 \
 (  \
 N_SEL7\<0\>_XI2\<0\>\/XI2\<0\>\/XI2\<1\>\/XI2\<1\>\/XI2\<0\>\/XI2\<0\>\/XI2\<0\>\/XI2\<1\>\/RR5_pos \
 N_WLSEL\<399\>_XI2\<0\>\/XI2\<0\>\/XI2\<1\>\/XI2\<1\>\/XI2\<0\>\/XI2\<0\>\/XI2\<0\>\/XI2\<1\>\/RR5_neg \
 ) R_1X_LL w=1e-07 l=1e-07   res=0.149966
XXI2\<0\>\/XI2\<0\>\/XI2\<1\>\/XI2\<1\>\/XI2\<0\>\/XI2\<0\>\/XI2\<1\>\/XI2\<0\>\/RR0 \
 (  \
 N_SEL0\<0\>_XI2\<0\>\/XI2\<0\>\/XI2\<1\>\/XI2\<1\>\/XI2\<0\>\/XI2\<0\>\/XI2\<1\>\/XI2\<0\>\/RR0_pos \
 N_WLSEL\<400\>_XI2\<0\>\/XI2\<0\>\/XI2\<1\>\/XI2\<1\>\/XI2\<0\>\/XI2\<0\>\/XI2\<1\>\/XI2\<0\>\/RR0_neg \
 ) R_1X_LL w=1e-07 l=1e-07   res=0.149966
XXI2\<0\>\/XI2\<0\>\/XI2\<1\>\/XI2\<1\>\/XI2\<0\>\/XI2\<0\>\/XI2\<1\>\/XI2\<0\>\/RR1 \
 (  \
 N_SEL1\<1\>_XI2\<0\>\/XI2\<0\>\/XI2\<1\>\/XI2\<1\>\/XI2\<0\>\/XI2\<0\>\/XI2\<1\>\/XI2\<0\>\/RR1_pos \
 N_WLSEL\<401\>_XI2\<0\>\/XI2\<0\>\/XI2\<1\>\/XI2\<1\>\/XI2\<0\>\/XI2\<0\>\/XI2\<1\>\/XI2\<0\>\/RR1_neg \
 ) R_1X_LL w=1e-07 l=1e-07   res=0.149966
XXI2\<0\>\/XI2\<0\>\/XI2\<1\>\/XI2\<1\>\/XI2\<0\>\/XI2\<0\>\/XI2\<1\>\/XI2\<0\>\/RR2 \
 (  \
 N_SEL2\<0\>_XI2\<0\>\/XI2\<0\>\/XI2\<1\>\/XI2\<1\>\/XI2\<0\>\/XI2\<0\>\/XI2\<1\>\/XI2\<0\>\/RR2_pos \
 N_WLSEL\<402\>_XI2\<0\>\/XI2\<0\>\/XI2\<1\>\/XI2\<1\>\/XI2\<0\>\/XI2\<0\>\/XI2\<1\>\/XI2\<0\>\/RR2_neg \
 ) R_1X_LL w=1e-07 l=1e-07   res=0.149966
XXI2\<0\>\/XI2\<0\>\/XI2\<1\>\/XI2\<1\>\/XI2\<0\>\/XI2\<0\>\/XI2\<1\>\/XI2\<0\>\/RR3 \
 (  \
 N_SEL3\<0\>_XI2\<0\>\/XI2\<0\>\/XI2\<1\>\/XI2\<1\>\/XI2\<0\>\/XI2\<0\>\/XI2\<1\>\/XI2\<0\>\/RR3_pos \
 N_WLSEL\<403\>_XI2\<0\>\/XI2\<0\>\/XI2\<1\>\/XI2\<1\>\/XI2\<0\>\/XI2\<0\>\/XI2\<1\>\/XI2\<0\>\/RR3_neg \
 ) R_1X_LL w=1e-07 l=1e-07   res=0.149966
XXI2\<0\>\/XI2\<0\>\/XI2\<1\>\/XI2\<1\>\/XI2\<0\>\/XI2\<0\>\/XI2\<1\>\/XI2\<0\>\/RR4 \
 (  \
 N_SEL4\<1\>_XI2\<0\>\/XI2\<0\>\/XI2\<1\>\/XI2\<1\>\/XI2\<0\>\/XI2\<0\>\/XI2\<1\>\/XI2\<0\>\/RR4_pos \
 N_WLSEL\<404\>_XI2\<0\>\/XI2\<0\>\/XI2\<1\>\/XI2\<1\>\/XI2\<0\>\/XI2\<0\>\/XI2\<1\>\/XI2\<0\>\/RR4_neg \
 ) R_1X_LL w=1e-07 l=1e-07   res=0.149966
XXI2\<0\>\/XI2\<0\>\/XI2\<1\>\/XI2\<1\>\/XI2\<0\>\/XI2\<0\>\/XI2\<1\>\/XI2\<0\>\/RR7 \
 (  \
 N_SEL5\<1\>_XI2\<0\>\/XI2\<0\>\/XI2\<1\>\/XI2\<1\>\/XI2\<0\>\/XI2\<0\>\/XI2\<1\>\/XI2\<0\>\/RR7_pos \
 N_WLSEL\<405\>_XI2\<0\>\/XI2\<0\>\/XI2\<1\>\/XI2\<1\>\/XI2\<0\>\/XI2\<0\>\/XI2\<1\>\/XI2\<0\>\/RR7_neg \
 ) R_1X_LL w=1e-07 l=1e-07   res=0.149966
XXI2\<0\>\/XI2\<0\>\/XI2\<1\>\/XI2\<1\>\/XI2\<0\>\/XI2\<0\>\/XI2\<1\>\/XI2\<0\>\/RR6 \
 (  \
 N_SEL6\<0\>_XI2\<0\>\/XI2\<0\>\/XI2\<1\>\/XI2\<1\>\/XI2\<0\>\/XI2\<0\>\/XI2\<1\>\/XI2\<0\>\/RR6_pos \
 N_WLSEL\<406\>_XI2\<0\>\/XI2\<0\>\/XI2\<1\>\/XI2\<1\>\/XI2\<0\>\/XI2\<0\>\/XI2\<1\>\/XI2\<0\>\/RR6_neg \
 ) R_1X_LL w=1e-07 l=1e-07   res=0.149966
XXI2\<0\>\/XI2\<0\>\/XI2\<1\>\/XI2\<1\>\/XI2\<0\>\/XI2\<0\>\/XI2\<1\>\/XI2\<0\>\/RR5 \
 (  \
 N_SEL7\<0\>_XI2\<0\>\/XI2\<0\>\/XI2\<1\>\/XI2\<1\>\/XI2\<0\>\/XI2\<0\>\/XI2\<1\>\/XI2\<0\>\/RR5_pos \
 N_WLSEL\<407\>_XI2\<0\>\/XI2\<0\>\/XI2\<1\>\/XI2\<1\>\/XI2\<0\>\/XI2\<0\>\/XI2\<1\>\/XI2\<0\>\/RR5_neg \
 ) R_1X_LL w=1e-07 l=1e-07   res=0.149966
XXI2\<0\>\/XI2\<0\>\/XI2\<1\>\/XI2\<1\>\/XI2\<0\>\/XI2\<0\>\/XI2\<1\>\/XI2\<1\>\/RR0 \
 (  \
 N_SEL0\<1\>_XI2\<0\>\/XI2\<0\>\/XI2\<1\>\/XI2\<1\>\/XI2\<0\>\/XI2\<0\>\/XI2\<1\>\/XI2\<1\>\/RR0_pos \
 N_WLSEL\<408\>_XI2\<0\>\/XI2\<0\>\/XI2\<1\>\/XI2\<1\>\/XI2\<0\>\/XI2\<0\>\/XI2\<1\>\/XI2\<1\>\/RR0_neg \
 ) R_1X_LL w=1e-07 l=1e-07   res=0.149966
XXI2\<0\>\/XI2\<0\>\/XI2\<1\>\/XI2\<1\>\/XI2\<0\>\/XI2\<0\>\/XI2\<1\>\/XI2\<1\>\/RR1 \
 (  \
 N_SEL1\<1\>_XI2\<0\>\/XI2\<0\>\/XI2\<1\>\/XI2\<1\>\/XI2\<0\>\/XI2\<0\>\/XI2\<1\>\/XI2\<1\>\/RR1_pos \
 N_WLSEL\<409\>_XI2\<0\>\/XI2\<0\>\/XI2\<1\>\/XI2\<1\>\/XI2\<0\>\/XI2\<0\>\/XI2\<1\>\/XI2\<1\>\/RR1_neg \
 ) R_1X_LL w=1e-07 l=1e-07   res=0.149966
XXI2\<0\>\/XI2\<0\>\/XI2\<1\>\/XI2\<1\>\/XI2\<0\>\/XI2\<0\>\/XI2\<1\>\/XI2\<1\>\/RR2 \
 (  \
 N_SEL2\<0\>_XI2\<0\>\/XI2\<0\>\/XI2\<1\>\/XI2\<1\>\/XI2\<0\>\/XI2\<0\>\/XI2\<1\>\/XI2\<1\>\/RR2_pos \
 N_WLSEL\<410\>_XI2\<0\>\/XI2\<0\>\/XI2\<1\>\/XI2\<1\>\/XI2\<0\>\/XI2\<0\>\/XI2\<1\>\/XI2\<1\>\/RR2_neg \
 ) R_1X_LL w=1e-07 l=1e-07   res=0.149966
XXI2\<0\>\/XI2\<0\>\/XI2\<1\>\/XI2\<1\>\/XI2\<0\>\/XI2\<0\>\/XI2\<1\>\/XI2\<1\>\/RR3 \
 (  \
 N_SEL3\<0\>_XI2\<0\>\/XI2\<0\>\/XI2\<1\>\/XI2\<1\>\/XI2\<0\>\/XI2\<0\>\/XI2\<1\>\/XI2\<1\>\/RR3_pos \
 N_WLSEL\<411\>_XI2\<0\>\/XI2\<0\>\/XI2\<1\>\/XI2\<1\>\/XI2\<0\>\/XI2\<0\>\/XI2\<1\>\/XI2\<1\>\/RR3_neg \
 ) R_1X_LL w=1e-07 l=1e-07   res=0.149966
XXI2\<0\>\/XI2\<0\>\/XI2\<1\>\/XI2\<1\>\/XI2\<0\>\/XI2\<0\>\/XI2\<1\>\/XI2\<1\>\/RR4 \
 (  \
 N_SEL4\<1\>_XI2\<0\>\/XI2\<0\>\/XI2\<1\>\/XI2\<1\>\/XI2\<0\>\/XI2\<0\>\/XI2\<1\>\/XI2\<1\>\/RR4_pos \
 N_WLSEL\<412\>_XI2\<0\>\/XI2\<0\>\/XI2\<1\>\/XI2\<1\>\/XI2\<0\>\/XI2\<0\>\/XI2\<1\>\/XI2\<1\>\/RR4_neg \
 ) R_1X_LL w=1e-07 l=1e-07   res=0.149966
XXI2\<0\>\/XI2\<0\>\/XI2\<1\>\/XI2\<1\>\/XI2\<0\>\/XI2\<0\>\/XI2\<1\>\/XI2\<1\>\/RR7 \
 (  \
 N_SEL5\<1\>_XI2\<0\>\/XI2\<0\>\/XI2\<1\>\/XI2\<1\>\/XI2\<0\>\/XI2\<0\>\/XI2\<1\>\/XI2\<1\>\/RR7_pos \
 N_WLSEL\<413\>_XI2\<0\>\/XI2\<0\>\/XI2\<1\>\/XI2\<1\>\/XI2\<0\>\/XI2\<0\>\/XI2\<1\>\/XI2\<1\>\/RR7_neg \
 ) R_1X_LL w=1e-07 l=1e-07   res=0.149966
XXI2\<0\>\/XI2\<0\>\/XI2\<1\>\/XI2\<1\>\/XI2\<0\>\/XI2\<0\>\/XI2\<1\>\/XI2\<1\>\/RR6 \
 (  \
 N_SEL6\<0\>_XI2\<0\>\/XI2\<0\>\/XI2\<1\>\/XI2\<1\>\/XI2\<0\>\/XI2\<0\>\/XI2\<1\>\/XI2\<1\>\/RR6_pos \
 N_WLSEL\<414\>_XI2\<0\>\/XI2\<0\>\/XI2\<1\>\/XI2\<1\>\/XI2\<0\>\/XI2\<0\>\/XI2\<1\>\/XI2\<1\>\/RR6_neg \
 ) R_1X_LL w=1e-07 l=1e-07   res=0.149966
XXI2\<0\>\/XI2\<0\>\/XI2\<1\>\/XI2\<1\>\/XI2\<0\>\/XI2\<0\>\/XI2\<1\>\/XI2\<1\>\/RR5 \
 (  \
 N_SEL7\<0\>_XI2\<0\>\/XI2\<0\>\/XI2\<1\>\/XI2\<1\>\/XI2\<0\>\/XI2\<0\>\/XI2\<1\>\/XI2\<1\>\/RR5_pos \
 N_WLSEL\<415\>_XI2\<0\>\/XI2\<0\>\/XI2\<1\>\/XI2\<1\>\/XI2\<0\>\/XI2\<0\>\/XI2\<1\>\/XI2\<1\>\/RR5_neg \
 ) R_1X_LL w=1e-07 l=1e-07   res=0.149966
XXI2\<0\>\/XI2\<0\>\/XI2\<1\>\/XI2\<1\>\/XI2\<0\>\/XI2\<1\>\/XI2\<0\>\/XI2\<0\>\/RR0 \
 (  \
 N_SEL0\<0\>_XI2\<0\>\/XI2\<0\>\/XI2\<1\>\/XI2\<1\>\/XI2\<0\>\/XI2\<1\>\/XI2\<0\>\/XI2\<0\>\/RR0_pos \
 N_WLSEL\<416\>_XI2\<0\>\/XI2\<0\>\/XI2\<1\>\/XI2\<1\>\/XI2\<0\>\/XI2\<1\>\/XI2\<0\>\/XI2\<0\>\/RR0_neg \
 ) R_1X_LL w=1e-07 l=1e-07   res=0.149966
XXI2\<0\>\/XI2\<0\>\/XI2\<1\>\/XI2\<1\>\/XI2\<0\>\/XI2\<1\>\/XI2\<0\>\/XI2\<0\>\/RR1 \
 (  \
 N_SEL1\<0\>_XI2\<0\>\/XI2\<0\>\/XI2\<1\>\/XI2\<1\>\/XI2\<0\>\/XI2\<1\>\/XI2\<0\>\/XI2\<0\>\/RR1_pos \
 N_WLSEL\<417\>_XI2\<0\>\/XI2\<0\>\/XI2\<1\>\/XI2\<1\>\/XI2\<0\>\/XI2\<1\>\/XI2\<0\>\/XI2\<0\>\/RR1_neg \
 ) R_1X_LL w=1e-07 l=1e-07   res=0.149966
XXI2\<0\>\/XI2\<0\>\/XI2\<1\>\/XI2\<1\>\/XI2\<0\>\/XI2\<1\>\/XI2\<0\>\/XI2\<0\>\/RR2 \
 (  \
 N_SEL2\<1\>_XI2\<0\>\/XI2\<0\>\/XI2\<1\>\/XI2\<1\>\/XI2\<0\>\/XI2\<1\>\/XI2\<0\>\/XI2\<0\>\/RR2_pos \
 N_WLSEL\<418\>_XI2\<0\>\/XI2\<0\>\/XI2\<1\>\/XI2\<1\>\/XI2\<0\>\/XI2\<1\>\/XI2\<0\>\/XI2\<0\>\/RR2_neg \
 ) R_1X_LL w=1e-07 l=1e-07   res=0.149966
XXI2\<0\>\/XI2\<0\>\/XI2\<1\>\/XI2\<1\>\/XI2\<0\>\/XI2\<1\>\/XI2\<0\>\/XI2\<0\>\/RR3 \
 (  \
 N_SEL3\<0\>_XI2\<0\>\/XI2\<0\>\/XI2\<1\>\/XI2\<1\>\/XI2\<0\>\/XI2\<1\>\/XI2\<0\>\/XI2\<0\>\/RR3_pos \
 N_WLSEL\<419\>_XI2\<0\>\/XI2\<0\>\/XI2\<1\>\/XI2\<1\>\/XI2\<0\>\/XI2\<1\>\/XI2\<0\>\/XI2\<0\>\/RR3_neg \
 ) R_1X_LL w=1e-07 l=1e-07   res=0.149966
XXI2\<0\>\/XI2\<0\>\/XI2\<1\>\/XI2\<1\>\/XI2\<0\>\/XI2\<1\>\/XI2\<0\>\/XI2\<0\>\/RR4 \
 (  \
 N_SEL4\<1\>_XI2\<0\>\/XI2\<0\>\/XI2\<1\>\/XI2\<1\>\/XI2\<0\>\/XI2\<1\>\/XI2\<0\>\/XI2\<0\>\/RR4_pos \
 N_WLSEL\<420\>_XI2\<0\>\/XI2\<0\>\/XI2\<1\>\/XI2\<1\>\/XI2\<0\>\/XI2\<1\>\/XI2\<0\>\/XI2\<0\>\/RR4_neg \
 ) R_1X_LL w=1e-07 l=1e-07   res=0.149966
XXI2\<0\>\/XI2\<0\>\/XI2\<1\>\/XI2\<1\>\/XI2\<0\>\/XI2\<1\>\/XI2\<0\>\/XI2\<0\>\/RR7 \
 (  \
 N_SEL5\<1\>_XI2\<0\>\/XI2\<0\>\/XI2\<1\>\/XI2\<1\>\/XI2\<0\>\/XI2\<1\>\/XI2\<0\>\/XI2\<0\>\/RR7_pos \
 N_WLSEL\<421\>_XI2\<0\>\/XI2\<0\>\/XI2\<1\>\/XI2\<1\>\/XI2\<0\>\/XI2\<1\>\/XI2\<0\>\/XI2\<0\>\/RR7_neg \
 ) R_1X_LL w=1e-07 l=1e-07   res=0.149966
XXI2\<0\>\/XI2\<0\>\/XI2\<1\>\/XI2\<1\>\/XI2\<0\>\/XI2\<1\>\/XI2\<0\>\/XI2\<0\>\/RR6 \
 (  \
 N_SEL6\<0\>_XI2\<0\>\/XI2\<0\>\/XI2\<1\>\/XI2\<1\>\/XI2\<0\>\/XI2\<1\>\/XI2\<0\>\/XI2\<0\>\/RR6_pos \
 N_WLSEL\<422\>_XI2\<0\>\/XI2\<0\>\/XI2\<1\>\/XI2\<1\>\/XI2\<0\>\/XI2\<1\>\/XI2\<0\>\/XI2\<0\>\/RR6_neg \
 ) R_1X_LL w=1e-07 l=1e-07   res=0.149966
XXI2\<0\>\/XI2\<0\>\/XI2\<1\>\/XI2\<1\>\/XI2\<0\>\/XI2\<1\>\/XI2\<0\>\/XI2\<0\>\/RR5 \
 (  \
 N_SEL7\<0\>_XI2\<0\>\/XI2\<0\>\/XI2\<1\>\/XI2\<1\>\/XI2\<0\>\/XI2\<1\>\/XI2\<0\>\/XI2\<0\>\/RR5_pos \
 N_WLSEL\<423\>_XI2\<0\>\/XI2\<0\>\/XI2\<1\>\/XI2\<1\>\/XI2\<0\>\/XI2\<1\>\/XI2\<0\>\/XI2\<0\>\/RR5_neg \
 ) R_1X_LL w=1e-07 l=1e-07   res=0.149966
XXI2\<0\>\/XI2\<0\>\/XI2\<1\>\/XI2\<1\>\/XI2\<0\>\/XI2\<1\>\/XI2\<0\>\/XI2\<1\>\/RR0 \
 (  \
 N_SEL0\<1\>_XI2\<0\>\/XI2\<0\>\/XI2\<1\>\/XI2\<1\>\/XI2\<0\>\/XI2\<1\>\/XI2\<0\>\/XI2\<1\>\/RR0_pos \
 N_WLSEL\<424\>_XI2\<0\>\/XI2\<0\>\/XI2\<1\>\/XI2\<1\>\/XI2\<0\>\/XI2\<1\>\/XI2\<0\>\/XI2\<1\>\/RR0_neg \
 ) R_1X_LL w=1e-07 l=1e-07   res=0.149966
XXI2\<0\>\/XI2\<0\>\/XI2\<1\>\/XI2\<1\>\/XI2\<0\>\/XI2\<1\>\/XI2\<0\>\/XI2\<1\>\/RR1 \
 (  \
 N_SEL1\<0\>_XI2\<0\>\/XI2\<0\>\/XI2\<1\>\/XI2\<1\>\/XI2\<0\>\/XI2\<1\>\/XI2\<0\>\/XI2\<1\>\/RR1_pos \
 N_WLSEL\<425\>_XI2\<0\>\/XI2\<0\>\/XI2\<1\>\/XI2\<1\>\/XI2\<0\>\/XI2\<1\>\/XI2\<0\>\/XI2\<1\>\/RR1_neg \
 ) R_1X_LL w=1e-07 l=1e-07   res=0.149966
XXI2\<0\>\/XI2\<0\>\/XI2\<1\>\/XI2\<1\>\/XI2\<0\>\/XI2\<1\>\/XI2\<0\>\/XI2\<1\>\/RR2 \
 (  \
 N_SEL2\<1\>_XI2\<0\>\/XI2\<0\>\/XI2\<1\>\/XI2\<1\>\/XI2\<0\>\/XI2\<1\>\/XI2\<0\>\/XI2\<1\>\/RR2_pos \
 N_WLSEL\<426\>_XI2\<0\>\/XI2\<0\>\/XI2\<1\>\/XI2\<1\>\/XI2\<0\>\/XI2\<1\>\/XI2\<0\>\/XI2\<1\>\/RR2_neg \
 ) R_1X_LL w=1e-07 l=1e-07   res=0.149966
XXI2\<0\>\/XI2\<0\>\/XI2\<1\>\/XI2\<1\>\/XI2\<0\>\/XI2\<1\>\/XI2\<0\>\/XI2\<1\>\/RR3 \
 (  \
 N_SEL3\<0\>_XI2\<0\>\/XI2\<0\>\/XI2\<1\>\/XI2\<1\>\/XI2\<0\>\/XI2\<1\>\/XI2\<0\>\/XI2\<1\>\/RR3_pos \
 N_WLSEL\<427\>_XI2\<0\>\/XI2\<0\>\/XI2\<1\>\/XI2\<1\>\/XI2\<0\>\/XI2\<1\>\/XI2\<0\>\/XI2\<1\>\/RR3_neg \
 ) R_1X_LL w=1e-07 l=1e-07   res=0.149966
XXI2\<0\>\/XI2\<0\>\/XI2\<1\>\/XI2\<1\>\/XI2\<0\>\/XI2\<1\>\/XI2\<0\>\/XI2\<1\>\/RR4 \
 (  \
 N_SEL4\<1\>_XI2\<0\>\/XI2\<0\>\/XI2\<1\>\/XI2\<1\>\/XI2\<0\>\/XI2\<1\>\/XI2\<0\>\/XI2\<1\>\/RR4_pos \
 N_WLSEL\<428\>_XI2\<0\>\/XI2\<0\>\/XI2\<1\>\/XI2\<1\>\/XI2\<0\>\/XI2\<1\>\/XI2\<0\>\/XI2\<1\>\/RR4_neg \
 ) R_1X_LL w=1e-07 l=1e-07   res=0.149966
XXI2\<0\>\/XI2\<0\>\/XI2\<1\>\/XI2\<1\>\/XI2\<0\>\/XI2\<1\>\/XI2\<0\>\/XI2\<1\>\/RR7 \
 (  \
 N_SEL5\<1\>_XI2\<0\>\/XI2\<0\>\/XI2\<1\>\/XI2\<1\>\/XI2\<0\>\/XI2\<1\>\/XI2\<0\>\/XI2\<1\>\/RR7_pos \
 N_WLSEL\<429\>_XI2\<0\>\/XI2\<0\>\/XI2\<1\>\/XI2\<1\>\/XI2\<0\>\/XI2\<1\>\/XI2\<0\>\/XI2\<1\>\/RR7_neg \
 ) R_1X_LL w=1e-07 l=1e-07   res=0.149966
XXI2\<0\>\/XI2\<0\>\/XI2\<1\>\/XI2\<1\>\/XI2\<0\>\/XI2\<1\>\/XI2\<0\>\/XI2\<1\>\/RR6 \
 (  \
 N_SEL6\<0\>_XI2\<0\>\/XI2\<0\>\/XI2\<1\>\/XI2\<1\>\/XI2\<0\>\/XI2\<1\>\/XI2\<0\>\/XI2\<1\>\/RR6_pos \
 N_WLSEL\<430\>_XI2\<0\>\/XI2\<0\>\/XI2\<1\>\/XI2\<1\>\/XI2\<0\>\/XI2\<1\>\/XI2\<0\>\/XI2\<1\>\/RR6_neg \
 ) R_1X_LL w=1e-07 l=1e-07   res=0.149966
XXI2\<1\>\/XI2\<1\>\/XI2\<1\>\/XI2\<0\>\/XI2\<0\>\/XI2\<0\>\/XI2\<0\>\/XI2\<1\>\/RR5 \
 (  \
 N_SEL7\<1\>_XI2\<1\>\/XI2\<1\>\/XI2\<1\>\/XI2\<0\>\/XI2\<0\>\/XI2\<0\>\/XI2\<0\>\/XI2\<1\>\/RR5_pos \
 N_WLSEL\<1807\>_XI2\<1\>\/XI2\<1\>\/XI2\<1\>\/XI2\<0\>\/XI2\<0\>\/XI2\<0\>\/XI2\<0\>\/XI2\<1\>\/RR5_neg \
 ) R_1X_LL w=1e-07 l=1e-07   res=0.149966
XXI2\<1\>\/XI2\<1\>\/XI2\<1\>\/XI2\<0\>\/XI2\<0\>\/XI2\<0\>\/XI2\<1\>\/XI2\<0\>\/RR0 \
 (  \
 N_SEL0\<0\>_XI2\<1\>\/XI2\<1\>\/XI2\<1\>\/XI2\<0\>\/XI2\<0\>\/XI2\<0\>\/XI2\<1\>\/XI2\<0\>\/RR0_pos \
 N_WLSEL\<1808\>_XI2\<1\>\/XI2\<1\>\/XI2\<1\>\/XI2\<0\>\/XI2\<0\>\/XI2\<0\>\/XI2\<1\>\/XI2\<0\>\/RR0_neg \
 ) R_1X_LL w=1e-07 l=1e-07   res=0.149966
XXI2\<1\>\/XI2\<1\>\/XI2\<1\>\/XI2\<0\>\/XI2\<0\>\/XI2\<0\>\/XI2\<1\>\/XI2\<0\>\/RR1 \
 (  \
 N_SEL1\<1\>_XI2\<1\>\/XI2\<1\>\/XI2\<1\>\/XI2\<0\>\/XI2\<0\>\/XI2\<0\>\/XI2\<1\>\/XI2\<0\>\/RR1_pos \
 N_WLSEL\<1809\>_XI2\<1\>\/XI2\<1\>\/XI2\<1\>\/XI2\<0\>\/XI2\<0\>\/XI2\<0\>\/XI2\<1\>\/XI2\<0\>\/RR1_neg \
 ) R_1X_LL w=1e-07 l=1e-07   res=0.149966
XXI2\<1\>\/XI2\<1\>\/XI2\<1\>\/XI2\<0\>\/XI2\<0\>\/XI2\<0\>\/XI2\<1\>\/XI2\<0\>\/RR2 \
 (  \
 N_SEL2\<0\>_XI2\<1\>\/XI2\<1\>\/XI2\<1\>\/XI2\<0\>\/XI2\<0\>\/XI2\<0\>\/XI2\<1\>\/XI2\<0\>\/RR2_pos \
 N_WLSEL\<1810\>_XI2\<1\>\/XI2\<1\>\/XI2\<1\>\/XI2\<0\>\/XI2\<0\>\/XI2\<0\>\/XI2\<1\>\/XI2\<0\>\/RR2_neg \
 ) R_1X_LL w=1e-07 l=1e-07   res=0.149966
XXI2\<1\>\/XI2\<1\>\/XI2\<1\>\/XI2\<0\>\/XI2\<0\>\/XI2\<0\>\/XI2\<1\>\/XI2\<0\>\/RR3 \
 (  \
 N_SEL3\<0\>_XI2\<1\>\/XI2\<1\>\/XI2\<1\>\/XI2\<0\>\/XI2\<0\>\/XI2\<0\>\/XI2\<1\>\/XI2\<0\>\/RR3_pos \
 N_WLSEL\<1811\>_XI2\<1\>\/XI2\<1\>\/XI2\<1\>\/XI2\<0\>\/XI2\<0\>\/XI2\<0\>\/XI2\<1\>\/XI2\<0\>\/RR3_neg \
 ) R_1X_LL w=1e-07 l=1e-07   res=0.149966
XXI2\<1\>\/XI2\<1\>\/XI2\<1\>\/XI2\<0\>\/XI2\<0\>\/XI2\<0\>\/XI2\<1\>\/XI2\<0\>\/RR4 \
 (  \
 N_SEL4\<0\>_XI2\<1\>\/XI2\<1\>\/XI2\<1\>\/XI2\<0\>\/XI2\<0\>\/XI2\<0\>\/XI2\<1\>\/XI2\<0\>\/RR4_pos \
 N_WLSEL\<1812\>_XI2\<1\>\/XI2\<1\>\/XI2\<1\>\/XI2\<0\>\/XI2\<0\>\/XI2\<0\>\/XI2\<1\>\/XI2\<0\>\/RR4_neg \
 ) R_1X_LL w=1e-07 l=1e-07   res=0.149966
XXI2\<1\>\/XI2\<1\>\/XI2\<1\>\/XI2\<0\>\/XI2\<0\>\/XI2\<0\>\/XI2\<1\>\/XI2\<0\>\/RR7 \
 (  \
 N_SEL5\<1\>_XI2\<1\>\/XI2\<1\>\/XI2\<1\>\/XI2\<0\>\/XI2\<0\>\/XI2\<0\>\/XI2\<1\>\/XI2\<0\>\/RR7_pos \
 N_WLSEL\<1813\>_XI2\<1\>\/XI2\<1\>\/XI2\<1\>\/XI2\<0\>\/XI2\<0\>\/XI2\<0\>\/XI2\<1\>\/XI2\<0\>\/RR7_neg \
 ) R_1X_LL w=1e-07 l=1e-07   res=0.149966
XXI2\<1\>\/XI2\<1\>\/XI2\<1\>\/XI2\<0\>\/XI2\<0\>\/XI2\<0\>\/XI2\<1\>\/XI2\<0\>\/RR6 \
 (  \
 N_SEL6\<1\>_XI2\<1\>\/XI2\<1\>\/XI2\<1\>\/XI2\<0\>\/XI2\<0\>\/XI2\<0\>\/XI2\<1\>\/XI2\<0\>\/RR6_pos \
 N_WLSEL\<1814\>_XI2\<1\>\/XI2\<1\>\/XI2\<1\>\/XI2\<0\>\/XI2\<0\>\/XI2\<0\>\/XI2\<1\>\/XI2\<0\>\/RR6_neg \
 ) R_1X_LL w=1e-07 l=1e-07   res=0.149966
XXI2\<1\>\/XI2\<1\>\/XI2\<1\>\/XI2\<0\>\/XI2\<0\>\/XI2\<0\>\/XI2\<1\>\/XI2\<0\>\/RR5 \
 (  \
 N_SEL7\<1\>_XI2\<1\>\/XI2\<1\>\/XI2\<1\>\/XI2\<0\>\/XI2\<0\>\/XI2\<0\>\/XI2\<1\>\/XI2\<0\>\/RR5_pos \
 N_WLSEL\<1815\>_XI2\<1\>\/XI2\<1\>\/XI2\<1\>\/XI2\<0\>\/XI2\<0\>\/XI2\<0\>\/XI2\<1\>\/XI2\<0\>\/RR5_neg \
 ) R_1X_LL w=1e-07 l=1e-07   res=0.149966
XXI2\<1\>\/XI2\<1\>\/XI2\<1\>\/XI2\<0\>\/XI2\<0\>\/XI2\<0\>\/XI2\<1\>\/XI2\<1\>\/RR0 \
 (  \
 N_SEL0\<1\>_XI2\<1\>\/XI2\<1\>\/XI2\<1\>\/XI2\<0\>\/XI2\<0\>\/XI2\<0\>\/XI2\<1\>\/XI2\<1\>\/RR0_pos \
 N_WLSEL\<1816\>_XI2\<1\>\/XI2\<1\>\/XI2\<1\>\/XI2\<0\>\/XI2\<0\>\/XI2\<0\>\/XI2\<1\>\/XI2\<1\>\/RR0_neg \
 ) R_1X_LL w=1e-07 l=1e-07   res=0.149966
XXI2\<1\>\/XI2\<1\>\/XI2\<1\>\/XI2\<0\>\/XI2\<0\>\/XI2\<0\>\/XI2\<1\>\/XI2\<1\>\/RR1 \
 (  \
 N_SEL1\<1\>_XI2\<1\>\/XI2\<1\>\/XI2\<1\>\/XI2\<0\>\/XI2\<0\>\/XI2\<0\>\/XI2\<1\>\/XI2\<1\>\/RR1_pos \
 N_WLSEL\<1817\>_XI2\<1\>\/XI2\<1\>\/XI2\<1\>\/XI2\<0\>\/XI2\<0\>\/XI2\<0\>\/XI2\<1\>\/XI2\<1\>\/RR1_neg \
 ) R_1X_LL w=1e-07 l=1e-07   res=0.149966
XXI2\<1\>\/XI2\<1\>\/XI2\<1\>\/XI2\<0\>\/XI2\<0\>\/XI2\<0\>\/XI2\<1\>\/XI2\<1\>\/RR2 \
 (  \
 N_SEL2\<0\>_XI2\<1\>\/XI2\<1\>\/XI2\<1\>\/XI2\<0\>\/XI2\<0\>\/XI2\<0\>\/XI2\<1\>\/XI2\<1\>\/RR2_pos \
 N_WLSEL\<1818\>_XI2\<1\>\/XI2\<1\>\/XI2\<1\>\/XI2\<0\>\/XI2\<0\>\/XI2\<0\>\/XI2\<1\>\/XI2\<1\>\/RR2_neg \
 ) R_1X_LL w=1e-07 l=1e-07   res=0.149966
XXI2\<1\>\/XI2\<1\>\/XI2\<1\>\/XI2\<0\>\/XI2\<0\>\/XI2\<0\>\/XI2\<1\>\/XI2\<1\>\/RR3 \
 (  \
 N_SEL3\<0\>_XI2\<1\>\/XI2\<1\>\/XI2\<1\>\/XI2\<0\>\/XI2\<0\>\/XI2\<0\>\/XI2\<1\>\/XI2\<1\>\/RR3_pos \
 N_WLSEL\<1819\>_XI2\<1\>\/XI2\<1\>\/XI2\<1\>\/XI2\<0\>\/XI2\<0\>\/XI2\<0\>\/XI2\<1\>\/XI2\<1\>\/RR3_neg \
 ) R_1X_LL w=1e-07 l=1e-07   res=0.149966
XXI2\<1\>\/XI2\<1\>\/XI2\<1\>\/XI2\<0\>\/XI2\<0\>\/XI2\<0\>\/XI2\<1\>\/XI2\<1\>\/RR4 \
 (  \
 N_SEL4\<0\>_XI2\<1\>\/XI2\<1\>\/XI2\<1\>\/XI2\<0\>\/XI2\<0\>\/XI2\<0\>\/XI2\<1\>\/XI2\<1\>\/RR4_pos \
 N_WLSEL\<1820\>_XI2\<1\>\/XI2\<1\>\/XI2\<1\>\/XI2\<0\>\/XI2\<0\>\/XI2\<0\>\/XI2\<1\>\/XI2\<1\>\/RR4_neg \
 ) R_1X_LL w=1e-07 l=1e-07   res=0.149966
XXI2\<1\>\/XI2\<1\>\/XI2\<1\>\/XI2\<0\>\/XI2\<0\>\/XI2\<0\>\/XI2\<1\>\/XI2\<1\>\/RR7 \
 (  \
 N_SEL5\<1\>_XI2\<1\>\/XI2\<1\>\/XI2\<1\>\/XI2\<0\>\/XI2\<0\>\/XI2\<0\>\/XI2\<1\>\/XI2\<1\>\/RR7_pos \
 N_WLSEL\<1821\>_XI2\<1\>\/XI2\<1\>\/XI2\<1\>\/XI2\<0\>\/XI2\<0\>\/XI2\<0\>\/XI2\<1\>\/XI2\<1\>\/RR7_neg \
 ) R_1X_LL w=1e-07 l=1e-07   res=0.149966
XXI2\<1\>\/XI2\<1\>\/XI2\<1\>\/XI2\<0\>\/XI2\<0\>\/XI2\<0\>\/XI2\<1\>\/XI2\<1\>\/RR6 \
 (  \
 N_SEL6\<1\>_XI2\<1\>\/XI2\<1\>\/XI2\<1\>\/XI2\<0\>\/XI2\<0\>\/XI2\<0\>\/XI2\<1\>\/XI2\<1\>\/RR6_pos \
 N_WLSEL\<1822\>_XI2\<1\>\/XI2\<1\>\/XI2\<1\>\/XI2\<0\>\/XI2\<0\>\/XI2\<0\>\/XI2\<1\>\/XI2\<1\>\/RR6_neg \
 ) R_1X_LL w=1e-07 l=1e-07   res=0.149966
XXI2\<1\>\/XI2\<1\>\/XI2\<1\>\/XI2\<0\>\/XI2\<0\>\/XI2\<0\>\/XI2\<1\>\/XI2\<1\>\/RR5 \
 (  \
 N_SEL7\<1\>_XI2\<1\>\/XI2\<1\>\/XI2\<1\>\/XI2\<0\>\/XI2\<0\>\/XI2\<0\>\/XI2\<1\>\/XI2\<1\>\/RR5_pos \
 N_WLSEL\<1823\>_XI2\<1\>\/XI2\<1\>\/XI2\<1\>\/XI2\<0\>\/XI2\<0\>\/XI2\<0\>\/XI2\<1\>\/XI2\<1\>\/RR5_neg \
 ) R_1X_LL w=1e-07 l=1e-07   res=0.149966
XXI2\<1\>\/XI2\<1\>\/XI2\<1\>\/XI2\<0\>\/XI2\<0\>\/XI2\<1\>\/XI2\<0\>\/XI2\<0\>\/RR0 \
 (  \
 N_SEL0\<0\>_XI2\<1\>\/XI2\<1\>\/XI2\<1\>\/XI2\<0\>\/XI2\<0\>\/XI2\<1\>\/XI2\<0\>\/XI2\<0\>\/RR0_pos \
 N_WLSEL\<1824\>_XI2\<1\>\/XI2\<1\>\/XI2\<1\>\/XI2\<0\>\/XI2\<0\>\/XI2\<1\>\/XI2\<0\>\/XI2\<0\>\/RR0_neg \
 ) R_1X_LL w=1e-07 l=1e-07   res=0.149966
XXI2\<1\>\/XI2\<1\>\/XI2\<1\>\/XI2\<0\>\/XI2\<0\>\/XI2\<1\>\/XI2\<0\>\/XI2\<0\>\/RR1 \
 (  \
 N_SEL1\<0\>_XI2\<1\>\/XI2\<1\>\/XI2\<1\>\/XI2\<0\>\/XI2\<0\>\/XI2\<1\>\/XI2\<0\>\/XI2\<0\>\/RR1_pos \
 N_WLSEL\<1825\>_XI2\<1\>\/XI2\<1\>\/XI2\<1\>\/XI2\<0\>\/XI2\<0\>\/XI2\<1\>\/XI2\<0\>\/XI2\<0\>\/RR1_neg \
 ) R_1X_LL w=1e-07 l=1e-07   res=0.149966
XXI2\<1\>\/XI2\<1\>\/XI2\<1\>\/XI2\<0\>\/XI2\<0\>\/XI2\<1\>\/XI2\<0\>\/XI2\<0\>\/RR2 \
 (  \
 N_SEL2\<1\>_XI2\<1\>\/XI2\<1\>\/XI2\<1\>\/XI2\<0\>\/XI2\<0\>\/XI2\<1\>\/XI2\<0\>\/XI2\<0\>\/RR2_pos \
 N_WLSEL\<1826\>_XI2\<1\>\/XI2\<1\>\/XI2\<1\>\/XI2\<0\>\/XI2\<0\>\/XI2\<1\>\/XI2\<0\>\/XI2\<0\>\/RR2_neg \
 ) R_1X_LL w=1e-07 l=1e-07   res=0.149966
XXI2\<1\>\/XI2\<1\>\/XI2\<1\>\/XI2\<0\>\/XI2\<0\>\/XI2\<1\>\/XI2\<0\>\/XI2\<0\>\/RR3 \
 (  \
 N_SEL3\<0\>_XI2\<1\>\/XI2\<1\>\/XI2\<1\>\/XI2\<0\>\/XI2\<0\>\/XI2\<1\>\/XI2\<0\>\/XI2\<0\>\/RR3_pos \
 N_WLSEL\<1827\>_XI2\<1\>\/XI2\<1\>\/XI2\<1\>\/XI2\<0\>\/XI2\<0\>\/XI2\<1\>\/XI2\<0\>\/XI2\<0\>\/RR3_neg \
 ) R_1X_LL w=1e-07 l=1e-07   res=0.149966
XXI2\<1\>\/XI2\<1\>\/XI2\<1\>\/XI2\<0\>\/XI2\<0\>\/XI2\<1\>\/XI2\<0\>\/XI2\<0\>\/RR4 \
 (  \
 N_SEL4\<0\>_XI2\<1\>\/XI2\<1\>\/XI2\<1\>\/XI2\<0\>\/XI2\<0\>\/XI2\<1\>\/XI2\<0\>\/XI2\<0\>\/RR4_pos \
 N_WLSEL\<1828\>_XI2\<1\>\/XI2\<1\>\/XI2\<1\>\/XI2\<0\>\/XI2\<0\>\/XI2\<1\>\/XI2\<0\>\/XI2\<0\>\/RR4_neg \
 ) R_1X_LL w=1e-07 l=1e-07   res=0.149966
XXI2\<1\>\/XI2\<1\>\/XI2\<1\>\/XI2\<0\>\/XI2\<0\>\/XI2\<1\>\/XI2\<0\>\/XI2\<0\>\/RR7 \
 (  \
 N_SEL5\<1\>_XI2\<1\>\/XI2\<1\>\/XI2\<1\>\/XI2\<0\>\/XI2\<0\>\/XI2\<1\>\/XI2\<0\>\/XI2\<0\>\/RR7_pos \
 N_WLSEL\<1829\>_XI2\<1\>\/XI2\<1\>\/XI2\<1\>\/XI2\<0\>\/XI2\<0\>\/XI2\<1\>\/XI2\<0\>\/XI2\<0\>\/RR7_neg \
 ) R_1X_LL w=1e-07 l=1e-07   res=0.149966
XXI2\<1\>\/XI2\<1\>\/XI2\<1\>\/XI2\<0\>\/XI2\<0\>\/XI2\<1\>\/XI2\<0\>\/XI2\<0\>\/RR6 \
 (  \
 N_SEL6\<1\>_XI2\<1\>\/XI2\<1\>\/XI2\<1\>\/XI2\<0\>\/XI2\<0\>\/XI2\<1\>\/XI2\<0\>\/XI2\<0\>\/RR6_pos \
 N_WLSEL\<1830\>_XI2\<1\>\/XI2\<1\>\/XI2\<1\>\/XI2\<0\>\/XI2\<0\>\/XI2\<1\>\/XI2\<0\>\/XI2\<0\>\/RR6_neg \
 ) R_1X_LL w=1e-07 l=1e-07   res=0.149966
XXI2\<1\>\/XI2\<1\>\/XI2\<1\>\/XI2\<0\>\/XI2\<0\>\/XI2\<1\>\/XI2\<0\>\/XI2\<0\>\/RR5 \
 (  \
 N_SEL7\<1\>_XI2\<1\>\/XI2\<1\>\/XI2\<1\>\/XI2\<0\>\/XI2\<0\>\/XI2\<1\>\/XI2\<0\>\/XI2\<0\>\/RR5_pos \
 N_WLSEL\<1831\>_XI2\<1\>\/XI2\<1\>\/XI2\<1\>\/XI2\<0\>\/XI2\<0\>\/XI2\<1\>\/XI2\<0\>\/XI2\<0\>\/RR5_neg \
 ) R_1X_LL w=1e-07 l=1e-07   res=0.149966
XXI2\<1\>\/XI2\<1\>\/XI2\<1\>\/XI2\<0\>\/XI2\<0\>\/XI2\<1\>\/XI2\<0\>\/XI2\<1\>\/RR0 \
 (  \
 N_SEL0\<1\>_XI2\<1\>\/XI2\<1\>\/XI2\<1\>\/XI2\<0\>\/XI2\<0\>\/XI2\<1\>\/XI2\<0\>\/XI2\<1\>\/RR0_pos \
 N_WLSEL\<1832\>_XI2\<1\>\/XI2\<1\>\/XI2\<1\>\/XI2\<0\>\/XI2\<0\>\/XI2\<1\>\/XI2\<0\>\/XI2\<1\>\/RR0_neg \
 ) R_1X_LL w=1e-07 l=1e-07   res=0.149966
XXI2\<1\>\/XI2\<1\>\/XI2\<1\>\/XI2\<0\>\/XI2\<0\>\/XI2\<1\>\/XI2\<0\>\/XI2\<1\>\/RR1 \
 (  \
 N_SEL1\<0\>_XI2\<1\>\/XI2\<1\>\/XI2\<1\>\/XI2\<0\>\/XI2\<0\>\/XI2\<1\>\/XI2\<0\>\/XI2\<1\>\/RR1_pos \
 N_WLSEL\<1833\>_XI2\<1\>\/XI2\<1\>\/XI2\<1\>\/XI2\<0\>\/XI2\<0\>\/XI2\<1\>\/XI2\<0\>\/XI2\<1\>\/RR1_neg \
 ) R_1X_LL w=1e-07 l=1e-07   res=0.149966
XXI2\<1\>\/XI2\<1\>\/XI2\<1\>\/XI2\<0\>\/XI2\<0\>\/XI2\<1\>\/XI2\<0\>\/XI2\<1\>\/RR2 \
 (  \
 N_SEL2\<1\>_XI2\<1\>\/XI2\<1\>\/XI2\<1\>\/XI2\<0\>\/XI2\<0\>\/XI2\<1\>\/XI2\<0\>\/XI2\<1\>\/RR2_pos \
 N_WLSEL\<1834\>_XI2\<1\>\/XI2\<1\>\/XI2\<1\>\/XI2\<0\>\/XI2\<0\>\/XI2\<1\>\/XI2\<0\>\/XI2\<1\>\/RR2_neg \
 ) R_1X_LL w=1e-07 l=1e-07   res=0.149966
XXI2\<1\>\/XI2\<1\>\/XI2\<1\>\/XI2\<0\>\/XI2\<0\>\/XI2\<1\>\/XI2\<0\>\/XI2\<1\>\/RR3 \
 (  \
 N_SEL3\<0\>_XI2\<1\>\/XI2\<1\>\/XI2\<1\>\/XI2\<0\>\/XI2\<0\>\/XI2\<1\>\/XI2\<0\>\/XI2\<1\>\/RR3_pos \
 N_WLSEL\<1835\>_XI2\<1\>\/XI2\<1\>\/XI2\<1\>\/XI2\<0\>\/XI2\<0\>\/XI2\<1\>\/XI2\<0\>\/XI2\<1\>\/RR3_neg \
 ) R_1X_LL w=1e-07 l=1e-07   res=0.149966
XXI2\<1\>\/XI2\<1\>\/XI2\<1\>\/XI2\<0\>\/XI2\<0\>\/XI2\<1\>\/XI2\<0\>\/XI2\<1\>\/RR4 \
 (  \
 N_SEL4\<0\>_XI2\<1\>\/XI2\<1\>\/XI2\<1\>\/XI2\<0\>\/XI2\<0\>\/XI2\<1\>\/XI2\<0\>\/XI2\<1\>\/RR4_pos \
 N_WLSEL\<1836\>_XI2\<1\>\/XI2\<1\>\/XI2\<1\>\/XI2\<0\>\/XI2\<0\>\/XI2\<1\>\/XI2\<0\>\/XI2\<1\>\/RR4_neg \
 ) R_1X_LL w=1e-07 l=1e-07   res=0.149966
XXI2\<1\>\/XI2\<1\>\/XI2\<1\>\/XI2\<0\>\/XI2\<0\>\/XI2\<1\>\/XI2\<0\>\/XI2\<1\>\/RR7 \
 (  \
 N_SEL5\<1\>_XI2\<1\>\/XI2\<1\>\/XI2\<1\>\/XI2\<0\>\/XI2\<0\>\/XI2\<1\>\/XI2\<0\>\/XI2\<1\>\/RR7_pos \
 N_WLSEL\<1837\>_XI2\<1\>\/XI2\<1\>\/XI2\<1\>\/XI2\<0\>\/XI2\<0\>\/XI2\<1\>\/XI2\<0\>\/XI2\<1\>\/RR7_neg \
 ) R_1X_LL w=1e-07 l=1e-07   res=0.149966
XXI2\<1\>\/XI2\<1\>\/XI2\<1\>\/XI2\<0\>\/XI2\<0\>\/XI2\<1\>\/XI2\<0\>\/XI2\<1\>\/RR6 \
 (  \
 N_SEL6\<1\>_XI2\<1\>\/XI2\<1\>\/XI2\<1\>\/XI2\<0\>\/XI2\<0\>\/XI2\<1\>\/XI2\<0\>\/XI2\<1\>\/RR6_pos \
 N_WLSEL\<1838\>_XI2\<1\>\/XI2\<1\>\/XI2\<1\>\/XI2\<0\>\/XI2\<0\>\/XI2\<1\>\/XI2\<0\>\/XI2\<1\>\/RR6_neg \
 ) R_1X_LL w=1e-07 l=1e-07   res=0.149966
XXI2\<1\>\/XI2\<1\>\/XI2\<1\>\/XI2\<0\>\/XI2\<0\>\/XI2\<1\>\/XI2\<0\>\/XI2\<1\>\/RR5 \
 (  \
 N_SEL7\<1\>_XI2\<1\>\/XI2\<1\>\/XI2\<1\>\/XI2\<0\>\/XI2\<0\>\/XI2\<1\>\/XI2\<0\>\/XI2\<1\>\/RR5_pos \
 N_WLSEL\<1839\>_XI2\<1\>\/XI2\<1\>\/XI2\<1\>\/XI2\<0\>\/XI2\<0\>\/XI2\<1\>\/XI2\<0\>\/XI2\<1\>\/RR5_neg \
 ) R_1X_LL w=1e-07 l=1e-07   res=0.149966
XXI2\<1\>\/XI2\<1\>\/XI2\<1\>\/XI2\<0\>\/XI2\<0\>\/XI2\<1\>\/XI2\<1\>\/XI2\<0\>\/RR0 \
 (  \
 N_SEL0\<0\>_XI2\<1\>\/XI2\<1\>\/XI2\<1\>\/XI2\<0\>\/XI2\<0\>\/XI2\<1\>\/XI2\<1\>\/XI2\<0\>\/RR0_pos \
 N_WLSEL\<1840\>_XI2\<1\>\/XI2\<1\>\/XI2\<1\>\/XI2\<0\>\/XI2\<0\>\/XI2\<1\>\/XI2\<1\>\/XI2\<0\>\/RR0_neg \
 ) R_1X_LL w=1e-07 l=1e-07   res=0.149966
XXI2\<1\>\/XI2\<1\>\/XI2\<1\>\/XI2\<0\>\/XI2\<0\>\/XI2\<1\>\/XI2\<1\>\/XI2\<0\>\/RR1 \
 (  \
 N_SEL1\<1\>_XI2\<1\>\/XI2\<1\>\/XI2\<1\>\/XI2\<0\>\/XI2\<0\>\/XI2\<1\>\/XI2\<1\>\/XI2\<0\>\/RR1_pos \
 N_WLSEL\<1841\>_XI2\<1\>\/XI2\<1\>\/XI2\<1\>\/XI2\<0\>\/XI2\<0\>\/XI2\<1\>\/XI2\<1\>\/XI2\<0\>\/RR1_neg \
 ) R_1X_LL w=1e-07 l=1e-07   res=0.149966
XXI2\<1\>\/XI2\<1\>\/XI2\<1\>\/XI2\<0\>\/XI2\<0\>\/XI2\<1\>\/XI2\<1\>\/XI2\<0\>\/RR2 \
 (  \
 N_SEL2\<1\>_XI2\<1\>\/XI2\<1\>\/XI2\<1\>\/XI2\<0\>\/XI2\<0\>\/XI2\<1\>\/XI2\<1\>\/XI2\<0\>\/RR2_pos \
 N_WLSEL\<1842\>_XI2\<1\>\/XI2\<1\>\/XI2\<1\>\/XI2\<0\>\/XI2\<0\>\/XI2\<1\>\/XI2\<1\>\/XI2\<0\>\/RR2_neg \
 ) R_1X_LL w=1e-07 l=1e-07   res=0.149966
XXI2\<1\>\/XI2\<1\>\/XI2\<1\>\/XI2\<0\>\/XI2\<0\>\/XI2\<1\>\/XI2\<1\>\/XI2\<0\>\/RR3 \
 (  \
 N_SEL3\<0\>_XI2\<1\>\/XI2\<1\>\/XI2\<1\>\/XI2\<0\>\/XI2\<0\>\/XI2\<1\>\/XI2\<1\>\/XI2\<0\>\/RR3_pos \
 N_WLSEL\<1843\>_XI2\<1\>\/XI2\<1\>\/XI2\<1\>\/XI2\<0\>\/XI2\<0\>\/XI2\<1\>\/XI2\<1\>\/XI2\<0\>\/RR3_neg \
 ) R_1X_LL w=1e-07 l=1e-07   res=0.149966
XXI2\<1\>\/XI2\<1\>\/XI2\<1\>\/XI2\<0\>\/XI2\<0\>\/XI2\<1\>\/XI2\<1\>\/XI2\<0\>\/RR4 \
 (  \
 N_SEL4\<0\>_XI2\<1\>\/XI2\<1\>\/XI2\<1\>\/XI2\<0\>\/XI2\<0\>\/XI2\<1\>\/XI2\<1\>\/XI2\<0\>\/RR4_pos \
 N_WLSEL\<1844\>_XI2\<1\>\/XI2\<1\>\/XI2\<1\>\/XI2\<0\>\/XI2\<0\>\/XI2\<1\>\/XI2\<1\>\/XI2\<0\>\/RR4_neg \
 ) R_1X_LL w=1e-07 l=1e-07   res=0.149966
XXI2\<1\>\/XI2\<1\>\/XI2\<1\>\/XI2\<0\>\/XI2\<0\>\/XI2\<1\>\/XI2\<1\>\/XI2\<0\>\/RR7 \
 (  \
 N_SEL5\<1\>_XI2\<1\>\/XI2\<1\>\/XI2\<1\>\/XI2\<0\>\/XI2\<0\>\/XI2\<1\>\/XI2\<1\>\/XI2\<0\>\/RR7_pos \
 N_WLSEL\<1845\>_XI2\<1\>\/XI2\<1\>\/XI2\<1\>\/XI2\<0\>\/XI2\<0\>\/XI2\<1\>\/XI2\<1\>\/XI2\<0\>\/RR7_neg \
 ) R_1X_LL w=1e-07 l=1e-07   res=0.149966
XXI2\<1\>\/XI2\<1\>\/XI2\<1\>\/XI2\<0\>\/XI2\<0\>\/XI2\<1\>\/XI2\<1\>\/XI2\<0\>\/RR6 \
 (  \
 N_SEL6\<1\>_XI2\<1\>\/XI2\<1\>\/XI2\<1\>\/XI2\<0\>\/XI2\<0\>\/XI2\<1\>\/XI2\<1\>\/XI2\<0\>\/RR6_pos \
 N_WLSEL\<1846\>_XI2\<1\>\/XI2\<1\>\/XI2\<1\>\/XI2\<0\>\/XI2\<0\>\/XI2\<1\>\/XI2\<1\>\/XI2\<0\>\/RR6_neg \
 ) R_1X_LL w=1e-07 l=1e-07   res=0.149966
XXI2\<1\>\/XI2\<1\>\/XI2\<1\>\/XI2\<0\>\/XI2\<0\>\/XI2\<1\>\/XI2\<1\>\/XI2\<0\>\/RR5 \
 (  \
 N_SEL7\<1\>_XI2\<1\>\/XI2\<1\>\/XI2\<1\>\/XI2\<0\>\/XI2\<0\>\/XI2\<1\>\/XI2\<1\>\/XI2\<0\>\/RR5_pos \
 N_WLSEL\<1847\>_XI2\<1\>\/XI2\<1\>\/XI2\<1\>\/XI2\<0\>\/XI2\<0\>\/XI2\<1\>\/XI2\<1\>\/XI2\<0\>\/RR5_neg \
 ) R_1X_LL w=1e-07 l=1e-07   res=0.149966
XXI2\<1\>\/XI2\<1\>\/XI2\<1\>\/XI2\<0\>\/XI2\<0\>\/XI2\<1\>\/XI2\<1\>\/XI2\<1\>\/RR0 \
 (  \
 N_SEL0\<1\>_XI2\<1\>\/XI2\<1\>\/XI2\<1\>\/XI2\<0\>\/XI2\<0\>\/XI2\<1\>\/XI2\<1\>\/XI2\<1\>\/RR0_pos \
 N_WLSEL\<1848\>_XI2\<1\>\/XI2\<1\>\/XI2\<1\>\/XI2\<0\>\/XI2\<0\>\/XI2\<1\>\/XI2\<1\>\/XI2\<1\>\/RR0_neg \
 ) R_1X_LL w=1e-07 l=1e-07   res=0.149966
XXI2\<1\>\/XI2\<1\>\/XI2\<1\>\/XI2\<0\>\/XI2\<0\>\/XI2\<1\>\/XI2\<1\>\/XI2\<1\>\/RR1 \
 (  \
 N_SEL1\<1\>_XI2\<1\>\/XI2\<1\>\/XI2\<1\>\/XI2\<0\>\/XI2\<0\>\/XI2\<1\>\/XI2\<1\>\/XI2\<1\>\/RR1_pos \
 N_WLSEL\<1849\>_XI2\<1\>\/XI2\<1\>\/XI2\<1\>\/XI2\<0\>\/XI2\<0\>\/XI2\<1\>\/XI2\<1\>\/XI2\<1\>\/RR1_neg \
 ) R_1X_LL w=1e-07 l=1e-07   res=0.149966
XXI2\<1\>\/XI2\<1\>\/XI2\<1\>\/XI2\<0\>\/XI2\<0\>\/XI2\<1\>\/XI2\<1\>\/XI2\<1\>\/RR2 \
 (  \
 N_SEL2\<1\>_XI2\<1\>\/XI2\<1\>\/XI2\<1\>\/XI2\<0\>\/XI2\<0\>\/XI2\<1\>\/XI2\<1\>\/XI2\<1\>\/RR2_pos \
 N_WLSEL\<1850\>_XI2\<1\>\/XI2\<1\>\/XI2\<1\>\/XI2\<0\>\/XI2\<0\>\/XI2\<1\>\/XI2\<1\>\/XI2\<1\>\/RR2_neg \
 ) R_1X_LL w=1e-07 l=1e-07   res=0.149966
XXI2\<1\>\/XI2\<1\>\/XI2\<1\>\/XI2\<0\>\/XI2\<0\>\/XI2\<1\>\/XI2\<1\>\/XI2\<1\>\/RR3 \
 (  \
 N_SEL3\<0\>_XI2\<1\>\/XI2\<1\>\/XI2\<1\>\/XI2\<0\>\/XI2\<0\>\/XI2\<1\>\/XI2\<1\>\/XI2\<1\>\/RR3_pos \
 N_WLSEL\<1851\>_XI2\<1\>\/XI2\<1\>\/XI2\<1\>\/XI2\<0\>\/XI2\<0\>\/XI2\<1\>\/XI2\<1\>\/XI2\<1\>\/RR3_neg \
 ) R_1X_LL w=1e-07 l=1e-07   res=0.149966
XXI2\<1\>\/XI2\<1\>\/XI2\<1\>\/XI2\<0\>\/XI2\<0\>\/XI2\<1\>\/XI2\<1\>\/XI2\<1\>\/RR4 \
 (  \
 N_SEL4\<0\>_XI2\<1\>\/XI2\<1\>\/XI2\<1\>\/XI2\<0\>\/XI2\<0\>\/XI2\<1\>\/XI2\<1\>\/XI2\<1\>\/RR4_pos \
 N_WLSEL\<1852\>_XI2\<1\>\/XI2\<1\>\/XI2\<1\>\/XI2\<0\>\/XI2\<0\>\/XI2\<1\>\/XI2\<1\>\/XI2\<1\>\/RR4_neg \
 ) R_1X_LL w=1e-07 l=1e-07   res=0.149966
XXI2\<1\>\/XI2\<1\>\/XI2\<1\>\/XI2\<0\>\/XI2\<0\>\/XI2\<1\>\/XI2\<1\>\/XI2\<1\>\/RR7 \
 (  \
 N_SEL5\<1\>_XI2\<1\>\/XI2\<1\>\/XI2\<1\>\/XI2\<0\>\/XI2\<0\>\/XI2\<1\>\/XI2\<1\>\/XI2\<1\>\/RR7_pos \
 N_WLSEL\<1853\>_XI2\<1\>\/XI2\<1\>\/XI2\<1\>\/XI2\<0\>\/XI2\<0\>\/XI2\<1\>\/XI2\<1\>\/XI2\<1\>\/RR7_neg \
 ) R_1X_LL w=1e-07 l=1e-07   res=0.149966
XXI2\<1\>\/XI2\<1\>\/XI2\<1\>\/XI2\<0\>\/XI2\<0\>\/XI2\<1\>\/XI2\<1\>\/XI2\<1\>\/RR6 \
 (  \
 N_SEL6\<1\>_XI2\<1\>\/XI2\<1\>\/XI2\<1\>\/XI2\<0\>\/XI2\<0\>\/XI2\<1\>\/XI2\<1\>\/XI2\<1\>\/RR6_pos \
 N_WLSEL\<1854\>_XI2\<1\>\/XI2\<1\>\/XI2\<1\>\/XI2\<0\>\/XI2\<0\>\/XI2\<1\>\/XI2\<1\>\/XI2\<1\>\/RR6_neg \
 ) R_1X_LL w=1e-07 l=1e-07   res=0.149966
XXI2\<1\>\/XI2\<1\>\/XI2\<1\>\/XI2\<0\>\/XI2\<0\>\/XI2\<1\>\/XI2\<1\>\/XI2\<1\>\/RR5 \
 (  \
 N_SEL7\<1\>_XI2\<1\>\/XI2\<1\>\/XI2\<1\>\/XI2\<0\>\/XI2\<0\>\/XI2\<1\>\/XI2\<1\>\/XI2\<1\>\/RR5_pos \
 N_WLSEL\<1855\>_XI2\<1\>\/XI2\<1\>\/XI2\<1\>\/XI2\<0\>\/XI2\<0\>\/XI2\<1\>\/XI2\<1\>\/XI2\<1\>\/RR5_neg \
 ) R_1X_LL w=1e-07 l=1e-07   res=0.149966
XXI2\<1\>\/XI2\<1\>\/XI2\<1\>\/XI2\<0\>\/XI2\<1\>\/XI2\<0\>\/XI2\<0\>\/XI2\<0\>\/RR0 \
 (  \
 N_SEL0\<0\>_XI2\<1\>\/XI2\<1\>\/XI2\<1\>\/XI2\<0\>\/XI2\<1\>\/XI2\<0\>\/XI2\<0\>\/XI2\<0\>\/RR0_pos \
 N_WLSEL\<1856\>_XI2\<1\>\/XI2\<1\>\/XI2\<1\>\/XI2\<0\>\/XI2\<1\>\/XI2\<0\>\/XI2\<0\>\/XI2\<0\>\/RR0_neg \
 ) R_1X_LL w=1e-07 l=1e-07   res=0.149966
XXI2\<1\>\/XI2\<1\>\/XI2\<1\>\/XI2\<0\>\/XI2\<1\>\/XI2\<0\>\/XI2\<0\>\/XI2\<0\>\/RR1 \
 (  \
 N_SEL1\<0\>_XI2\<1\>\/XI2\<1\>\/XI2\<1\>\/XI2\<0\>\/XI2\<1\>\/XI2\<0\>\/XI2\<0\>\/XI2\<0\>\/RR1_pos \
 N_WLSEL\<1857\>_XI2\<1\>\/XI2\<1\>\/XI2\<1\>\/XI2\<0\>\/XI2\<1\>\/XI2\<0\>\/XI2\<0\>\/XI2\<0\>\/RR1_neg \
 ) R_1X_LL w=1e-07 l=1e-07   res=0.149966
XXI2\<1\>\/XI2\<1\>\/XI2\<1\>\/XI2\<0\>\/XI2\<1\>\/XI2\<0\>\/XI2\<0\>\/XI2\<0\>\/RR2 \
 (  \
 N_SEL2\<0\>_XI2\<1\>\/XI2\<1\>\/XI2\<1\>\/XI2\<0\>\/XI2\<1\>\/XI2\<0\>\/XI2\<0\>\/XI2\<0\>\/RR2_pos \
 N_WLSEL\<1858\>_XI2\<1\>\/XI2\<1\>\/XI2\<1\>\/XI2\<0\>\/XI2\<1\>\/XI2\<0\>\/XI2\<0\>\/XI2\<0\>\/RR2_neg \
 ) R_1X_LL w=1e-07 l=1e-07   res=0.149966
XXI2\<1\>\/XI2\<1\>\/XI2\<1\>\/XI2\<0\>\/XI2\<1\>\/XI2\<0\>\/XI2\<0\>\/XI2\<0\>\/RR3 \
 (  \
 N_SEL3\<1\>_XI2\<1\>\/XI2\<1\>\/XI2\<1\>\/XI2\<0\>\/XI2\<1\>\/XI2\<0\>\/XI2\<0\>\/XI2\<0\>\/RR3_pos \
 N_WLSEL\<1859\>_XI2\<1\>\/XI2\<1\>\/XI2\<1\>\/XI2\<0\>\/XI2\<1\>\/XI2\<0\>\/XI2\<0\>\/XI2\<0\>\/RR3_neg \
 ) R_1X_LL w=1e-07 l=1e-07   res=0.149966
XXI2\<1\>\/XI2\<1\>\/XI2\<1\>\/XI2\<0\>\/XI2\<1\>\/XI2\<0\>\/XI2\<0\>\/XI2\<0\>\/RR4 \
 (  \
 N_SEL4\<0\>_XI2\<1\>\/XI2\<1\>\/XI2\<1\>\/XI2\<0\>\/XI2\<1\>\/XI2\<0\>\/XI2\<0\>\/XI2\<0\>\/RR4_pos \
 N_WLSEL\<1860\>_XI2\<1\>\/XI2\<1\>\/XI2\<1\>\/XI2\<0\>\/XI2\<1\>\/XI2\<0\>\/XI2\<0\>\/XI2\<0\>\/RR4_neg \
 ) R_1X_LL w=1e-07 l=1e-07   res=0.149966
XXI2\<1\>\/XI2\<1\>\/XI2\<1\>\/XI2\<0\>\/XI2\<1\>\/XI2\<0\>\/XI2\<0\>\/XI2\<0\>\/RR7 \
 (  \
 N_SEL5\<1\>_XI2\<1\>\/XI2\<1\>\/XI2\<1\>\/XI2\<0\>\/XI2\<1\>\/XI2\<0\>\/XI2\<0\>\/XI2\<0\>\/RR7_pos \
 N_WLSEL\<1861\>_XI2\<1\>\/XI2\<1\>\/XI2\<1\>\/XI2\<0\>\/XI2\<1\>\/XI2\<0\>\/XI2\<0\>\/XI2\<0\>\/RR7_neg \
 ) R_1X_LL w=1e-07 l=1e-07   res=0.149966
XXI2\<1\>\/XI2\<1\>\/XI2\<1\>\/XI2\<0\>\/XI2\<1\>\/XI2\<0\>\/XI2\<0\>\/XI2\<0\>\/RR6 \
 (  \
 N_SEL6\<1\>_XI2\<1\>\/XI2\<1\>\/XI2\<1\>\/XI2\<0\>\/XI2\<1\>\/XI2\<0\>\/XI2\<0\>\/XI2\<0\>\/RR6_pos \
 N_WLSEL\<1862\>_XI2\<1\>\/XI2\<1\>\/XI2\<1\>\/XI2\<0\>\/XI2\<1\>\/XI2\<0\>\/XI2\<0\>\/XI2\<0\>\/RR6_neg \
 ) R_1X_LL w=1e-07 l=1e-07   res=0.149966
XXI2\<1\>\/XI2\<1\>\/XI2\<1\>\/XI2\<0\>\/XI2\<1\>\/XI2\<0\>\/XI2\<0\>\/XI2\<0\>\/RR5 \
 (  \
 N_SEL7\<1\>_XI2\<1\>\/XI2\<1\>\/XI2\<1\>\/XI2\<0\>\/XI2\<1\>\/XI2\<0\>\/XI2\<0\>\/XI2\<0\>\/RR5_pos \
 N_WLSEL\<1863\>_XI2\<1\>\/XI2\<1\>\/XI2\<1\>\/XI2\<0\>\/XI2\<1\>\/XI2\<0\>\/XI2\<0\>\/XI2\<0\>\/RR5_neg \
 ) R_1X_LL w=1e-07 l=1e-07   res=0.149966
XXI2\<1\>\/XI2\<1\>\/XI2\<1\>\/XI2\<0\>\/XI2\<1\>\/XI2\<0\>\/XI2\<0\>\/XI2\<1\>\/RR0 \
 (  \
 N_SEL0\<1\>_XI2\<1\>\/XI2\<1\>\/XI2\<1\>\/XI2\<0\>\/XI2\<1\>\/XI2\<0\>\/XI2\<0\>\/XI2\<1\>\/RR0_pos \
 N_WLSEL\<1864\>_XI2\<1\>\/XI2\<1\>\/XI2\<1\>\/XI2\<0\>\/XI2\<1\>\/XI2\<0\>\/XI2\<0\>\/XI2\<1\>\/RR0_neg \
 ) R_1X_LL w=1e-07 l=1e-07   res=0.149966
XXI2\<1\>\/XI2\<1\>\/XI2\<1\>\/XI2\<0\>\/XI2\<1\>\/XI2\<0\>\/XI2\<0\>\/XI2\<1\>\/RR1 \
 (  \
 N_SEL1\<0\>_XI2\<1\>\/XI2\<1\>\/XI2\<1\>\/XI2\<0\>\/XI2\<1\>\/XI2\<0\>\/XI2\<0\>\/XI2\<1\>\/RR1_pos \
 N_WLSEL\<1865\>_XI2\<1\>\/XI2\<1\>\/XI2\<1\>\/XI2\<0\>\/XI2\<1\>\/XI2\<0\>\/XI2\<0\>\/XI2\<1\>\/RR1_neg \
 ) R_1X_LL w=1e-07 l=1e-07   res=0.149966
XXI2\<1\>\/XI2\<1\>\/XI2\<1\>\/XI2\<0\>\/XI2\<1\>\/XI2\<0\>\/XI2\<0\>\/XI2\<1\>\/RR2 \
 (  \
 N_SEL2\<0\>_XI2\<1\>\/XI2\<1\>\/XI2\<1\>\/XI2\<0\>\/XI2\<1\>\/XI2\<0\>\/XI2\<0\>\/XI2\<1\>\/RR2_pos \
 N_WLSEL\<1866\>_XI2\<1\>\/XI2\<1\>\/XI2\<1\>\/XI2\<0\>\/XI2\<1\>\/XI2\<0\>\/XI2\<0\>\/XI2\<1\>\/RR2_neg \
 ) R_1X_LL w=1e-07 l=1e-07   res=0.149966
XXI2\<1\>\/XI2\<1\>\/XI2\<1\>\/XI2\<0\>\/XI2\<1\>\/XI2\<0\>\/XI2\<0\>\/XI2\<1\>\/RR3 \
 (  \
 N_SEL3\<1\>_XI2\<1\>\/XI2\<1\>\/XI2\<1\>\/XI2\<0\>\/XI2\<1\>\/XI2\<0\>\/XI2\<0\>\/XI2\<1\>\/RR3_pos \
 N_WLSEL\<1867\>_XI2\<1\>\/XI2\<1\>\/XI2\<1\>\/XI2\<0\>\/XI2\<1\>\/XI2\<0\>\/XI2\<0\>\/XI2\<1\>\/RR3_neg \
 ) R_1X_LL w=1e-07 l=1e-07   res=0.149966
XXI2\<1\>\/XI2\<1\>\/XI2\<1\>\/XI2\<0\>\/XI2\<1\>\/XI2\<0\>\/XI2\<0\>\/XI2\<1\>\/RR4 \
 (  \
 N_SEL4\<0\>_XI2\<1\>\/XI2\<1\>\/XI2\<1\>\/XI2\<0\>\/XI2\<1\>\/XI2\<0\>\/XI2\<0\>\/XI2\<1\>\/RR4_pos \
 N_WLSEL\<1868\>_XI2\<1\>\/XI2\<1\>\/XI2\<1\>\/XI2\<0\>\/XI2\<1\>\/XI2\<0\>\/XI2\<0\>\/XI2\<1\>\/RR4_neg \
 ) R_1X_LL w=1e-07 l=1e-07   res=0.149966
XXI2\<1\>\/XI2\<1\>\/XI2\<1\>\/XI2\<0\>\/XI2\<1\>\/XI2\<0\>\/XI2\<0\>\/XI2\<1\>\/RR7 \
 (  \
 N_SEL5\<1\>_XI2\<1\>\/XI2\<1\>\/XI2\<1\>\/XI2\<0\>\/XI2\<1\>\/XI2\<0\>\/XI2\<0\>\/XI2\<1\>\/RR7_pos \
 N_WLSEL\<1869\>_XI2\<1\>\/XI2\<1\>\/XI2\<1\>\/XI2\<0\>\/XI2\<1\>\/XI2\<0\>\/XI2\<0\>\/XI2\<1\>\/RR7_neg \
 ) R_1X_LL w=1e-07 l=1e-07   res=0.149966
XXI2\<1\>\/XI2\<1\>\/XI2\<1\>\/XI2\<0\>\/XI2\<1\>\/XI2\<0\>\/XI2\<0\>\/XI2\<1\>\/RR6 \
 (  \
 N_SEL6\<1\>_XI2\<1\>\/XI2\<1\>\/XI2\<1\>\/XI2\<0\>\/XI2\<1\>\/XI2\<0\>\/XI2\<0\>\/XI2\<1\>\/RR6_pos \
 N_WLSEL\<1870\>_XI2\<1\>\/XI2\<1\>\/XI2\<1\>\/XI2\<0\>\/XI2\<1\>\/XI2\<0\>\/XI2\<0\>\/XI2\<1\>\/RR6_neg \
 ) R_1X_LL w=1e-07 l=1e-07   res=0.149966
XXI2\<1\>\/XI2\<1\>\/XI2\<1\>\/XI2\<0\>\/XI2\<1\>\/XI2\<0\>\/XI2\<0\>\/XI2\<1\>\/RR5 \
 (  \
 N_SEL7\<1\>_XI2\<1\>\/XI2\<1\>\/XI2\<1\>\/XI2\<0\>\/XI2\<1\>\/XI2\<0\>\/XI2\<0\>\/XI2\<1\>\/RR5_pos \
 N_WLSEL\<1871\>_XI2\<1\>\/XI2\<1\>\/XI2\<1\>\/XI2\<0\>\/XI2\<1\>\/XI2\<0\>\/XI2\<0\>\/XI2\<1\>\/RR5_neg \
 ) R_1X_LL w=1e-07 l=1e-07   res=0.149966
XXI2\<1\>\/XI2\<1\>\/XI2\<1\>\/XI2\<0\>\/XI2\<1\>\/XI2\<0\>\/XI2\<1\>\/XI2\<0\>\/RR0 \
 (  \
 N_SEL0\<0\>_XI2\<1\>\/XI2\<1\>\/XI2\<1\>\/XI2\<0\>\/XI2\<1\>\/XI2\<0\>\/XI2\<1\>\/XI2\<0\>\/RR0_pos \
 N_WLSEL\<1872\>_XI2\<1\>\/XI2\<1\>\/XI2\<1\>\/XI2\<0\>\/XI2\<1\>\/XI2\<0\>\/XI2\<1\>\/XI2\<0\>\/RR0_neg \
 ) R_1X_LL w=1e-07 l=1e-07   res=0.149966
XXI2\<1\>\/XI2\<1\>\/XI2\<1\>\/XI2\<0\>\/XI2\<1\>\/XI2\<0\>\/XI2\<1\>\/XI2\<0\>\/RR1 \
 (  \
 N_SEL1\<1\>_XI2\<1\>\/XI2\<1\>\/XI2\<1\>\/XI2\<0\>\/XI2\<1\>\/XI2\<0\>\/XI2\<1\>\/XI2\<0\>\/RR1_pos \
 N_WLSEL\<1873\>_XI2\<1\>\/XI2\<1\>\/XI2\<1\>\/XI2\<0\>\/XI2\<1\>\/XI2\<0\>\/XI2\<1\>\/XI2\<0\>\/RR1_neg \
 ) R_1X_LL w=1e-07 l=1e-07   res=0.149966
XXI2\<1\>\/XI2\<1\>\/XI2\<1\>\/XI2\<0\>\/XI2\<1\>\/XI2\<0\>\/XI2\<1\>\/XI2\<0\>\/RR2 \
 (  \
 N_SEL2\<0\>_XI2\<1\>\/XI2\<1\>\/XI2\<1\>\/XI2\<0\>\/XI2\<1\>\/XI2\<0\>\/XI2\<1\>\/XI2\<0\>\/RR2_pos \
 N_WLSEL\<1874\>_XI2\<1\>\/XI2\<1\>\/XI2\<1\>\/XI2\<0\>\/XI2\<1\>\/XI2\<0\>\/XI2\<1\>\/XI2\<0\>\/RR2_neg \
 ) R_1X_LL w=1e-07 l=1e-07   res=0.149966
XXI2\<1\>\/XI2\<1\>\/XI2\<1\>\/XI2\<0\>\/XI2\<1\>\/XI2\<0\>\/XI2\<1\>\/XI2\<0\>\/RR3 \
 (  \
 N_SEL3\<1\>_XI2\<1\>\/XI2\<1\>\/XI2\<1\>\/XI2\<0\>\/XI2\<1\>\/XI2\<0\>\/XI2\<1\>\/XI2\<0\>\/RR3_pos \
 N_WLSEL\<1875\>_XI2\<1\>\/XI2\<1\>\/XI2\<1\>\/XI2\<0\>\/XI2\<1\>\/XI2\<0\>\/XI2\<1\>\/XI2\<0\>\/RR3_neg \
 ) R_1X_LL w=1e-07 l=1e-07   res=0.149966
XXI2\<1\>\/XI2\<1\>\/XI2\<1\>\/XI2\<0\>\/XI2\<1\>\/XI2\<0\>\/XI2\<1\>\/XI2\<0\>\/RR4 \
 (  \
 N_SEL4\<0\>_XI2\<1\>\/XI2\<1\>\/XI2\<1\>\/XI2\<0\>\/XI2\<1\>\/XI2\<0\>\/XI2\<1\>\/XI2\<0\>\/RR4_pos \
 N_WLSEL\<1876\>_XI2\<1\>\/XI2\<1\>\/XI2\<1\>\/XI2\<0\>\/XI2\<1\>\/XI2\<0\>\/XI2\<1\>\/XI2\<0\>\/RR4_neg \
 ) R_1X_LL w=1e-07 l=1e-07   res=0.149966
XXI2\<1\>\/XI2\<1\>\/XI2\<1\>\/XI2\<0\>\/XI2\<1\>\/XI2\<0\>\/XI2\<1\>\/XI2\<0\>\/RR7 \
 (  \
 N_SEL5\<1\>_XI2\<1\>\/XI2\<1\>\/XI2\<1\>\/XI2\<0\>\/XI2\<1\>\/XI2\<0\>\/XI2\<1\>\/XI2\<0\>\/RR7_pos \
 N_WLSEL\<1877\>_XI2\<1\>\/XI2\<1\>\/XI2\<1\>\/XI2\<0\>\/XI2\<1\>\/XI2\<0\>\/XI2\<1\>\/XI2\<0\>\/RR7_neg \
 ) R_1X_LL w=1e-07 l=1e-07   res=0.149966
XXI2\<1\>\/XI2\<1\>\/XI2\<1\>\/XI2\<0\>\/XI2\<1\>\/XI2\<0\>\/XI2\<1\>\/XI2\<0\>\/RR6 \
 (  \
 N_SEL6\<1\>_XI2\<1\>\/XI2\<1\>\/XI2\<1\>\/XI2\<0\>\/XI2\<1\>\/XI2\<0\>\/XI2\<1\>\/XI2\<0\>\/RR6_pos \
 N_WLSEL\<1878\>_XI2\<1\>\/XI2\<1\>\/XI2\<1\>\/XI2\<0\>\/XI2\<1\>\/XI2\<0\>\/XI2\<1\>\/XI2\<0\>\/RR6_neg \
 ) R_1X_LL w=1e-07 l=1e-07   res=0.149966
XXI2\<1\>\/XI2\<1\>\/XI2\<1\>\/XI2\<0\>\/XI2\<1\>\/XI2\<0\>\/XI2\<1\>\/XI2\<0\>\/RR5 \
 (  \
 N_SEL7\<1\>_XI2\<1\>\/XI2\<1\>\/XI2\<1\>\/XI2\<0\>\/XI2\<1\>\/XI2\<0\>\/XI2\<1\>\/XI2\<0\>\/RR5_pos \
 N_WLSEL\<1879\>_XI2\<1\>\/XI2\<1\>\/XI2\<1\>\/XI2\<0\>\/XI2\<1\>\/XI2\<0\>\/XI2\<1\>\/XI2\<0\>\/RR5_neg \
 ) R_1X_LL w=1e-07 l=1e-07   res=0.149966
XXI2\<1\>\/XI2\<1\>\/XI2\<1\>\/XI2\<0\>\/XI2\<1\>\/XI2\<0\>\/XI2\<1\>\/XI2\<1\>\/RR0 \
 (  \
 N_SEL0\<1\>_XI2\<1\>\/XI2\<1\>\/XI2\<1\>\/XI2\<0\>\/XI2\<1\>\/XI2\<0\>\/XI2\<1\>\/XI2\<1\>\/RR0_pos \
 N_WLSEL\<1880\>_XI2\<1\>\/XI2\<1\>\/XI2\<1\>\/XI2\<0\>\/XI2\<1\>\/XI2\<0\>\/XI2\<1\>\/XI2\<1\>\/RR0_neg \
 ) R_1X_LL w=1e-07 l=1e-07   res=0.149966
XXI2\<1\>\/XI2\<1\>\/XI2\<1\>\/XI2\<0\>\/XI2\<1\>\/XI2\<0\>\/XI2\<1\>\/XI2\<1\>\/RR1 \
 (  \
 N_SEL1\<1\>_XI2\<1\>\/XI2\<1\>\/XI2\<1\>\/XI2\<0\>\/XI2\<1\>\/XI2\<0\>\/XI2\<1\>\/XI2\<1\>\/RR1_pos \
 N_WLSEL\<1881\>_XI2\<1\>\/XI2\<1\>\/XI2\<1\>\/XI2\<0\>\/XI2\<1\>\/XI2\<0\>\/XI2\<1\>\/XI2\<1\>\/RR1_neg \
 ) R_1X_LL w=1e-07 l=1e-07   res=0.149966
XXI2\<1\>\/XI2\<1\>\/XI2\<1\>\/XI2\<0\>\/XI2\<1\>\/XI2\<0\>\/XI2\<1\>\/XI2\<1\>\/RR2 \
 (  \
 N_SEL2\<0\>_XI2\<1\>\/XI2\<1\>\/XI2\<1\>\/XI2\<0\>\/XI2\<1\>\/XI2\<0\>\/XI2\<1\>\/XI2\<1\>\/RR2_pos \
 N_WLSEL\<1882\>_XI2\<1\>\/XI2\<1\>\/XI2\<1\>\/XI2\<0\>\/XI2\<1\>\/XI2\<0\>\/XI2\<1\>\/XI2\<1\>\/RR2_neg \
 ) R_1X_LL w=1e-07 l=1e-07   res=0.149966
XXI2\<1\>\/XI2\<1\>\/XI2\<1\>\/XI2\<0\>\/XI2\<1\>\/XI2\<0\>\/XI2\<1\>\/XI2\<1\>\/RR3 \
 (  \
 N_SEL3\<1\>_XI2\<1\>\/XI2\<1\>\/XI2\<1\>\/XI2\<0\>\/XI2\<1\>\/XI2\<0\>\/XI2\<1\>\/XI2\<1\>\/RR3_pos \
 N_WLSEL\<1883\>_XI2\<1\>\/XI2\<1\>\/XI2\<1\>\/XI2\<0\>\/XI2\<1\>\/XI2\<0\>\/XI2\<1\>\/XI2\<1\>\/RR3_neg \
 ) R_1X_LL w=1e-07 l=1e-07   res=0.149966
XXI2\<1\>\/XI2\<1\>\/XI2\<1\>\/XI2\<0\>\/XI2\<1\>\/XI2\<0\>\/XI2\<1\>\/XI2\<1\>\/RR4 \
 (  \
 N_SEL4\<0\>_XI2\<1\>\/XI2\<1\>\/XI2\<1\>\/XI2\<0\>\/XI2\<1\>\/XI2\<0\>\/XI2\<1\>\/XI2\<1\>\/RR4_pos \
 N_WLSEL\<1884\>_XI2\<1\>\/XI2\<1\>\/XI2\<1\>\/XI2\<0\>\/XI2\<1\>\/XI2\<0\>\/XI2\<1\>\/XI2\<1\>\/RR4_neg \
 ) R_1X_LL w=1e-07 l=1e-07   res=0.149966
XXI2\<1\>\/XI2\<1\>\/XI2\<1\>\/XI2\<0\>\/XI2\<1\>\/XI2\<0\>\/XI2\<1\>\/XI2\<1\>\/RR7 \
 (  \
 N_SEL5\<1\>_XI2\<1\>\/XI2\<1\>\/XI2\<1\>\/XI2\<0\>\/XI2\<1\>\/XI2\<0\>\/XI2\<1\>\/XI2\<1\>\/RR7_pos \
 N_WLSEL\<1885\>_XI2\<1\>\/XI2\<1\>\/XI2\<1\>\/XI2\<0\>\/XI2\<1\>\/XI2\<0\>\/XI2\<1\>\/XI2\<1\>\/RR7_neg \
 ) R_1X_LL w=1e-07 l=1e-07   res=0.149966
XXI2\<1\>\/XI2\<1\>\/XI2\<1\>\/XI2\<0\>\/XI2\<1\>\/XI2\<0\>\/XI2\<1\>\/XI2\<1\>\/RR6 \
 (  \
 N_SEL6\<1\>_XI2\<1\>\/XI2\<1\>\/XI2\<1\>\/XI2\<0\>\/XI2\<1\>\/XI2\<0\>\/XI2\<1\>\/XI2\<1\>\/RR6_pos \
 N_WLSEL\<1886\>_XI2\<1\>\/XI2\<1\>\/XI2\<1\>\/XI2\<0\>\/XI2\<1\>\/XI2\<0\>\/XI2\<1\>\/XI2\<1\>\/RR6_neg \
 ) R_1X_LL w=1e-07 l=1e-07   res=0.149966
XXI2\<1\>\/XI2\<0\>\/XI2\<1\>\/XI2\<0\>\/XI2\<0\>\/XI2\<0\>\/XI2\<0\>\/XI2\<1\>\/RR5 \
 (  \
 N_SEL7\<1\>_XI2\<1\>\/XI2\<0\>\/XI2\<1\>\/XI2\<0\>\/XI2\<0\>\/XI2\<0\>\/XI2\<0\>\/XI2\<1\>\/RR5_pos \
 N_WLSEL\<1295\>_XI2\<1\>\/XI2\<0\>\/XI2\<1\>\/XI2\<0\>\/XI2\<0\>\/XI2\<0\>\/XI2\<0\>\/XI2\<1\>\/RR5_neg \
 ) R_1X_LL w=1e-07 l=1e-07   res=0.149966
XXI2\<1\>\/XI2\<0\>\/XI2\<1\>\/XI2\<0\>\/XI2\<0\>\/XI2\<0\>\/XI2\<1\>\/XI2\<0\>\/RR0 \
 (  \
 N_SEL0\<0\>_XI2\<1\>\/XI2\<0\>\/XI2\<1\>\/XI2\<0\>\/XI2\<0\>\/XI2\<0\>\/XI2\<1\>\/XI2\<0\>\/RR0_pos \
 N_WLSEL\<1296\>_XI2\<1\>\/XI2\<0\>\/XI2\<1\>\/XI2\<0\>\/XI2\<0\>\/XI2\<0\>\/XI2\<1\>\/XI2\<0\>\/RR0_neg \
 ) R_1X_LL w=1e-07 l=1e-07   res=0.149966
XXI2\<1\>\/XI2\<0\>\/XI2\<1\>\/XI2\<0\>\/XI2\<0\>\/XI2\<0\>\/XI2\<1\>\/XI2\<0\>\/RR1 \
 (  \
 N_SEL1\<1\>_XI2\<1\>\/XI2\<0\>\/XI2\<1\>\/XI2\<0\>\/XI2\<0\>\/XI2\<0\>\/XI2\<1\>\/XI2\<0\>\/RR1_pos \
 N_WLSEL\<1297\>_XI2\<1\>\/XI2\<0\>\/XI2\<1\>\/XI2\<0\>\/XI2\<0\>\/XI2\<0\>\/XI2\<1\>\/XI2\<0\>\/RR1_neg \
 ) R_1X_LL w=1e-07 l=1e-07   res=0.149966
XXI2\<1\>\/XI2\<0\>\/XI2\<1\>\/XI2\<0\>\/XI2\<0\>\/XI2\<0\>\/XI2\<1\>\/XI2\<0\>\/RR2 \
 (  \
 N_SEL2\<0\>_XI2\<1\>\/XI2\<0\>\/XI2\<1\>\/XI2\<0\>\/XI2\<0\>\/XI2\<0\>\/XI2\<1\>\/XI2\<0\>\/RR2_pos \
 N_WLSEL\<1298\>_XI2\<1\>\/XI2\<0\>\/XI2\<1\>\/XI2\<0\>\/XI2\<0\>\/XI2\<0\>\/XI2\<1\>\/XI2\<0\>\/RR2_neg \
 ) R_1X_LL w=1e-07 l=1e-07   res=0.149966
XXI2\<1\>\/XI2\<0\>\/XI2\<1\>\/XI2\<0\>\/XI2\<0\>\/XI2\<0\>\/XI2\<1\>\/XI2\<0\>\/RR3 \
 (  \
 N_SEL3\<0\>_XI2\<1\>\/XI2\<0\>\/XI2\<1\>\/XI2\<0\>\/XI2\<0\>\/XI2\<0\>\/XI2\<1\>\/XI2\<0\>\/RR3_pos \
 N_WLSEL\<1299\>_XI2\<1\>\/XI2\<0\>\/XI2\<1\>\/XI2\<0\>\/XI2\<0\>\/XI2\<0\>\/XI2\<1\>\/XI2\<0\>\/RR3_neg \
 ) R_1X_LL w=1e-07 l=1e-07   res=0.149966
XXI2\<1\>\/XI2\<0\>\/XI2\<1\>\/XI2\<0\>\/XI2\<0\>\/XI2\<0\>\/XI2\<1\>\/XI2\<0\>\/RR4 \
 (  \
 N_SEL4\<0\>_XI2\<1\>\/XI2\<0\>\/XI2\<1\>\/XI2\<0\>\/XI2\<0\>\/XI2\<0\>\/XI2\<1\>\/XI2\<0\>\/RR4_pos \
 N_WLSEL\<1300\>_XI2\<1\>\/XI2\<0\>\/XI2\<1\>\/XI2\<0\>\/XI2\<0\>\/XI2\<0\>\/XI2\<1\>\/XI2\<0\>\/RR4_neg \
 ) R_1X_LL w=1e-07 l=1e-07   res=0.149966
XXI2\<1\>\/XI2\<0\>\/XI2\<1\>\/XI2\<0\>\/XI2\<0\>\/XI2\<0\>\/XI2\<1\>\/XI2\<0\>\/RR7 \
 (  \
 N_SEL5\<1\>_XI2\<1\>\/XI2\<0\>\/XI2\<1\>\/XI2\<0\>\/XI2\<0\>\/XI2\<0\>\/XI2\<1\>\/XI2\<0\>\/RR7_pos \
 N_WLSEL\<1301\>_XI2\<1\>\/XI2\<0\>\/XI2\<1\>\/XI2\<0\>\/XI2\<0\>\/XI2\<0\>\/XI2\<1\>\/XI2\<0\>\/RR7_neg \
 ) R_1X_LL w=1e-07 l=1e-07   res=0.149966
XXI2\<1\>\/XI2\<0\>\/XI2\<1\>\/XI2\<0\>\/XI2\<0\>\/XI2\<0\>\/XI2\<1\>\/XI2\<0\>\/RR6 \
 (  \
 N_SEL6\<0\>_XI2\<1\>\/XI2\<0\>\/XI2\<1\>\/XI2\<0\>\/XI2\<0\>\/XI2\<0\>\/XI2\<1\>\/XI2\<0\>\/RR6_pos \
 N_WLSEL\<1302\>_XI2\<1\>\/XI2\<0\>\/XI2\<1\>\/XI2\<0\>\/XI2\<0\>\/XI2\<0\>\/XI2\<1\>\/XI2\<0\>\/RR6_neg \
 ) R_1X_LL w=1e-07 l=1e-07   res=0.149966
XXI2\<1\>\/XI2\<0\>\/XI2\<1\>\/XI2\<0\>\/XI2\<0\>\/XI2\<0\>\/XI2\<1\>\/XI2\<0\>\/RR5 \
 (  \
 N_SEL7\<1\>_XI2\<1\>\/XI2\<0\>\/XI2\<1\>\/XI2\<0\>\/XI2\<0\>\/XI2\<0\>\/XI2\<1\>\/XI2\<0\>\/RR5_pos \
 N_WLSEL\<1303\>_XI2\<1\>\/XI2\<0\>\/XI2\<1\>\/XI2\<0\>\/XI2\<0\>\/XI2\<0\>\/XI2\<1\>\/XI2\<0\>\/RR5_neg \
 ) R_1X_LL w=1e-07 l=1e-07   res=0.149966
XXI2\<1\>\/XI2\<0\>\/XI2\<1\>\/XI2\<0\>\/XI2\<0\>\/XI2\<0\>\/XI2\<1\>\/XI2\<1\>\/RR0 \
 (  \
 N_SEL0\<1\>_XI2\<1\>\/XI2\<0\>\/XI2\<1\>\/XI2\<0\>\/XI2\<0\>\/XI2\<0\>\/XI2\<1\>\/XI2\<1\>\/RR0_pos \
 N_WLSEL\<1304\>_XI2\<1\>\/XI2\<0\>\/XI2\<1\>\/XI2\<0\>\/XI2\<0\>\/XI2\<0\>\/XI2\<1\>\/XI2\<1\>\/RR0_neg \
 ) R_1X_LL w=1e-07 l=1e-07   res=0.149966
XXI2\<1\>\/XI2\<0\>\/XI2\<1\>\/XI2\<0\>\/XI2\<0\>\/XI2\<0\>\/XI2\<1\>\/XI2\<1\>\/RR1 \
 (  \
 N_SEL1\<1\>_XI2\<1\>\/XI2\<0\>\/XI2\<1\>\/XI2\<0\>\/XI2\<0\>\/XI2\<0\>\/XI2\<1\>\/XI2\<1\>\/RR1_pos \
 N_WLSEL\<1305\>_XI2\<1\>\/XI2\<0\>\/XI2\<1\>\/XI2\<0\>\/XI2\<0\>\/XI2\<0\>\/XI2\<1\>\/XI2\<1\>\/RR1_neg \
 ) R_1X_LL w=1e-07 l=1e-07   res=0.149966
XXI2\<1\>\/XI2\<0\>\/XI2\<1\>\/XI2\<0\>\/XI2\<0\>\/XI2\<0\>\/XI2\<1\>\/XI2\<1\>\/RR2 \
 (  \
 N_SEL2\<0\>_XI2\<1\>\/XI2\<0\>\/XI2\<1\>\/XI2\<0\>\/XI2\<0\>\/XI2\<0\>\/XI2\<1\>\/XI2\<1\>\/RR2_pos \
 N_WLSEL\<1306\>_XI2\<1\>\/XI2\<0\>\/XI2\<1\>\/XI2\<0\>\/XI2\<0\>\/XI2\<0\>\/XI2\<1\>\/XI2\<1\>\/RR2_neg \
 ) R_1X_LL w=1e-07 l=1e-07   res=0.149966
XXI2\<1\>\/XI2\<0\>\/XI2\<1\>\/XI2\<0\>\/XI2\<0\>\/XI2\<0\>\/XI2\<1\>\/XI2\<1\>\/RR3 \
 (  \
 N_SEL3\<0\>_XI2\<1\>\/XI2\<0\>\/XI2\<1\>\/XI2\<0\>\/XI2\<0\>\/XI2\<0\>\/XI2\<1\>\/XI2\<1\>\/RR3_pos \
 N_WLSEL\<1307\>_XI2\<1\>\/XI2\<0\>\/XI2\<1\>\/XI2\<0\>\/XI2\<0\>\/XI2\<0\>\/XI2\<1\>\/XI2\<1\>\/RR3_neg \
 ) R_1X_LL w=1e-07 l=1e-07   res=0.149966
XXI2\<1\>\/XI2\<0\>\/XI2\<1\>\/XI2\<0\>\/XI2\<0\>\/XI2\<0\>\/XI2\<1\>\/XI2\<1\>\/RR4 \
 (  \
 N_SEL4\<0\>_XI2\<1\>\/XI2\<0\>\/XI2\<1\>\/XI2\<0\>\/XI2\<0\>\/XI2\<0\>\/XI2\<1\>\/XI2\<1\>\/RR4_pos \
 N_WLSEL\<1308\>_XI2\<1\>\/XI2\<0\>\/XI2\<1\>\/XI2\<0\>\/XI2\<0\>\/XI2\<0\>\/XI2\<1\>\/XI2\<1\>\/RR4_neg \
 ) R_1X_LL w=1e-07 l=1e-07   res=0.149966
XXI2\<1\>\/XI2\<0\>\/XI2\<1\>\/XI2\<0\>\/XI2\<0\>\/XI2\<0\>\/XI2\<1\>\/XI2\<1\>\/RR7 \
 (  \
 N_SEL5\<1\>_XI2\<1\>\/XI2\<0\>\/XI2\<1\>\/XI2\<0\>\/XI2\<0\>\/XI2\<0\>\/XI2\<1\>\/XI2\<1\>\/RR7_pos \
 N_WLSEL\<1309\>_XI2\<1\>\/XI2\<0\>\/XI2\<1\>\/XI2\<0\>\/XI2\<0\>\/XI2\<0\>\/XI2\<1\>\/XI2\<1\>\/RR7_neg \
 ) R_1X_LL w=1e-07 l=1e-07   res=0.149966
XXI2\<1\>\/XI2\<0\>\/XI2\<1\>\/XI2\<0\>\/XI2\<0\>\/XI2\<0\>\/XI2\<1\>\/XI2\<1\>\/RR6 \
 (  \
 N_SEL6\<0\>_XI2\<1\>\/XI2\<0\>\/XI2\<1\>\/XI2\<0\>\/XI2\<0\>\/XI2\<0\>\/XI2\<1\>\/XI2\<1\>\/RR6_pos \
 N_WLSEL\<1310\>_XI2\<1\>\/XI2\<0\>\/XI2\<1\>\/XI2\<0\>\/XI2\<0\>\/XI2\<0\>\/XI2\<1\>\/XI2\<1\>\/RR6_neg \
 ) R_1X_LL w=1e-07 l=1e-07   res=0.149966
XXI2\<1\>\/XI2\<0\>\/XI2\<1\>\/XI2\<0\>\/XI2\<0\>\/XI2\<0\>\/XI2\<1\>\/XI2\<1\>\/RR5 \
 (  \
 N_SEL7\<1\>_XI2\<1\>\/XI2\<0\>\/XI2\<1\>\/XI2\<0\>\/XI2\<0\>\/XI2\<0\>\/XI2\<1\>\/XI2\<1\>\/RR5_pos \
 N_WLSEL\<1311\>_XI2\<1\>\/XI2\<0\>\/XI2\<1\>\/XI2\<0\>\/XI2\<0\>\/XI2\<0\>\/XI2\<1\>\/XI2\<1\>\/RR5_neg \
 ) R_1X_LL w=1e-07 l=1e-07   res=0.149966
XXI2\<1\>\/XI2\<0\>\/XI2\<1\>\/XI2\<0\>\/XI2\<0\>\/XI2\<1\>\/XI2\<0\>\/XI2\<0\>\/RR0 \
 (  \
 N_SEL0\<0\>_XI2\<1\>\/XI2\<0\>\/XI2\<1\>\/XI2\<0\>\/XI2\<0\>\/XI2\<1\>\/XI2\<0\>\/XI2\<0\>\/RR0_pos \
 N_WLSEL\<1312\>_XI2\<1\>\/XI2\<0\>\/XI2\<1\>\/XI2\<0\>\/XI2\<0\>\/XI2\<1\>\/XI2\<0\>\/XI2\<0\>\/RR0_neg \
 ) R_1X_LL w=1e-07 l=1e-07   res=0.149966
XXI2\<1\>\/XI2\<0\>\/XI2\<1\>\/XI2\<0\>\/XI2\<0\>\/XI2\<1\>\/XI2\<0\>\/XI2\<0\>\/RR1 \
 (  \
 N_SEL1\<0\>_XI2\<1\>\/XI2\<0\>\/XI2\<1\>\/XI2\<0\>\/XI2\<0\>\/XI2\<1\>\/XI2\<0\>\/XI2\<0\>\/RR1_pos \
 N_WLSEL\<1313\>_XI2\<1\>\/XI2\<0\>\/XI2\<1\>\/XI2\<0\>\/XI2\<0\>\/XI2\<1\>\/XI2\<0\>\/XI2\<0\>\/RR1_neg \
 ) R_1X_LL w=1e-07 l=1e-07   res=0.149966
XXI2\<1\>\/XI2\<0\>\/XI2\<1\>\/XI2\<0\>\/XI2\<0\>\/XI2\<1\>\/XI2\<0\>\/XI2\<0\>\/RR2 \
 (  \
 N_SEL2\<1\>_XI2\<1\>\/XI2\<0\>\/XI2\<1\>\/XI2\<0\>\/XI2\<0\>\/XI2\<1\>\/XI2\<0\>\/XI2\<0\>\/RR2_pos \
 N_WLSEL\<1314\>_XI2\<1\>\/XI2\<0\>\/XI2\<1\>\/XI2\<0\>\/XI2\<0\>\/XI2\<1\>\/XI2\<0\>\/XI2\<0\>\/RR2_neg \
 ) R_1X_LL w=1e-07 l=1e-07   res=0.149966
XXI2\<1\>\/XI2\<0\>\/XI2\<1\>\/XI2\<0\>\/XI2\<0\>\/XI2\<1\>\/XI2\<0\>\/XI2\<0\>\/RR3 \
 (  \
 N_SEL3\<0\>_XI2\<1\>\/XI2\<0\>\/XI2\<1\>\/XI2\<0\>\/XI2\<0\>\/XI2\<1\>\/XI2\<0\>\/XI2\<0\>\/RR3_pos \
 N_WLSEL\<1315\>_XI2\<1\>\/XI2\<0\>\/XI2\<1\>\/XI2\<0\>\/XI2\<0\>\/XI2\<1\>\/XI2\<0\>\/XI2\<0\>\/RR3_neg \
 ) R_1X_LL w=1e-07 l=1e-07   res=0.149966
XXI2\<1\>\/XI2\<0\>\/XI2\<1\>\/XI2\<0\>\/XI2\<0\>\/XI2\<1\>\/XI2\<0\>\/XI2\<0\>\/RR4 \
 (  \
 N_SEL4\<0\>_XI2\<1\>\/XI2\<0\>\/XI2\<1\>\/XI2\<0\>\/XI2\<0\>\/XI2\<1\>\/XI2\<0\>\/XI2\<0\>\/RR4_pos \
 N_WLSEL\<1316\>_XI2\<1\>\/XI2\<0\>\/XI2\<1\>\/XI2\<0\>\/XI2\<0\>\/XI2\<1\>\/XI2\<0\>\/XI2\<0\>\/RR4_neg \
 ) R_1X_LL w=1e-07 l=1e-07   res=0.149966
XXI2\<1\>\/XI2\<0\>\/XI2\<1\>\/XI2\<0\>\/XI2\<0\>\/XI2\<1\>\/XI2\<0\>\/XI2\<0\>\/RR7 \
 (  \
 N_SEL5\<1\>_XI2\<1\>\/XI2\<0\>\/XI2\<1\>\/XI2\<0\>\/XI2\<0\>\/XI2\<1\>\/XI2\<0\>\/XI2\<0\>\/RR7_pos \
 N_WLSEL\<1317\>_XI2\<1\>\/XI2\<0\>\/XI2\<1\>\/XI2\<0\>\/XI2\<0\>\/XI2\<1\>\/XI2\<0\>\/XI2\<0\>\/RR7_neg \
 ) R_1X_LL w=1e-07 l=1e-07   res=0.149966
XXI2\<1\>\/XI2\<0\>\/XI2\<1\>\/XI2\<0\>\/XI2\<0\>\/XI2\<1\>\/XI2\<0\>\/XI2\<0\>\/RR6 \
 (  \
 N_SEL6\<0\>_XI2\<1\>\/XI2\<0\>\/XI2\<1\>\/XI2\<0\>\/XI2\<0\>\/XI2\<1\>\/XI2\<0\>\/XI2\<0\>\/RR6_pos \
 N_WLSEL\<1318\>_XI2\<1\>\/XI2\<0\>\/XI2\<1\>\/XI2\<0\>\/XI2\<0\>\/XI2\<1\>\/XI2\<0\>\/XI2\<0\>\/RR6_neg \
 ) R_1X_LL w=1e-07 l=1e-07   res=0.149966
XXI2\<1\>\/XI2\<0\>\/XI2\<1\>\/XI2\<0\>\/XI2\<0\>\/XI2\<1\>\/XI2\<0\>\/XI2\<0\>\/RR5 \
 (  \
 N_SEL7\<1\>_XI2\<1\>\/XI2\<0\>\/XI2\<1\>\/XI2\<0\>\/XI2\<0\>\/XI2\<1\>\/XI2\<0\>\/XI2\<0\>\/RR5_pos \
 N_WLSEL\<1319\>_XI2\<1\>\/XI2\<0\>\/XI2\<1\>\/XI2\<0\>\/XI2\<0\>\/XI2\<1\>\/XI2\<0\>\/XI2\<0\>\/RR5_neg \
 ) R_1X_LL w=1e-07 l=1e-07   res=0.149966
XXI2\<1\>\/XI2\<0\>\/XI2\<1\>\/XI2\<0\>\/XI2\<0\>\/XI2\<1\>\/XI2\<0\>\/XI2\<1\>\/RR0 \
 (  \
 N_SEL0\<1\>_XI2\<1\>\/XI2\<0\>\/XI2\<1\>\/XI2\<0\>\/XI2\<0\>\/XI2\<1\>\/XI2\<0\>\/XI2\<1\>\/RR0_pos \
 N_WLSEL\<1320\>_XI2\<1\>\/XI2\<0\>\/XI2\<1\>\/XI2\<0\>\/XI2\<0\>\/XI2\<1\>\/XI2\<0\>\/XI2\<1\>\/RR0_neg \
 ) R_1X_LL w=1e-07 l=1e-07   res=0.149966
XXI2\<1\>\/XI2\<0\>\/XI2\<1\>\/XI2\<0\>\/XI2\<0\>\/XI2\<1\>\/XI2\<0\>\/XI2\<1\>\/RR1 \
 (  \
 N_SEL1\<0\>_XI2\<1\>\/XI2\<0\>\/XI2\<1\>\/XI2\<0\>\/XI2\<0\>\/XI2\<1\>\/XI2\<0\>\/XI2\<1\>\/RR1_pos \
 N_WLSEL\<1321\>_XI2\<1\>\/XI2\<0\>\/XI2\<1\>\/XI2\<0\>\/XI2\<0\>\/XI2\<1\>\/XI2\<0\>\/XI2\<1\>\/RR1_neg \
 ) R_1X_LL w=1e-07 l=1e-07   res=0.149966
XXI2\<1\>\/XI2\<0\>\/XI2\<1\>\/XI2\<0\>\/XI2\<0\>\/XI2\<1\>\/XI2\<0\>\/XI2\<1\>\/RR2 \
 (  \
 N_SEL2\<1\>_XI2\<1\>\/XI2\<0\>\/XI2\<1\>\/XI2\<0\>\/XI2\<0\>\/XI2\<1\>\/XI2\<0\>\/XI2\<1\>\/RR2_pos \
 N_WLSEL\<1322\>_XI2\<1\>\/XI2\<0\>\/XI2\<1\>\/XI2\<0\>\/XI2\<0\>\/XI2\<1\>\/XI2\<0\>\/XI2\<1\>\/RR2_neg \
 ) R_1X_LL w=1e-07 l=1e-07   res=0.149966
XXI2\<1\>\/XI2\<0\>\/XI2\<1\>\/XI2\<0\>\/XI2\<0\>\/XI2\<1\>\/XI2\<0\>\/XI2\<1\>\/RR3 \
 (  \
 N_SEL3\<0\>_XI2\<1\>\/XI2\<0\>\/XI2\<1\>\/XI2\<0\>\/XI2\<0\>\/XI2\<1\>\/XI2\<0\>\/XI2\<1\>\/RR3_pos \
 N_WLSEL\<1323\>_XI2\<1\>\/XI2\<0\>\/XI2\<1\>\/XI2\<0\>\/XI2\<0\>\/XI2\<1\>\/XI2\<0\>\/XI2\<1\>\/RR3_neg \
 ) R_1X_LL w=1e-07 l=1e-07   res=0.149966
XXI2\<1\>\/XI2\<0\>\/XI2\<1\>\/XI2\<0\>\/XI2\<0\>\/XI2\<1\>\/XI2\<0\>\/XI2\<1\>\/RR4 \
 (  \
 N_SEL4\<0\>_XI2\<1\>\/XI2\<0\>\/XI2\<1\>\/XI2\<0\>\/XI2\<0\>\/XI2\<1\>\/XI2\<0\>\/XI2\<1\>\/RR4_pos \
 N_WLSEL\<1324\>_XI2\<1\>\/XI2\<0\>\/XI2\<1\>\/XI2\<0\>\/XI2\<0\>\/XI2\<1\>\/XI2\<0\>\/XI2\<1\>\/RR4_neg \
 ) R_1X_LL w=1e-07 l=1e-07   res=0.149966
XXI2\<1\>\/XI2\<0\>\/XI2\<1\>\/XI2\<0\>\/XI2\<0\>\/XI2\<1\>\/XI2\<0\>\/XI2\<1\>\/RR7 \
 (  \
 N_SEL5\<1\>_XI2\<1\>\/XI2\<0\>\/XI2\<1\>\/XI2\<0\>\/XI2\<0\>\/XI2\<1\>\/XI2\<0\>\/XI2\<1\>\/RR7_pos \
 N_WLSEL\<1325\>_XI2\<1\>\/XI2\<0\>\/XI2\<1\>\/XI2\<0\>\/XI2\<0\>\/XI2\<1\>\/XI2\<0\>\/XI2\<1\>\/RR7_neg \
 ) R_1X_LL w=1e-07 l=1e-07   res=0.149966
XXI2\<1\>\/XI2\<0\>\/XI2\<1\>\/XI2\<0\>\/XI2\<0\>\/XI2\<1\>\/XI2\<0\>\/XI2\<1\>\/RR6 \
 (  \
 N_SEL6\<0\>_XI2\<1\>\/XI2\<0\>\/XI2\<1\>\/XI2\<0\>\/XI2\<0\>\/XI2\<1\>\/XI2\<0\>\/XI2\<1\>\/RR6_pos \
 N_WLSEL\<1326\>_XI2\<1\>\/XI2\<0\>\/XI2\<1\>\/XI2\<0\>\/XI2\<0\>\/XI2\<1\>\/XI2\<0\>\/XI2\<1\>\/RR6_neg \
 ) R_1X_LL w=1e-07 l=1e-07   res=0.149966
XXI2\<1\>\/XI2\<0\>\/XI2\<1\>\/XI2\<0\>\/XI2\<0\>\/XI2\<1\>\/XI2\<0\>\/XI2\<1\>\/RR5 \
 (  \
 N_SEL7\<1\>_XI2\<1\>\/XI2\<0\>\/XI2\<1\>\/XI2\<0\>\/XI2\<0\>\/XI2\<1\>\/XI2\<0\>\/XI2\<1\>\/RR5_pos \
 N_WLSEL\<1327\>_XI2\<1\>\/XI2\<0\>\/XI2\<1\>\/XI2\<0\>\/XI2\<0\>\/XI2\<1\>\/XI2\<0\>\/XI2\<1\>\/RR5_neg \
 ) R_1X_LL w=1e-07 l=1e-07   res=0.149966
XXI2\<1\>\/XI2\<0\>\/XI2\<1\>\/XI2\<0\>\/XI2\<0\>\/XI2\<1\>\/XI2\<1\>\/XI2\<0\>\/RR0 \
 (  \
 N_SEL0\<0\>_XI2\<1\>\/XI2\<0\>\/XI2\<1\>\/XI2\<0\>\/XI2\<0\>\/XI2\<1\>\/XI2\<1\>\/XI2\<0\>\/RR0_pos \
 N_WLSEL\<1328\>_XI2\<1\>\/XI2\<0\>\/XI2\<1\>\/XI2\<0\>\/XI2\<0\>\/XI2\<1\>\/XI2\<1\>\/XI2\<0\>\/RR0_neg \
 ) R_1X_LL w=1e-07 l=1e-07   res=0.149966
XXI2\<1\>\/XI2\<0\>\/XI2\<1\>\/XI2\<0\>\/XI2\<0\>\/XI2\<1\>\/XI2\<1\>\/XI2\<0\>\/RR1 \
 (  \
 N_SEL1\<1\>_XI2\<1\>\/XI2\<0\>\/XI2\<1\>\/XI2\<0\>\/XI2\<0\>\/XI2\<1\>\/XI2\<1\>\/XI2\<0\>\/RR1_pos \
 N_WLSEL\<1329\>_XI2\<1\>\/XI2\<0\>\/XI2\<1\>\/XI2\<0\>\/XI2\<0\>\/XI2\<1\>\/XI2\<1\>\/XI2\<0\>\/RR1_neg \
 ) R_1X_LL w=1e-07 l=1e-07   res=0.149966
XXI2\<1\>\/XI2\<0\>\/XI2\<1\>\/XI2\<0\>\/XI2\<0\>\/XI2\<1\>\/XI2\<1\>\/XI2\<0\>\/RR2 \
 (  \
 N_SEL2\<1\>_XI2\<1\>\/XI2\<0\>\/XI2\<1\>\/XI2\<0\>\/XI2\<0\>\/XI2\<1\>\/XI2\<1\>\/XI2\<0\>\/RR2_pos \
 N_WLSEL\<1330\>_XI2\<1\>\/XI2\<0\>\/XI2\<1\>\/XI2\<0\>\/XI2\<0\>\/XI2\<1\>\/XI2\<1\>\/XI2\<0\>\/RR2_neg \
 ) R_1X_LL w=1e-07 l=1e-07   res=0.149966
XXI2\<1\>\/XI2\<0\>\/XI2\<1\>\/XI2\<0\>\/XI2\<0\>\/XI2\<1\>\/XI2\<1\>\/XI2\<0\>\/RR3 \
 (  \
 N_SEL3\<0\>_XI2\<1\>\/XI2\<0\>\/XI2\<1\>\/XI2\<0\>\/XI2\<0\>\/XI2\<1\>\/XI2\<1\>\/XI2\<0\>\/RR3_pos \
 N_WLSEL\<1331\>_XI2\<1\>\/XI2\<0\>\/XI2\<1\>\/XI2\<0\>\/XI2\<0\>\/XI2\<1\>\/XI2\<1\>\/XI2\<0\>\/RR3_neg \
 ) R_1X_LL w=1e-07 l=1e-07   res=0.149966
XXI2\<1\>\/XI2\<0\>\/XI2\<1\>\/XI2\<0\>\/XI2\<0\>\/XI2\<1\>\/XI2\<1\>\/XI2\<0\>\/RR4 \
 (  \
 N_SEL4\<0\>_XI2\<1\>\/XI2\<0\>\/XI2\<1\>\/XI2\<0\>\/XI2\<0\>\/XI2\<1\>\/XI2\<1\>\/XI2\<0\>\/RR4_pos \
 N_WLSEL\<1332\>_XI2\<1\>\/XI2\<0\>\/XI2\<1\>\/XI2\<0\>\/XI2\<0\>\/XI2\<1\>\/XI2\<1\>\/XI2\<0\>\/RR4_neg \
 ) R_1X_LL w=1e-07 l=1e-07   res=0.149966
XXI2\<1\>\/XI2\<0\>\/XI2\<1\>\/XI2\<0\>\/XI2\<0\>\/XI2\<1\>\/XI2\<1\>\/XI2\<0\>\/RR7 \
 (  \
 N_SEL5\<1\>_XI2\<1\>\/XI2\<0\>\/XI2\<1\>\/XI2\<0\>\/XI2\<0\>\/XI2\<1\>\/XI2\<1\>\/XI2\<0\>\/RR7_pos \
 N_WLSEL\<1333\>_XI2\<1\>\/XI2\<0\>\/XI2\<1\>\/XI2\<0\>\/XI2\<0\>\/XI2\<1\>\/XI2\<1\>\/XI2\<0\>\/RR7_neg \
 ) R_1X_LL w=1e-07 l=1e-07   res=0.149966
XXI2\<1\>\/XI2\<0\>\/XI2\<1\>\/XI2\<0\>\/XI2\<0\>\/XI2\<1\>\/XI2\<1\>\/XI2\<0\>\/RR6 \
 (  \
 N_SEL6\<0\>_XI2\<1\>\/XI2\<0\>\/XI2\<1\>\/XI2\<0\>\/XI2\<0\>\/XI2\<1\>\/XI2\<1\>\/XI2\<0\>\/RR6_pos \
 N_WLSEL\<1334\>_XI2\<1\>\/XI2\<0\>\/XI2\<1\>\/XI2\<0\>\/XI2\<0\>\/XI2\<1\>\/XI2\<1\>\/XI2\<0\>\/RR6_neg \
 ) R_1X_LL w=1e-07 l=1e-07   res=0.149966
XXI2\<1\>\/XI2\<0\>\/XI2\<1\>\/XI2\<0\>\/XI2\<0\>\/XI2\<1\>\/XI2\<1\>\/XI2\<0\>\/RR5 \
 (  \
 N_SEL7\<1\>_XI2\<1\>\/XI2\<0\>\/XI2\<1\>\/XI2\<0\>\/XI2\<0\>\/XI2\<1\>\/XI2\<1\>\/XI2\<0\>\/RR5_pos \
 N_WLSEL\<1335\>_XI2\<1\>\/XI2\<0\>\/XI2\<1\>\/XI2\<0\>\/XI2\<0\>\/XI2\<1\>\/XI2\<1\>\/XI2\<0\>\/RR5_neg \
 ) R_1X_LL w=1e-07 l=1e-07   res=0.149966
XXI2\<1\>\/XI2\<0\>\/XI2\<1\>\/XI2\<0\>\/XI2\<0\>\/XI2\<1\>\/XI2\<1\>\/XI2\<1\>\/RR0 \
 (  \
 N_SEL0\<1\>_XI2\<1\>\/XI2\<0\>\/XI2\<1\>\/XI2\<0\>\/XI2\<0\>\/XI2\<1\>\/XI2\<1\>\/XI2\<1\>\/RR0_pos \
 N_WLSEL\<1336\>_XI2\<1\>\/XI2\<0\>\/XI2\<1\>\/XI2\<0\>\/XI2\<0\>\/XI2\<1\>\/XI2\<1\>\/XI2\<1\>\/RR0_neg \
 ) R_1X_LL w=1e-07 l=1e-07   res=0.149966
XXI2\<1\>\/XI2\<0\>\/XI2\<1\>\/XI2\<0\>\/XI2\<0\>\/XI2\<1\>\/XI2\<1\>\/XI2\<1\>\/RR1 \
 (  \
 N_SEL1\<1\>_XI2\<1\>\/XI2\<0\>\/XI2\<1\>\/XI2\<0\>\/XI2\<0\>\/XI2\<1\>\/XI2\<1\>\/XI2\<1\>\/RR1_pos \
 N_WLSEL\<1337\>_XI2\<1\>\/XI2\<0\>\/XI2\<1\>\/XI2\<0\>\/XI2\<0\>\/XI2\<1\>\/XI2\<1\>\/XI2\<1\>\/RR1_neg \
 ) R_1X_LL w=1e-07 l=1e-07   res=0.149966
XXI2\<1\>\/XI2\<0\>\/XI2\<1\>\/XI2\<0\>\/XI2\<0\>\/XI2\<1\>\/XI2\<1\>\/XI2\<1\>\/RR2 \
 (  \
 N_SEL2\<1\>_XI2\<1\>\/XI2\<0\>\/XI2\<1\>\/XI2\<0\>\/XI2\<0\>\/XI2\<1\>\/XI2\<1\>\/XI2\<1\>\/RR2_pos \
 N_WLSEL\<1338\>_XI2\<1\>\/XI2\<0\>\/XI2\<1\>\/XI2\<0\>\/XI2\<0\>\/XI2\<1\>\/XI2\<1\>\/XI2\<1\>\/RR2_neg \
 ) R_1X_LL w=1e-07 l=1e-07   res=0.149966
XXI2\<1\>\/XI2\<0\>\/XI2\<1\>\/XI2\<0\>\/XI2\<0\>\/XI2\<1\>\/XI2\<1\>\/XI2\<1\>\/RR3 \
 (  \
 N_SEL3\<0\>_XI2\<1\>\/XI2\<0\>\/XI2\<1\>\/XI2\<0\>\/XI2\<0\>\/XI2\<1\>\/XI2\<1\>\/XI2\<1\>\/RR3_pos \
 N_WLSEL\<1339\>_XI2\<1\>\/XI2\<0\>\/XI2\<1\>\/XI2\<0\>\/XI2\<0\>\/XI2\<1\>\/XI2\<1\>\/XI2\<1\>\/RR3_neg \
 ) R_1X_LL w=1e-07 l=1e-07   res=0.149966
XXI2\<1\>\/XI2\<0\>\/XI2\<1\>\/XI2\<0\>\/XI2\<0\>\/XI2\<1\>\/XI2\<1\>\/XI2\<1\>\/RR4 \
 (  \
 N_SEL4\<0\>_XI2\<1\>\/XI2\<0\>\/XI2\<1\>\/XI2\<0\>\/XI2\<0\>\/XI2\<1\>\/XI2\<1\>\/XI2\<1\>\/RR4_pos \
 N_WLSEL\<1340\>_XI2\<1\>\/XI2\<0\>\/XI2\<1\>\/XI2\<0\>\/XI2\<0\>\/XI2\<1\>\/XI2\<1\>\/XI2\<1\>\/RR4_neg \
 ) R_1X_LL w=1e-07 l=1e-07   res=0.149966
XXI2\<1\>\/XI2\<0\>\/XI2\<1\>\/XI2\<0\>\/XI2\<0\>\/XI2\<1\>\/XI2\<1\>\/XI2\<1\>\/RR7 \
 (  \
 N_SEL5\<1\>_XI2\<1\>\/XI2\<0\>\/XI2\<1\>\/XI2\<0\>\/XI2\<0\>\/XI2\<1\>\/XI2\<1\>\/XI2\<1\>\/RR7_pos \
 N_WLSEL\<1341\>_XI2\<1\>\/XI2\<0\>\/XI2\<1\>\/XI2\<0\>\/XI2\<0\>\/XI2\<1\>\/XI2\<1\>\/XI2\<1\>\/RR7_neg \
 ) R_1X_LL w=1e-07 l=1e-07   res=0.149966
XXI2\<1\>\/XI2\<0\>\/XI2\<1\>\/XI2\<0\>\/XI2\<0\>\/XI2\<1\>\/XI2\<1\>\/XI2\<1\>\/RR6 \
 (  \
 N_SEL6\<0\>_XI2\<1\>\/XI2\<0\>\/XI2\<1\>\/XI2\<0\>\/XI2\<0\>\/XI2\<1\>\/XI2\<1\>\/XI2\<1\>\/RR6_pos \
 N_WLSEL\<1342\>_XI2\<1\>\/XI2\<0\>\/XI2\<1\>\/XI2\<0\>\/XI2\<0\>\/XI2\<1\>\/XI2\<1\>\/XI2\<1\>\/RR6_neg \
 ) R_1X_LL w=1e-07 l=1e-07   res=0.149966
XXI2\<1\>\/XI2\<0\>\/XI2\<1\>\/XI2\<0\>\/XI2\<0\>\/XI2\<1\>\/XI2\<1\>\/XI2\<1\>\/RR5 \
 (  \
 N_SEL7\<1\>_XI2\<1\>\/XI2\<0\>\/XI2\<1\>\/XI2\<0\>\/XI2\<0\>\/XI2\<1\>\/XI2\<1\>\/XI2\<1\>\/RR5_pos \
 N_WLSEL\<1343\>_XI2\<1\>\/XI2\<0\>\/XI2\<1\>\/XI2\<0\>\/XI2\<0\>\/XI2\<1\>\/XI2\<1\>\/XI2\<1\>\/RR5_neg \
 ) R_1X_LL w=1e-07 l=1e-07   res=0.149966
XXI2\<1\>\/XI2\<0\>\/XI2\<1\>\/XI2\<0\>\/XI2\<1\>\/XI2\<0\>\/XI2\<0\>\/XI2\<0\>\/RR0 \
 (  \
 N_SEL0\<0\>_XI2\<1\>\/XI2\<0\>\/XI2\<1\>\/XI2\<0\>\/XI2\<1\>\/XI2\<0\>\/XI2\<0\>\/XI2\<0\>\/RR0_pos \
 N_WLSEL\<1344\>_XI2\<1\>\/XI2\<0\>\/XI2\<1\>\/XI2\<0\>\/XI2\<1\>\/XI2\<0\>\/XI2\<0\>\/XI2\<0\>\/RR0_neg \
 ) R_1X_LL w=1e-07 l=1e-07   res=0.149966
XXI2\<1\>\/XI2\<0\>\/XI2\<1\>\/XI2\<0\>\/XI2\<1\>\/XI2\<0\>\/XI2\<0\>\/XI2\<0\>\/RR1 \
 (  \
 N_SEL1\<0\>_XI2\<1\>\/XI2\<0\>\/XI2\<1\>\/XI2\<0\>\/XI2\<1\>\/XI2\<0\>\/XI2\<0\>\/XI2\<0\>\/RR1_pos \
 N_WLSEL\<1345\>_XI2\<1\>\/XI2\<0\>\/XI2\<1\>\/XI2\<0\>\/XI2\<1\>\/XI2\<0\>\/XI2\<0\>\/XI2\<0\>\/RR1_neg \
 ) R_1X_LL w=1e-07 l=1e-07   res=0.149966
XXI2\<1\>\/XI2\<0\>\/XI2\<1\>\/XI2\<0\>\/XI2\<1\>\/XI2\<0\>\/XI2\<0\>\/XI2\<0\>\/RR2 \
 (  \
 N_SEL2\<0\>_XI2\<1\>\/XI2\<0\>\/XI2\<1\>\/XI2\<0\>\/XI2\<1\>\/XI2\<0\>\/XI2\<0\>\/XI2\<0\>\/RR2_pos \
 N_WLSEL\<1346\>_XI2\<1\>\/XI2\<0\>\/XI2\<1\>\/XI2\<0\>\/XI2\<1\>\/XI2\<0\>\/XI2\<0\>\/XI2\<0\>\/RR2_neg \
 ) R_1X_LL w=1e-07 l=1e-07   res=0.149966
XXI2\<1\>\/XI2\<0\>\/XI2\<1\>\/XI2\<0\>\/XI2\<1\>\/XI2\<0\>\/XI2\<0\>\/XI2\<0\>\/RR3 \
 (  \
 N_SEL3\<1\>_XI2\<1\>\/XI2\<0\>\/XI2\<1\>\/XI2\<0\>\/XI2\<1\>\/XI2\<0\>\/XI2\<0\>\/XI2\<0\>\/RR3_pos \
 N_WLSEL\<1347\>_XI2\<1\>\/XI2\<0\>\/XI2\<1\>\/XI2\<0\>\/XI2\<1\>\/XI2\<0\>\/XI2\<0\>\/XI2\<0\>\/RR3_neg \
 ) R_1X_LL w=1e-07 l=1e-07   res=0.149966
XXI2\<1\>\/XI2\<0\>\/XI2\<1\>\/XI2\<0\>\/XI2\<1\>\/XI2\<0\>\/XI2\<0\>\/XI2\<0\>\/RR4 \
 (  \
 N_SEL4\<0\>_XI2\<1\>\/XI2\<0\>\/XI2\<1\>\/XI2\<0\>\/XI2\<1\>\/XI2\<0\>\/XI2\<0\>\/XI2\<0\>\/RR4_pos \
 N_WLSEL\<1348\>_XI2\<1\>\/XI2\<0\>\/XI2\<1\>\/XI2\<0\>\/XI2\<1\>\/XI2\<0\>\/XI2\<0\>\/XI2\<0\>\/RR4_neg \
 ) R_1X_LL w=1e-07 l=1e-07   res=0.149966
XXI2\<1\>\/XI2\<0\>\/XI2\<1\>\/XI2\<0\>\/XI2\<1\>\/XI2\<0\>\/XI2\<0\>\/XI2\<0\>\/RR7 \
 (  \
 N_SEL5\<1\>_XI2\<1\>\/XI2\<0\>\/XI2\<1\>\/XI2\<0\>\/XI2\<1\>\/XI2\<0\>\/XI2\<0\>\/XI2\<0\>\/RR7_pos \
 N_WLSEL\<1349\>_XI2\<1\>\/XI2\<0\>\/XI2\<1\>\/XI2\<0\>\/XI2\<1\>\/XI2\<0\>\/XI2\<0\>\/XI2\<0\>\/RR7_neg \
 ) R_1X_LL w=1e-07 l=1e-07   res=0.149966
XXI2\<1\>\/XI2\<0\>\/XI2\<1\>\/XI2\<0\>\/XI2\<1\>\/XI2\<0\>\/XI2\<0\>\/XI2\<0\>\/RR6 \
 (  \
 N_SEL6\<0\>_XI2\<1\>\/XI2\<0\>\/XI2\<1\>\/XI2\<0\>\/XI2\<1\>\/XI2\<0\>\/XI2\<0\>\/XI2\<0\>\/RR6_pos \
 N_WLSEL\<1350\>_XI2\<1\>\/XI2\<0\>\/XI2\<1\>\/XI2\<0\>\/XI2\<1\>\/XI2\<0\>\/XI2\<0\>\/XI2\<0\>\/RR6_neg \
 ) R_1X_LL w=1e-07 l=1e-07   res=0.149966
XXI2\<1\>\/XI2\<0\>\/XI2\<1\>\/XI2\<0\>\/XI2\<1\>\/XI2\<0\>\/XI2\<0\>\/XI2\<0\>\/RR5 \
 (  \
 N_SEL7\<1\>_XI2\<1\>\/XI2\<0\>\/XI2\<1\>\/XI2\<0\>\/XI2\<1\>\/XI2\<0\>\/XI2\<0\>\/XI2\<0\>\/RR5_pos \
 N_WLSEL\<1351\>_XI2\<1\>\/XI2\<0\>\/XI2\<1\>\/XI2\<0\>\/XI2\<1\>\/XI2\<0\>\/XI2\<0\>\/XI2\<0\>\/RR5_neg \
 ) R_1X_LL w=1e-07 l=1e-07   res=0.149966
XXI2\<1\>\/XI2\<0\>\/XI2\<1\>\/XI2\<0\>\/XI2\<1\>\/XI2\<0\>\/XI2\<0\>\/XI2\<1\>\/RR0 \
 (  \
 N_SEL0\<1\>_XI2\<1\>\/XI2\<0\>\/XI2\<1\>\/XI2\<0\>\/XI2\<1\>\/XI2\<0\>\/XI2\<0\>\/XI2\<1\>\/RR0_pos \
 N_WLSEL\<1352\>_XI2\<1\>\/XI2\<0\>\/XI2\<1\>\/XI2\<0\>\/XI2\<1\>\/XI2\<0\>\/XI2\<0\>\/XI2\<1\>\/RR0_neg \
 ) R_1X_LL w=1e-07 l=1e-07   res=0.149966
XXI2\<1\>\/XI2\<0\>\/XI2\<1\>\/XI2\<0\>\/XI2\<1\>\/XI2\<0\>\/XI2\<0\>\/XI2\<1\>\/RR1 \
 (  \
 N_SEL1\<0\>_XI2\<1\>\/XI2\<0\>\/XI2\<1\>\/XI2\<0\>\/XI2\<1\>\/XI2\<0\>\/XI2\<0\>\/XI2\<1\>\/RR1_pos \
 N_WLSEL\<1353\>_XI2\<1\>\/XI2\<0\>\/XI2\<1\>\/XI2\<0\>\/XI2\<1\>\/XI2\<0\>\/XI2\<0\>\/XI2\<1\>\/RR1_neg \
 ) R_1X_LL w=1e-07 l=1e-07   res=0.149966
XXI2\<1\>\/XI2\<0\>\/XI2\<1\>\/XI2\<0\>\/XI2\<1\>\/XI2\<0\>\/XI2\<0\>\/XI2\<1\>\/RR2 \
 (  \
 N_SEL2\<0\>_XI2\<1\>\/XI2\<0\>\/XI2\<1\>\/XI2\<0\>\/XI2\<1\>\/XI2\<0\>\/XI2\<0\>\/XI2\<1\>\/RR2_pos \
 N_WLSEL\<1354\>_XI2\<1\>\/XI2\<0\>\/XI2\<1\>\/XI2\<0\>\/XI2\<1\>\/XI2\<0\>\/XI2\<0\>\/XI2\<1\>\/RR2_neg \
 ) R_1X_LL w=1e-07 l=1e-07   res=0.149966
XXI2\<1\>\/XI2\<0\>\/XI2\<1\>\/XI2\<0\>\/XI2\<1\>\/XI2\<0\>\/XI2\<0\>\/XI2\<1\>\/RR3 \
 (  \
 N_SEL3\<1\>_XI2\<1\>\/XI2\<0\>\/XI2\<1\>\/XI2\<0\>\/XI2\<1\>\/XI2\<0\>\/XI2\<0\>\/XI2\<1\>\/RR3_pos \
 N_WLSEL\<1355\>_XI2\<1\>\/XI2\<0\>\/XI2\<1\>\/XI2\<0\>\/XI2\<1\>\/XI2\<0\>\/XI2\<0\>\/XI2\<1\>\/RR3_neg \
 ) R_1X_LL w=1e-07 l=1e-07   res=0.149966
XXI2\<1\>\/XI2\<0\>\/XI2\<1\>\/XI2\<0\>\/XI2\<1\>\/XI2\<0\>\/XI2\<0\>\/XI2\<1\>\/RR4 \
 (  \
 N_SEL4\<0\>_XI2\<1\>\/XI2\<0\>\/XI2\<1\>\/XI2\<0\>\/XI2\<1\>\/XI2\<0\>\/XI2\<0\>\/XI2\<1\>\/RR4_pos \
 N_WLSEL\<1356\>_XI2\<1\>\/XI2\<0\>\/XI2\<1\>\/XI2\<0\>\/XI2\<1\>\/XI2\<0\>\/XI2\<0\>\/XI2\<1\>\/RR4_neg \
 ) R_1X_LL w=1e-07 l=1e-07   res=0.149966
XXI2\<1\>\/XI2\<0\>\/XI2\<1\>\/XI2\<0\>\/XI2\<1\>\/XI2\<0\>\/XI2\<0\>\/XI2\<1\>\/RR7 \
 (  \
 N_SEL5\<1\>_XI2\<1\>\/XI2\<0\>\/XI2\<1\>\/XI2\<0\>\/XI2\<1\>\/XI2\<0\>\/XI2\<0\>\/XI2\<1\>\/RR7_pos \
 N_WLSEL\<1357\>_XI2\<1\>\/XI2\<0\>\/XI2\<1\>\/XI2\<0\>\/XI2\<1\>\/XI2\<0\>\/XI2\<0\>\/XI2\<1\>\/RR7_neg \
 ) R_1X_LL w=1e-07 l=1e-07   res=0.149966
XXI2\<1\>\/XI2\<0\>\/XI2\<1\>\/XI2\<0\>\/XI2\<1\>\/XI2\<0\>\/XI2\<0\>\/XI2\<1\>\/RR6 \
 (  \
 N_SEL6\<0\>_XI2\<1\>\/XI2\<0\>\/XI2\<1\>\/XI2\<0\>\/XI2\<1\>\/XI2\<0\>\/XI2\<0\>\/XI2\<1\>\/RR6_pos \
 N_WLSEL\<1358\>_XI2\<1\>\/XI2\<0\>\/XI2\<1\>\/XI2\<0\>\/XI2\<1\>\/XI2\<0\>\/XI2\<0\>\/XI2\<1\>\/RR6_neg \
 ) R_1X_LL w=1e-07 l=1e-07   res=0.149966
XXI2\<1\>\/XI2\<0\>\/XI2\<1\>\/XI2\<0\>\/XI2\<1\>\/XI2\<0\>\/XI2\<0\>\/XI2\<1\>\/RR5 \
 (  \
 N_SEL7\<1\>_XI2\<1\>\/XI2\<0\>\/XI2\<1\>\/XI2\<0\>\/XI2\<1\>\/XI2\<0\>\/XI2\<0\>\/XI2\<1\>\/RR5_pos \
 N_WLSEL\<1359\>_XI2\<1\>\/XI2\<0\>\/XI2\<1\>\/XI2\<0\>\/XI2\<1\>\/XI2\<0\>\/XI2\<0\>\/XI2\<1\>\/RR5_neg \
 ) R_1X_LL w=1e-07 l=1e-07   res=0.149966
XXI2\<1\>\/XI2\<0\>\/XI2\<1\>\/XI2\<0\>\/XI2\<1\>\/XI2\<0\>\/XI2\<1\>\/XI2\<0\>\/RR0 \
 (  \
 N_SEL0\<0\>_XI2\<1\>\/XI2\<0\>\/XI2\<1\>\/XI2\<0\>\/XI2\<1\>\/XI2\<0\>\/XI2\<1\>\/XI2\<0\>\/RR0_pos \
 N_WLSEL\<1360\>_XI2\<1\>\/XI2\<0\>\/XI2\<1\>\/XI2\<0\>\/XI2\<1\>\/XI2\<0\>\/XI2\<1\>\/XI2\<0\>\/RR0_neg \
 ) R_1X_LL w=1e-07 l=1e-07   res=0.149966
XXI2\<1\>\/XI2\<0\>\/XI2\<1\>\/XI2\<0\>\/XI2\<1\>\/XI2\<0\>\/XI2\<1\>\/XI2\<0\>\/RR1 \
 (  \
 N_SEL1\<1\>_XI2\<1\>\/XI2\<0\>\/XI2\<1\>\/XI2\<0\>\/XI2\<1\>\/XI2\<0\>\/XI2\<1\>\/XI2\<0\>\/RR1_pos \
 N_WLSEL\<1361\>_XI2\<1\>\/XI2\<0\>\/XI2\<1\>\/XI2\<0\>\/XI2\<1\>\/XI2\<0\>\/XI2\<1\>\/XI2\<0\>\/RR1_neg \
 ) R_1X_LL w=1e-07 l=1e-07   res=0.149966
XXI2\<1\>\/XI2\<0\>\/XI2\<1\>\/XI2\<0\>\/XI2\<1\>\/XI2\<0\>\/XI2\<1\>\/XI2\<0\>\/RR2 \
 (  \
 N_SEL2\<0\>_XI2\<1\>\/XI2\<0\>\/XI2\<1\>\/XI2\<0\>\/XI2\<1\>\/XI2\<0\>\/XI2\<1\>\/XI2\<0\>\/RR2_pos \
 N_WLSEL\<1362\>_XI2\<1\>\/XI2\<0\>\/XI2\<1\>\/XI2\<0\>\/XI2\<1\>\/XI2\<0\>\/XI2\<1\>\/XI2\<0\>\/RR2_neg \
 ) R_1X_LL w=1e-07 l=1e-07   res=0.149966
XXI2\<1\>\/XI2\<0\>\/XI2\<1\>\/XI2\<0\>\/XI2\<1\>\/XI2\<0\>\/XI2\<1\>\/XI2\<0\>\/RR3 \
 (  \
 N_SEL3\<1\>_XI2\<1\>\/XI2\<0\>\/XI2\<1\>\/XI2\<0\>\/XI2\<1\>\/XI2\<0\>\/XI2\<1\>\/XI2\<0\>\/RR3_pos \
 N_WLSEL\<1363\>_XI2\<1\>\/XI2\<0\>\/XI2\<1\>\/XI2\<0\>\/XI2\<1\>\/XI2\<0\>\/XI2\<1\>\/XI2\<0\>\/RR3_neg \
 ) R_1X_LL w=1e-07 l=1e-07   res=0.149966
XXI2\<1\>\/XI2\<0\>\/XI2\<1\>\/XI2\<0\>\/XI2\<1\>\/XI2\<0\>\/XI2\<1\>\/XI2\<0\>\/RR4 \
 (  \
 N_SEL4\<0\>_XI2\<1\>\/XI2\<0\>\/XI2\<1\>\/XI2\<0\>\/XI2\<1\>\/XI2\<0\>\/XI2\<1\>\/XI2\<0\>\/RR4_pos \
 N_WLSEL\<1364\>_XI2\<1\>\/XI2\<0\>\/XI2\<1\>\/XI2\<0\>\/XI2\<1\>\/XI2\<0\>\/XI2\<1\>\/XI2\<0\>\/RR4_neg \
 ) R_1X_LL w=1e-07 l=1e-07   res=0.149966
XXI2\<1\>\/XI2\<0\>\/XI2\<1\>\/XI2\<0\>\/XI2\<1\>\/XI2\<0\>\/XI2\<1\>\/XI2\<0\>\/RR7 \
 (  \
 N_SEL5\<1\>_XI2\<1\>\/XI2\<0\>\/XI2\<1\>\/XI2\<0\>\/XI2\<1\>\/XI2\<0\>\/XI2\<1\>\/XI2\<0\>\/RR7_pos \
 N_WLSEL\<1365\>_XI2\<1\>\/XI2\<0\>\/XI2\<1\>\/XI2\<0\>\/XI2\<1\>\/XI2\<0\>\/XI2\<1\>\/XI2\<0\>\/RR7_neg \
 ) R_1X_LL w=1e-07 l=1e-07   res=0.149966
XXI2\<1\>\/XI2\<0\>\/XI2\<1\>\/XI2\<0\>\/XI2\<1\>\/XI2\<0\>\/XI2\<1\>\/XI2\<0\>\/RR6 \
 (  \
 N_SEL6\<0\>_XI2\<1\>\/XI2\<0\>\/XI2\<1\>\/XI2\<0\>\/XI2\<1\>\/XI2\<0\>\/XI2\<1\>\/XI2\<0\>\/RR6_pos \
 N_WLSEL\<1366\>_XI2\<1\>\/XI2\<0\>\/XI2\<1\>\/XI2\<0\>\/XI2\<1\>\/XI2\<0\>\/XI2\<1\>\/XI2\<0\>\/RR6_neg \
 ) R_1X_LL w=1e-07 l=1e-07   res=0.149966
XXI2\<1\>\/XI2\<0\>\/XI2\<1\>\/XI2\<0\>\/XI2\<1\>\/XI2\<0\>\/XI2\<1\>\/XI2\<0\>\/RR5 \
 (  \
 N_SEL7\<1\>_XI2\<1\>\/XI2\<0\>\/XI2\<1\>\/XI2\<0\>\/XI2\<1\>\/XI2\<0\>\/XI2\<1\>\/XI2\<0\>\/RR5_pos \
 N_WLSEL\<1367\>_XI2\<1\>\/XI2\<0\>\/XI2\<1\>\/XI2\<0\>\/XI2\<1\>\/XI2\<0\>\/XI2\<1\>\/XI2\<0\>\/RR5_neg \
 ) R_1X_LL w=1e-07 l=1e-07   res=0.149966
XXI2\<1\>\/XI2\<0\>\/XI2\<1\>\/XI2\<0\>\/XI2\<1\>\/XI2\<0\>\/XI2\<1\>\/XI2\<1\>\/RR0 \
 (  \
 N_SEL0\<1\>_XI2\<1\>\/XI2\<0\>\/XI2\<1\>\/XI2\<0\>\/XI2\<1\>\/XI2\<0\>\/XI2\<1\>\/XI2\<1\>\/RR0_pos \
 N_WLSEL\<1368\>_XI2\<1\>\/XI2\<0\>\/XI2\<1\>\/XI2\<0\>\/XI2\<1\>\/XI2\<0\>\/XI2\<1\>\/XI2\<1\>\/RR0_neg \
 ) R_1X_LL w=1e-07 l=1e-07   res=0.149966
XXI2\<1\>\/XI2\<0\>\/XI2\<1\>\/XI2\<0\>\/XI2\<1\>\/XI2\<0\>\/XI2\<1\>\/XI2\<1\>\/RR1 \
 (  \
 N_SEL1\<1\>_XI2\<1\>\/XI2\<0\>\/XI2\<1\>\/XI2\<0\>\/XI2\<1\>\/XI2\<0\>\/XI2\<1\>\/XI2\<1\>\/RR1_pos \
 N_WLSEL\<1369\>_XI2\<1\>\/XI2\<0\>\/XI2\<1\>\/XI2\<0\>\/XI2\<1\>\/XI2\<0\>\/XI2\<1\>\/XI2\<1\>\/RR1_neg \
 ) R_1X_LL w=1e-07 l=1e-07   res=0.149966
XXI2\<1\>\/XI2\<0\>\/XI2\<1\>\/XI2\<0\>\/XI2\<1\>\/XI2\<0\>\/XI2\<1\>\/XI2\<1\>\/RR2 \
 (  \
 N_SEL2\<0\>_XI2\<1\>\/XI2\<0\>\/XI2\<1\>\/XI2\<0\>\/XI2\<1\>\/XI2\<0\>\/XI2\<1\>\/XI2\<1\>\/RR2_pos \
 N_WLSEL\<1370\>_XI2\<1\>\/XI2\<0\>\/XI2\<1\>\/XI2\<0\>\/XI2\<1\>\/XI2\<0\>\/XI2\<1\>\/XI2\<1\>\/RR2_neg \
 ) R_1X_LL w=1e-07 l=1e-07   res=0.149966
XXI2\<1\>\/XI2\<0\>\/XI2\<1\>\/XI2\<0\>\/XI2\<1\>\/XI2\<0\>\/XI2\<1\>\/XI2\<1\>\/RR3 \
 (  \
 N_SEL3\<1\>_XI2\<1\>\/XI2\<0\>\/XI2\<1\>\/XI2\<0\>\/XI2\<1\>\/XI2\<0\>\/XI2\<1\>\/XI2\<1\>\/RR3_pos \
 N_WLSEL\<1371\>_XI2\<1\>\/XI2\<0\>\/XI2\<1\>\/XI2\<0\>\/XI2\<1\>\/XI2\<0\>\/XI2\<1\>\/XI2\<1\>\/RR3_neg \
 ) R_1X_LL w=1e-07 l=1e-07   res=0.149966
XXI2\<1\>\/XI2\<0\>\/XI2\<1\>\/XI2\<0\>\/XI2\<1\>\/XI2\<0\>\/XI2\<1\>\/XI2\<1\>\/RR4 \
 (  \
 N_SEL4\<0\>_XI2\<1\>\/XI2\<0\>\/XI2\<1\>\/XI2\<0\>\/XI2\<1\>\/XI2\<0\>\/XI2\<1\>\/XI2\<1\>\/RR4_pos \
 N_WLSEL\<1372\>_XI2\<1\>\/XI2\<0\>\/XI2\<1\>\/XI2\<0\>\/XI2\<1\>\/XI2\<0\>\/XI2\<1\>\/XI2\<1\>\/RR4_neg \
 ) R_1X_LL w=1e-07 l=1e-07   res=0.149966
XXI2\<1\>\/XI2\<0\>\/XI2\<1\>\/XI2\<0\>\/XI2\<1\>\/XI2\<0\>\/XI2\<1\>\/XI2\<1\>\/RR7 \
 (  \
 N_SEL5\<1\>_XI2\<1\>\/XI2\<0\>\/XI2\<1\>\/XI2\<0\>\/XI2\<1\>\/XI2\<0\>\/XI2\<1\>\/XI2\<1\>\/RR7_pos \
 N_WLSEL\<1373\>_XI2\<1\>\/XI2\<0\>\/XI2\<1\>\/XI2\<0\>\/XI2\<1\>\/XI2\<0\>\/XI2\<1\>\/XI2\<1\>\/RR7_neg \
 ) R_1X_LL w=1e-07 l=1e-07   res=0.149966
XXI2\<1\>\/XI2\<0\>\/XI2\<1\>\/XI2\<0\>\/XI2\<1\>\/XI2\<0\>\/XI2\<1\>\/XI2\<1\>\/RR6 \
 (  \
 N_SEL6\<0\>_XI2\<1\>\/XI2\<0\>\/XI2\<1\>\/XI2\<0\>\/XI2\<1\>\/XI2\<0\>\/XI2\<1\>\/XI2\<1\>\/RR6_pos \
 N_WLSEL\<1374\>_XI2\<1\>\/XI2\<0\>\/XI2\<1\>\/XI2\<0\>\/XI2\<1\>\/XI2\<0\>\/XI2\<1\>\/XI2\<1\>\/RR6_neg \
 ) R_1X_LL w=1e-07 l=1e-07   res=0.149966
XXI2\<0\>\/XI2\<1\>\/XI2\<1\>\/XI2\<0\>\/XI2\<0\>\/XI2\<0\>\/XI2\<0\>\/XI2\<1\>\/RR5 \
 (  \
 N_SEL7\<0\>_XI2\<0\>\/XI2\<1\>\/XI2\<1\>\/XI2\<0\>\/XI2\<0\>\/XI2\<0\>\/XI2\<0\>\/XI2\<1\>\/RR5_pos \
 N_WLSEL\<783\>_XI2\<0\>\/XI2\<1\>\/XI2\<1\>\/XI2\<0\>\/XI2\<0\>\/XI2\<0\>\/XI2\<0\>\/XI2\<1\>\/RR5_neg \
 ) R_1X_LL w=1e-07 l=1e-07   res=0.149966
XXI2\<0\>\/XI2\<1\>\/XI2\<1\>\/XI2\<0\>\/XI2\<0\>\/XI2\<0\>\/XI2\<1\>\/XI2\<0\>\/RR0 \
 (  \
 N_SEL0\<0\>_XI2\<0\>\/XI2\<1\>\/XI2\<1\>\/XI2\<0\>\/XI2\<0\>\/XI2\<0\>\/XI2\<1\>\/XI2\<0\>\/RR0_pos \
 N_WLSEL\<784\>_XI2\<0\>\/XI2\<1\>\/XI2\<1\>\/XI2\<0\>\/XI2\<0\>\/XI2\<0\>\/XI2\<1\>\/XI2\<0\>\/RR0_neg \
 ) R_1X_LL w=1e-07 l=1e-07   res=0.149966
XXI2\<0\>\/XI2\<1\>\/XI2\<1\>\/XI2\<0\>\/XI2\<0\>\/XI2\<0\>\/XI2\<1\>\/XI2\<0\>\/RR1 \
 (  \
 N_SEL1\<1\>_XI2\<0\>\/XI2\<1\>\/XI2\<1\>\/XI2\<0\>\/XI2\<0\>\/XI2\<0\>\/XI2\<1\>\/XI2\<0\>\/RR1_pos \
 N_WLSEL\<785\>_XI2\<0\>\/XI2\<1\>\/XI2\<1\>\/XI2\<0\>\/XI2\<0\>\/XI2\<0\>\/XI2\<1\>\/XI2\<0\>\/RR1_neg \
 ) R_1X_LL w=1e-07 l=1e-07   res=0.149966
XXI2\<0\>\/XI2\<1\>\/XI2\<1\>\/XI2\<0\>\/XI2\<0\>\/XI2\<0\>\/XI2\<1\>\/XI2\<0\>\/RR2 \
 (  \
 N_SEL2\<0\>_XI2\<0\>\/XI2\<1\>\/XI2\<1\>\/XI2\<0\>\/XI2\<0\>\/XI2\<0\>\/XI2\<1\>\/XI2\<0\>\/RR2_pos \
 N_WLSEL\<786\>_XI2\<0\>\/XI2\<1\>\/XI2\<1\>\/XI2\<0\>\/XI2\<0\>\/XI2\<0\>\/XI2\<1\>\/XI2\<0\>\/RR2_neg \
 ) R_1X_LL w=1e-07 l=1e-07   res=0.149966
XXI2\<0\>\/XI2\<1\>\/XI2\<1\>\/XI2\<0\>\/XI2\<0\>\/XI2\<0\>\/XI2\<1\>\/XI2\<0\>\/RR3 \
 (  \
 N_SEL3\<0\>_XI2\<0\>\/XI2\<1\>\/XI2\<1\>\/XI2\<0\>\/XI2\<0\>\/XI2\<0\>\/XI2\<1\>\/XI2\<0\>\/RR3_pos \
 N_WLSEL\<787\>_XI2\<0\>\/XI2\<1\>\/XI2\<1\>\/XI2\<0\>\/XI2\<0\>\/XI2\<0\>\/XI2\<1\>\/XI2\<0\>\/RR3_neg \
 ) R_1X_LL w=1e-07 l=1e-07   res=0.149966
XXI2\<0\>\/XI2\<1\>\/XI2\<1\>\/XI2\<0\>\/XI2\<0\>\/XI2\<0\>\/XI2\<1\>\/XI2\<0\>\/RR4 \
 (  \
 N_SEL4\<0\>_XI2\<0\>\/XI2\<1\>\/XI2\<1\>\/XI2\<0\>\/XI2\<0\>\/XI2\<0\>\/XI2\<1\>\/XI2\<0\>\/RR4_pos \
 N_WLSEL\<788\>_XI2\<0\>\/XI2\<1\>\/XI2\<1\>\/XI2\<0\>\/XI2\<0\>\/XI2\<0\>\/XI2\<1\>\/XI2\<0\>\/RR4_neg \
 ) R_1X_LL w=1e-07 l=1e-07   res=0.149966
XXI2\<0\>\/XI2\<1\>\/XI2\<1\>\/XI2\<0\>\/XI2\<0\>\/XI2\<0\>\/XI2\<1\>\/XI2\<0\>\/RR7 \
 (  \
 N_SEL5\<1\>_XI2\<0\>\/XI2\<1\>\/XI2\<1\>\/XI2\<0\>\/XI2\<0\>\/XI2\<0\>\/XI2\<1\>\/XI2\<0\>\/RR7_pos \
 N_WLSEL\<789\>_XI2\<0\>\/XI2\<1\>\/XI2\<1\>\/XI2\<0\>\/XI2\<0\>\/XI2\<0\>\/XI2\<1\>\/XI2\<0\>\/RR7_neg \
 ) R_1X_LL w=1e-07 l=1e-07   res=0.149966
XXI2\<0\>\/XI2\<1\>\/XI2\<1\>\/XI2\<0\>\/XI2\<0\>\/XI2\<0\>\/XI2\<1\>\/XI2\<0\>\/RR6 \
 (  \
 N_SEL6\<1\>_XI2\<0\>\/XI2\<1\>\/XI2\<1\>\/XI2\<0\>\/XI2\<0\>\/XI2\<0\>\/XI2\<1\>\/XI2\<0\>\/RR6_pos \
 N_WLSEL\<790\>_XI2\<0\>\/XI2\<1\>\/XI2\<1\>\/XI2\<0\>\/XI2\<0\>\/XI2\<0\>\/XI2\<1\>\/XI2\<0\>\/RR6_neg \
 ) R_1X_LL w=1e-07 l=1e-07   res=0.149966
XXI2\<0\>\/XI2\<1\>\/XI2\<1\>\/XI2\<0\>\/XI2\<0\>\/XI2\<0\>\/XI2\<1\>\/XI2\<0\>\/RR5 \
 (  \
 N_SEL7\<0\>_XI2\<0\>\/XI2\<1\>\/XI2\<1\>\/XI2\<0\>\/XI2\<0\>\/XI2\<0\>\/XI2\<1\>\/XI2\<0\>\/RR5_pos \
 N_WLSEL\<791\>_XI2\<0\>\/XI2\<1\>\/XI2\<1\>\/XI2\<0\>\/XI2\<0\>\/XI2\<0\>\/XI2\<1\>\/XI2\<0\>\/RR5_neg \
 ) R_1X_LL w=1e-07 l=1e-07   res=0.149966
XXI2\<0\>\/XI2\<1\>\/XI2\<1\>\/XI2\<0\>\/XI2\<0\>\/XI2\<0\>\/XI2\<1\>\/XI2\<1\>\/RR0 \
 (  \
 N_SEL0\<1\>_XI2\<0\>\/XI2\<1\>\/XI2\<1\>\/XI2\<0\>\/XI2\<0\>\/XI2\<0\>\/XI2\<1\>\/XI2\<1\>\/RR0_pos \
 N_WLSEL\<792\>_XI2\<0\>\/XI2\<1\>\/XI2\<1\>\/XI2\<0\>\/XI2\<0\>\/XI2\<0\>\/XI2\<1\>\/XI2\<1\>\/RR0_neg \
 ) R_1X_LL w=1e-07 l=1e-07   res=0.149966
XXI2\<0\>\/XI2\<1\>\/XI2\<1\>\/XI2\<0\>\/XI2\<0\>\/XI2\<0\>\/XI2\<1\>\/XI2\<1\>\/RR1 \
 (  \
 N_SEL1\<1\>_XI2\<0\>\/XI2\<1\>\/XI2\<1\>\/XI2\<0\>\/XI2\<0\>\/XI2\<0\>\/XI2\<1\>\/XI2\<1\>\/RR1_pos \
 N_WLSEL\<793\>_XI2\<0\>\/XI2\<1\>\/XI2\<1\>\/XI2\<0\>\/XI2\<0\>\/XI2\<0\>\/XI2\<1\>\/XI2\<1\>\/RR1_neg \
 ) R_1X_LL w=1e-07 l=1e-07   res=0.149966
XXI2\<0\>\/XI2\<1\>\/XI2\<1\>\/XI2\<0\>\/XI2\<0\>\/XI2\<0\>\/XI2\<1\>\/XI2\<1\>\/RR2 \
 (  \
 N_SEL2\<0\>_XI2\<0\>\/XI2\<1\>\/XI2\<1\>\/XI2\<0\>\/XI2\<0\>\/XI2\<0\>\/XI2\<1\>\/XI2\<1\>\/RR2_pos \
 N_WLSEL\<794\>_XI2\<0\>\/XI2\<1\>\/XI2\<1\>\/XI2\<0\>\/XI2\<0\>\/XI2\<0\>\/XI2\<1\>\/XI2\<1\>\/RR2_neg \
 ) R_1X_LL w=1e-07 l=1e-07   res=0.149966
XXI2\<0\>\/XI2\<1\>\/XI2\<1\>\/XI2\<0\>\/XI2\<0\>\/XI2\<0\>\/XI2\<1\>\/XI2\<1\>\/RR3 \
 (  \
 N_SEL3\<0\>_XI2\<0\>\/XI2\<1\>\/XI2\<1\>\/XI2\<0\>\/XI2\<0\>\/XI2\<0\>\/XI2\<1\>\/XI2\<1\>\/RR3_pos \
 N_WLSEL\<795\>_XI2\<0\>\/XI2\<1\>\/XI2\<1\>\/XI2\<0\>\/XI2\<0\>\/XI2\<0\>\/XI2\<1\>\/XI2\<1\>\/RR3_neg \
 ) R_1X_LL w=1e-07 l=1e-07   res=0.149966
XXI2\<0\>\/XI2\<1\>\/XI2\<1\>\/XI2\<0\>\/XI2\<0\>\/XI2\<0\>\/XI2\<1\>\/XI2\<1\>\/RR4 \
 (  \
 N_SEL4\<0\>_XI2\<0\>\/XI2\<1\>\/XI2\<1\>\/XI2\<0\>\/XI2\<0\>\/XI2\<0\>\/XI2\<1\>\/XI2\<1\>\/RR4_pos \
 N_WLSEL\<796\>_XI2\<0\>\/XI2\<1\>\/XI2\<1\>\/XI2\<0\>\/XI2\<0\>\/XI2\<0\>\/XI2\<1\>\/XI2\<1\>\/RR4_neg \
 ) R_1X_LL w=1e-07 l=1e-07   res=0.149966
XXI2\<0\>\/XI2\<1\>\/XI2\<1\>\/XI2\<0\>\/XI2\<0\>\/XI2\<0\>\/XI2\<1\>\/XI2\<1\>\/RR7 \
 (  \
 N_SEL5\<1\>_XI2\<0\>\/XI2\<1\>\/XI2\<1\>\/XI2\<0\>\/XI2\<0\>\/XI2\<0\>\/XI2\<1\>\/XI2\<1\>\/RR7_pos \
 N_WLSEL\<797\>_XI2\<0\>\/XI2\<1\>\/XI2\<1\>\/XI2\<0\>\/XI2\<0\>\/XI2\<0\>\/XI2\<1\>\/XI2\<1\>\/RR7_neg \
 ) R_1X_LL w=1e-07 l=1e-07   res=0.149966
XXI2\<0\>\/XI2\<1\>\/XI2\<1\>\/XI2\<0\>\/XI2\<0\>\/XI2\<0\>\/XI2\<1\>\/XI2\<1\>\/RR6 \
 (  \
 N_SEL6\<1\>_XI2\<0\>\/XI2\<1\>\/XI2\<1\>\/XI2\<0\>\/XI2\<0\>\/XI2\<0\>\/XI2\<1\>\/XI2\<1\>\/RR6_pos \
 N_WLSEL\<798\>_XI2\<0\>\/XI2\<1\>\/XI2\<1\>\/XI2\<0\>\/XI2\<0\>\/XI2\<0\>\/XI2\<1\>\/XI2\<1\>\/RR6_neg \
 ) R_1X_LL w=1e-07 l=1e-07   res=0.149966
XXI2\<0\>\/XI2\<1\>\/XI2\<1\>\/XI2\<0\>\/XI2\<0\>\/XI2\<0\>\/XI2\<1\>\/XI2\<1\>\/RR5 \
 (  \
 N_SEL7\<0\>_XI2\<0\>\/XI2\<1\>\/XI2\<1\>\/XI2\<0\>\/XI2\<0\>\/XI2\<0\>\/XI2\<1\>\/XI2\<1\>\/RR5_pos \
 N_WLSEL\<799\>_XI2\<0\>\/XI2\<1\>\/XI2\<1\>\/XI2\<0\>\/XI2\<0\>\/XI2\<0\>\/XI2\<1\>\/XI2\<1\>\/RR5_neg \
 ) R_1X_LL w=1e-07 l=1e-07   res=0.149966
XXI2\<0\>\/XI2\<1\>\/XI2\<1\>\/XI2\<0\>\/XI2\<0\>\/XI2\<1\>\/XI2\<0\>\/XI2\<0\>\/RR0 \
 (  \
 N_SEL0\<0\>_XI2\<0\>\/XI2\<1\>\/XI2\<1\>\/XI2\<0\>\/XI2\<0\>\/XI2\<1\>\/XI2\<0\>\/XI2\<0\>\/RR0_pos \
 N_WLSEL\<800\>_XI2\<0\>\/XI2\<1\>\/XI2\<1\>\/XI2\<0\>\/XI2\<0\>\/XI2\<1\>\/XI2\<0\>\/XI2\<0\>\/RR0_neg \
 ) R_1X_LL w=1e-07 l=1e-07   res=0.149966
XXI2\<0\>\/XI2\<1\>\/XI2\<1\>\/XI2\<0\>\/XI2\<0\>\/XI2\<1\>\/XI2\<0\>\/XI2\<0\>\/RR1 \
 (  \
 N_SEL1\<0\>_XI2\<0\>\/XI2\<1\>\/XI2\<1\>\/XI2\<0\>\/XI2\<0\>\/XI2\<1\>\/XI2\<0\>\/XI2\<0\>\/RR1_pos \
 N_WLSEL\<801\>_XI2\<0\>\/XI2\<1\>\/XI2\<1\>\/XI2\<0\>\/XI2\<0\>\/XI2\<1\>\/XI2\<0\>\/XI2\<0\>\/RR1_neg \
 ) R_1X_LL w=1e-07 l=1e-07   res=0.149966
XXI2\<0\>\/XI2\<1\>\/XI2\<1\>\/XI2\<0\>\/XI2\<0\>\/XI2\<1\>\/XI2\<0\>\/XI2\<0\>\/RR2 \
 (  \
 N_SEL2\<1\>_XI2\<0\>\/XI2\<1\>\/XI2\<1\>\/XI2\<0\>\/XI2\<0\>\/XI2\<1\>\/XI2\<0\>\/XI2\<0\>\/RR2_pos \
 N_WLSEL\<802\>_XI2\<0\>\/XI2\<1\>\/XI2\<1\>\/XI2\<0\>\/XI2\<0\>\/XI2\<1\>\/XI2\<0\>\/XI2\<0\>\/RR2_neg \
 ) R_1X_LL w=1e-07 l=1e-07   res=0.149966
XXI2\<0\>\/XI2\<1\>\/XI2\<1\>\/XI2\<0\>\/XI2\<0\>\/XI2\<1\>\/XI2\<0\>\/XI2\<0\>\/RR3 \
 (  \
 N_SEL3\<0\>_XI2\<0\>\/XI2\<1\>\/XI2\<1\>\/XI2\<0\>\/XI2\<0\>\/XI2\<1\>\/XI2\<0\>\/XI2\<0\>\/RR3_pos \
 N_WLSEL\<803\>_XI2\<0\>\/XI2\<1\>\/XI2\<1\>\/XI2\<0\>\/XI2\<0\>\/XI2\<1\>\/XI2\<0\>\/XI2\<0\>\/RR3_neg \
 ) R_1X_LL w=1e-07 l=1e-07   res=0.149966
XXI2\<0\>\/XI2\<1\>\/XI2\<1\>\/XI2\<0\>\/XI2\<0\>\/XI2\<1\>\/XI2\<0\>\/XI2\<0\>\/RR4 \
 (  \
 N_SEL4\<0\>_XI2\<0\>\/XI2\<1\>\/XI2\<1\>\/XI2\<0\>\/XI2\<0\>\/XI2\<1\>\/XI2\<0\>\/XI2\<0\>\/RR4_pos \
 N_WLSEL\<804\>_XI2\<0\>\/XI2\<1\>\/XI2\<1\>\/XI2\<0\>\/XI2\<0\>\/XI2\<1\>\/XI2\<0\>\/XI2\<0\>\/RR4_neg \
 ) R_1X_LL w=1e-07 l=1e-07   res=0.149966
XXI2\<0\>\/XI2\<1\>\/XI2\<1\>\/XI2\<0\>\/XI2\<0\>\/XI2\<1\>\/XI2\<0\>\/XI2\<0\>\/RR7 \
 (  \
 N_SEL5\<1\>_XI2\<0\>\/XI2\<1\>\/XI2\<1\>\/XI2\<0\>\/XI2\<0\>\/XI2\<1\>\/XI2\<0\>\/XI2\<0\>\/RR7_pos \
 N_WLSEL\<805\>_XI2\<0\>\/XI2\<1\>\/XI2\<1\>\/XI2\<0\>\/XI2\<0\>\/XI2\<1\>\/XI2\<0\>\/XI2\<0\>\/RR7_neg \
 ) R_1X_LL w=1e-07 l=1e-07   res=0.149966
XXI2\<0\>\/XI2\<1\>\/XI2\<1\>\/XI2\<0\>\/XI2\<0\>\/XI2\<1\>\/XI2\<0\>\/XI2\<0\>\/RR6 \
 (  \
 N_SEL6\<1\>_XI2\<0\>\/XI2\<1\>\/XI2\<1\>\/XI2\<0\>\/XI2\<0\>\/XI2\<1\>\/XI2\<0\>\/XI2\<0\>\/RR6_pos \
 N_WLSEL\<806\>_XI2\<0\>\/XI2\<1\>\/XI2\<1\>\/XI2\<0\>\/XI2\<0\>\/XI2\<1\>\/XI2\<0\>\/XI2\<0\>\/RR6_neg \
 ) R_1X_LL w=1e-07 l=1e-07   res=0.149966
XXI2\<0\>\/XI2\<1\>\/XI2\<1\>\/XI2\<0\>\/XI2\<0\>\/XI2\<1\>\/XI2\<0\>\/XI2\<0\>\/RR5 \
 (  \
 N_SEL7\<0\>_XI2\<0\>\/XI2\<1\>\/XI2\<1\>\/XI2\<0\>\/XI2\<0\>\/XI2\<1\>\/XI2\<0\>\/XI2\<0\>\/RR5_pos \
 N_WLSEL\<807\>_XI2\<0\>\/XI2\<1\>\/XI2\<1\>\/XI2\<0\>\/XI2\<0\>\/XI2\<1\>\/XI2\<0\>\/XI2\<0\>\/RR5_neg \
 ) R_1X_LL w=1e-07 l=1e-07   res=0.149966
XXI2\<0\>\/XI2\<1\>\/XI2\<1\>\/XI2\<0\>\/XI2\<0\>\/XI2\<1\>\/XI2\<0\>\/XI2\<1\>\/RR0 \
 (  \
 N_SEL0\<1\>_XI2\<0\>\/XI2\<1\>\/XI2\<1\>\/XI2\<0\>\/XI2\<0\>\/XI2\<1\>\/XI2\<0\>\/XI2\<1\>\/RR0_pos \
 N_WLSEL\<808\>_XI2\<0\>\/XI2\<1\>\/XI2\<1\>\/XI2\<0\>\/XI2\<0\>\/XI2\<1\>\/XI2\<0\>\/XI2\<1\>\/RR0_neg \
 ) R_1X_LL w=1e-07 l=1e-07   res=0.149966
XXI2\<0\>\/XI2\<1\>\/XI2\<1\>\/XI2\<0\>\/XI2\<0\>\/XI2\<1\>\/XI2\<0\>\/XI2\<1\>\/RR1 \
 (  \
 N_SEL1\<0\>_XI2\<0\>\/XI2\<1\>\/XI2\<1\>\/XI2\<0\>\/XI2\<0\>\/XI2\<1\>\/XI2\<0\>\/XI2\<1\>\/RR1_pos \
 N_WLSEL\<809\>_XI2\<0\>\/XI2\<1\>\/XI2\<1\>\/XI2\<0\>\/XI2\<0\>\/XI2\<1\>\/XI2\<0\>\/XI2\<1\>\/RR1_neg \
 ) R_1X_LL w=1e-07 l=1e-07   res=0.149966
XXI2\<0\>\/XI2\<1\>\/XI2\<1\>\/XI2\<0\>\/XI2\<0\>\/XI2\<1\>\/XI2\<0\>\/XI2\<1\>\/RR2 \
 (  \
 N_SEL2\<1\>_XI2\<0\>\/XI2\<1\>\/XI2\<1\>\/XI2\<0\>\/XI2\<0\>\/XI2\<1\>\/XI2\<0\>\/XI2\<1\>\/RR2_pos \
 N_WLSEL\<810\>_XI2\<0\>\/XI2\<1\>\/XI2\<1\>\/XI2\<0\>\/XI2\<0\>\/XI2\<1\>\/XI2\<0\>\/XI2\<1\>\/RR2_neg \
 ) R_1X_LL w=1e-07 l=1e-07   res=0.149966
XXI2\<0\>\/XI2\<1\>\/XI2\<1\>\/XI2\<0\>\/XI2\<0\>\/XI2\<1\>\/XI2\<0\>\/XI2\<1\>\/RR3 \
 (  \
 N_SEL3\<0\>_XI2\<0\>\/XI2\<1\>\/XI2\<1\>\/XI2\<0\>\/XI2\<0\>\/XI2\<1\>\/XI2\<0\>\/XI2\<1\>\/RR3_pos \
 N_WLSEL\<811\>_XI2\<0\>\/XI2\<1\>\/XI2\<1\>\/XI2\<0\>\/XI2\<0\>\/XI2\<1\>\/XI2\<0\>\/XI2\<1\>\/RR3_neg \
 ) R_1X_LL w=1e-07 l=1e-07   res=0.149966
XXI2\<0\>\/XI2\<1\>\/XI2\<1\>\/XI2\<0\>\/XI2\<0\>\/XI2\<1\>\/XI2\<0\>\/XI2\<1\>\/RR4 \
 (  \
 N_SEL4\<0\>_XI2\<0\>\/XI2\<1\>\/XI2\<1\>\/XI2\<0\>\/XI2\<0\>\/XI2\<1\>\/XI2\<0\>\/XI2\<1\>\/RR4_pos \
 N_WLSEL\<812\>_XI2\<0\>\/XI2\<1\>\/XI2\<1\>\/XI2\<0\>\/XI2\<0\>\/XI2\<1\>\/XI2\<0\>\/XI2\<1\>\/RR4_neg \
 ) R_1X_LL w=1e-07 l=1e-07   res=0.149966
XXI2\<0\>\/XI2\<1\>\/XI2\<1\>\/XI2\<0\>\/XI2\<0\>\/XI2\<1\>\/XI2\<0\>\/XI2\<1\>\/RR7 \
 (  \
 N_SEL5\<1\>_XI2\<0\>\/XI2\<1\>\/XI2\<1\>\/XI2\<0\>\/XI2\<0\>\/XI2\<1\>\/XI2\<0\>\/XI2\<1\>\/RR7_pos \
 N_WLSEL\<813\>_XI2\<0\>\/XI2\<1\>\/XI2\<1\>\/XI2\<0\>\/XI2\<0\>\/XI2\<1\>\/XI2\<0\>\/XI2\<1\>\/RR7_neg \
 ) R_1X_LL w=1e-07 l=1e-07   res=0.149966
XXI2\<0\>\/XI2\<1\>\/XI2\<1\>\/XI2\<0\>\/XI2\<0\>\/XI2\<1\>\/XI2\<0\>\/XI2\<1\>\/RR6 \
 (  \
 N_SEL6\<1\>_XI2\<0\>\/XI2\<1\>\/XI2\<1\>\/XI2\<0\>\/XI2\<0\>\/XI2\<1\>\/XI2\<0\>\/XI2\<1\>\/RR6_pos \
 N_WLSEL\<814\>_XI2\<0\>\/XI2\<1\>\/XI2\<1\>\/XI2\<0\>\/XI2\<0\>\/XI2\<1\>\/XI2\<0\>\/XI2\<1\>\/RR6_neg \
 ) R_1X_LL w=1e-07 l=1e-07   res=0.149966
XXI2\<0\>\/XI2\<1\>\/XI2\<1\>\/XI2\<0\>\/XI2\<0\>\/XI2\<1\>\/XI2\<0\>\/XI2\<1\>\/RR5 \
 (  \
 N_SEL7\<0\>_XI2\<0\>\/XI2\<1\>\/XI2\<1\>\/XI2\<0\>\/XI2\<0\>\/XI2\<1\>\/XI2\<0\>\/XI2\<1\>\/RR5_pos \
 N_WLSEL\<815\>_XI2\<0\>\/XI2\<1\>\/XI2\<1\>\/XI2\<0\>\/XI2\<0\>\/XI2\<1\>\/XI2\<0\>\/XI2\<1\>\/RR5_neg \
 ) R_1X_LL w=1e-07 l=1e-07   res=0.149966
XXI2\<0\>\/XI2\<1\>\/XI2\<1\>\/XI2\<0\>\/XI2\<0\>\/XI2\<1\>\/XI2\<1\>\/XI2\<0\>\/RR0 \
 (  \
 N_SEL0\<0\>_XI2\<0\>\/XI2\<1\>\/XI2\<1\>\/XI2\<0\>\/XI2\<0\>\/XI2\<1\>\/XI2\<1\>\/XI2\<0\>\/RR0_pos \
 N_WLSEL\<816\>_XI2\<0\>\/XI2\<1\>\/XI2\<1\>\/XI2\<0\>\/XI2\<0\>\/XI2\<1\>\/XI2\<1\>\/XI2\<0\>\/RR0_neg \
 ) R_1X_LL w=1e-07 l=1e-07   res=0.149966
XXI2\<0\>\/XI2\<1\>\/XI2\<1\>\/XI2\<0\>\/XI2\<0\>\/XI2\<1\>\/XI2\<1\>\/XI2\<0\>\/RR1 \
 (  \
 N_SEL1\<1\>_XI2\<0\>\/XI2\<1\>\/XI2\<1\>\/XI2\<0\>\/XI2\<0\>\/XI2\<1\>\/XI2\<1\>\/XI2\<0\>\/RR1_pos \
 N_WLSEL\<817\>_XI2\<0\>\/XI2\<1\>\/XI2\<1\>\/XI2\<0\>\/XI2\<0\>\/XI2\<1\>\/XI2\<1\>\/XI2\<0\>\/RR1_neg \
 ) R_1X_LL w=1e-07 l=1e-07   res=0.149966
XXI2\<0\>\/XI2\<1\>\/XI2\<1\>\/XI2\<0\>\/XI2\<0\>\/XI2\<1\>\/XI2\<1\>\/XI2\<0\>\/RR2 \
 (  \
 N_SEL2\<1\>_XI2\<0\>\/XI2\<1\>\/XI2\<1\>\/XI2\<0\>\/XI2\<0\>\/XI2\<1\>\/XI2\<1\>\/XI2\<0\>\/RR2_pos \
 N_WLSEL\<818\>_XI2\<0\>\/XI2\<1\>\/XI2\<1\>\/XI2\<0\>\/XI2\<0\>\/XI2\<1\>\/XI2\<1\>\/XI2\<0\>\/RR2_neg \
 ) R_1X_LL w=1e-07 l=1e-07   res=0.149966
XXI2\<0\>\/XI2\<1\>\/XI2\<1\>\/XI2\<0\>\/XI2\<0\>\/XI2\<1\>\/XI2\<1\>\/XI2\<0\>\/RR3 \
 (  \
 N_SEL3\<0\>_XI2\<0\>\/XI2\<1\>\/XI2\<1\>\/XI2\<0\>\/XI2\<0\>\/XI2\<1\>\/XI2\<1\>\/XI2\<0\>\/RR3_pos \
 N_WLSEL\<819\>_XI2\<0\>\/XI2\<1\>\/XI2\<1\>\/XI2\<0\>\/XI2\<0\>\/XI2\<1\>\/XI2\<1\>\/XI2\<0\>\/RR3_neg \
 ) R_1X_LL w=1e-07 l=1e-07   res=0.149966
XXI2\<0\>\/XI2\<1\>\/XI2\<1\>\/XI2\<0\>\/XI2\<0\>\/XI2\<1\>\/XI2\<1\>\/XI2\<0\>\/RR4 \
 (  \
 N_SEL4\<0\>_XI2\<0\>\/XI2\<1\>\/XI2\<1\>\/XI2\<0\>\/XI2\<0\>\/XI2\<1\>\/XI2\<1\>\/XI2\<0\>\/RR4_pos \
 N_WLSEL\<820\>_XI2\<0\>\/XI2\<1\>\/XI2\<1\>\/XI2\<0\>\/XI2\<0\>\/XI2\<1\>\/XI2\<1\>\/XI2\<0\>\/RR4_neg \
 ) R_1X_LL w=1e-07 l=1e-07   res=0.149966
XXI2\<0\>\/XI2\<1\>\/XI2\<1\>\/XI2\<0\>\/XI2\<0\>\/XI2\<1\>\/XI2\<1\>\/XI2\<0\>\/RR7 \
 (  \
 N_SEL5\<1\>_XI2\<0\>\/XI2\<1\>\/XI2\<1\>\/XI2\<0\>\/XI2\<0\>\/XI2\<1\>\/XI2\<1\>\/XI2\<0\>\/RR7_pos \
 N_WLSEL\<821\>_XI2\<0\>\/XI2\<1\>\/XI2\<1\>\/XI2\<0\>\/XI2\<0\>\/XI2\<1\>\/XI2\<1\>\/XI2\<0\>\/RR7_neg \
 ) R_1X_LL w=1e-07 l=1e-07   res=0.149966
XXI2\<0\>\/XI2\<1\>\/XI2\<1\>\/XI2\<0\>\/XI2\<0\>\/XI2\<1\>\/XI2\<1\>\/XI2\<0\>\/RR6 \
 (  \
 N_SEL6\<1\>_XI2\<0\>\/XI2\<1\>\/XI2\<1\>\/XI2\<0\>\/XI2\<0\>\/XI2\<1\>\/XI2\<1\>\/XI2\<0\>\/RR6_pos \
 N_WLSEL\<822\>_XI2\<0\>\/XI2\<1\>\/XI2\<1\>\/XI2\<0\>\/XI2\<0\>\/XI2\<1\>\/XI2\<1\>\/XI2\<0\>\/RR6_neg \
 ) R_1X_LL w=1e-07 l=1e-07   res=0.149966
XXI2\<0\>\/XI2\<1\>\/XI2\<1\>\/XI2\<0\>\/XI2\<0\>\/XI2\<1\>\/XI2\<1\>\/XI2\<0\>\/RR5 \
 (  \
 N_SEL7\<0\>_XI2\<0\>\/XI2\<1\>\/XI2\<1\>\/XI2\<0\>\/XI2\<0\>\/XI2\<1\>\/XI2\<1\>\/XI2\<0\>\/RR5_pos \
 N_WLSEL\<823\>_XI2\<0\>\/XI2\<1\>\/XI2\<1\>\/XI2\<0\>\/XI2\<0\>\/XI2\<1\>\/XI2\<1\>\/XI2\<0\>\/RR5_neg \
 ) R_1X_LL w=1e-07 l=1e-07   res=0.149966
XXI2\<0\>\/XI2\<1\>\/XI2\<1\>\/XI2\<0\>\/XI2\<0\>\/XI2\<1\>\/XI2\<1\>\/XI2\<1\>\/RR0 \
 (  \
 N_SEL0\<1\>_XI2\<0\>\/XI2\<1\>\/XI2\<1\>\/XI2\<0\>\/XI2\<0\>\/XI2\<1\>\/XI2\<1\>\/XI2\<1\>\/RR0_pos \
 N_WLSEL\<824\>_XI2\<0\>\/XI2\<1\>\/XI2\<1\>\/XI2\<0\>\/XI2\<0\>\/XI2\<1\>\/XI2\<1\>\/XI2\<1\>\/RR0_neg \
 ) R_1X_LL w=1e-07 l=1e-07   res=0.149966
XXI2\<0\>\/XI2\<1\>\/XI2\<1\>\/XI2\<0\>\/XI2\<0\>\/XI2\<1\>\/XI2\<1\>\/XI2\<1\>\/RR1 \
 (  \
 N_SEL1\<1\>_XI2\<0\>\/XI2\<1\>\/XI2\<1\>\/XI2\<0\>\/XI2\<0\>\/XI2\<1\>\/XI2\<1\>\/XI2\<1\>\/RR1_pos \
 N_WLSEL\<825\>_XI2\<0\>\/XI2\<1\>\/XI2\<1\>\/XI2\<0\>\/XI2\<0\>\/XI2\<1\>\/XI2\<1\>\/XI2\<1\>\/RR1_neg \
 ) R_1X_LL w=1e-07 l=1e-07   res=0.149966
XXI2\<0\>\/XI2\<1\>\/XI2\<1\>\/XI2\<0\>\/XI2\<0\>\/XI2\<1\>\/XI2\<1\>\/XI2\<1\>\/RR2 \
 (  \
 N_SEL2\<1\>_XI2\<0\>\/XI2\<1\>\/XI2\<1\>\/XI2\<0\>\/XI2\<0\>\/XI2\<1\>\/XI2\<1\>\/XI2\<1\>\/RR2_pos \
 N_WLSEL\<826\>_XI2\<0\>\/XI2\<1\>\/XI2\<1\>\/XI2\<0\>\/XI2\<0\>\/XI2\<1\>\/XI2\<1\>\/XI2\<1\>\/RR2_neg \
 ) R_1X_LL w=1e-07 l=1e-07   res=0.149966
XXI2\<0\>\/XI2\<1\>\/XI2\<1\>\/XI2\<0\>\/XI2\<0\>\/XI2\<1\>\/XI2\<1\>\/XI2\<1\>\/RR3 \
 (  \
 N_SEL3\<0\>_XI2\<0\>\/XI2\<1\>\/XI2\<1\>\/XI2\<0\>\/XI2\<0\>\/XI2\<1\>\/XI2\<1\>\/XI2\<1\>\/RR3_pos \
 N_WLSEL\<827\>_XI2\<0\>\/XI2\<1\>\/XI2\<1\>\/XI2\<0\>\/XI2\<0\>\/XI2\<1\>\/XI2\<1\>\/XI2\<1\>\/RR3_neg \
 ) R_1X_LL w=1e-07 l=1e-07   res=0.149966
XXI2\<0\>\/XI2\<1\>\/XI2\<1\>\/XI2\<0\>\/XI2\<0\>\/XI2\<1\>\/XI2\<1\>\/XI2\<1\>\/RR4 \
 (  \
 N_SEL4\<0\>_XI2\<0\>\/XI2\<1\>\/XI2\<1\>\/XI2\<0\>\/XI2\<0\>\/XI2\<1\>\/XI2\<1\>\/XI2\<1\>\/RR4_pos \
 N_WLSEL\<828\>_XI2\<0\>\/XI2\<1\>\/XI2\<1\>\/XI2\<0\>\/XI2\<0\>\/XI2\<1\>\/XI2\<1\>\/XI2\<1\>\/RR4_neg \
 ) R_1X_LL w=1e-07 l=1e-07   res=0.149966
XXI2\<0\>\/XI2\<1\>\/XI2\<1\>\/XI2\<0\>\/XI2\<0\>\/XI2\<1\>\/XI2\<1\>\/XI2\<1\>\/RR7 \
 (  \
 N_SEL5\<1\>_XI2\<0\>\/XI2\<1\>\/XI2\<1\>\/XI2\<0\>\/XI2\<0\>\/XI2\<1\>\/XI2\<1\>\/XI2\<1\>\/RR7_pos \
 N_WLSEL\<829\>_XI2\<0\>\/XI2\<1\>\/XI2\<1\>\/XI2\<0\>\/XI2\<0\>\/XI2\<1\>\/XI2\<1\>\/XI2\<1\>\/RR7_neg \
 ) R_1X_LL w=1e-07 l=1e-07   res=0.149966
XXI2\<0\>\/XI2\<1\>\/XI2\<1\>\/XI2\<0\>\/XI2\<0\>\/XI2\<1\>\/XI2\<1\>\/XI2\<1\>\/RR6 \
 (  \
 N_SEL6\<1\>_XI2\<0\>\/XI2\<1\>\/XI2\<1\>\/XI2\<0\>\/XI2\<0\>\/XI2\<1\>\/XI2\<1\>\/XI2\<1\>\/RR6_pos \
 N_WLSEL\<830\>_XI2\<0\>\/XI2\<1\>\/XI2\<1\>\/XI2\<0\>\/XI2\<0\>\/XI2\<1\>\/XI2\<1\>\/XI2\<1\>\/RR6_neg \
 ) R_1X_LL w=1e-07 l=1e-07   res=0.149966
XXI2\<0\>\/XI2\<1\>\/XI2\<1\>\/XI2\<0\>\/XI2\<0\>\/XI2\<1\>\/XI2\<1\>\/XI2\<1\>\/RR5 \
 (  \
 N_SEL7\<0\>_XI2\<0\>\/XI2\<1\>\/XI2\<1\>\/XI2\<0\>\/XI2\<0\>\/XI2\<1\>\/XI2\<1\>\/XI2\<1\>\/RR5_pos \
 N_WLSEL\<831\>_XI2\<0\>\/XI2\<1\>\/XI2\<1\>\/XI2\<0\>\/XI2\<0\>\/XI2\<1\>\/XI2\<1\>\/XI2\<1\>\/RR5_neg \
 ) R_1X_LL w=1e-07 l=1e-07   res=0.149966
XXI2\<0\>\/XI2\<1\>\/XI2\<1\>\/XI2\<0\>\/XI2\<1\>\/XI2\<0\>\/XI2\<0\>\/XI2\<0\>\/RR0 \
 (  \
 N_SEL0\<0\>_XI2\<0\>\/XI2\<1\>\/XI2\<1\>\/XI2\<0\>\/XI2\<1\>\/XI2\<0\>\/XI2\<0\>\/XI2\<0\>\/RR0_pos \
 N_WLSEL\<832\>_XI2\<0\>\/XI2\<1\>\/XI2\<1\>\/XI2\<0\>\/XI2\<1\>\/XI2\<0\>\/XI2\<0\>\/XI2\<0\>\/RR0_neg \
 ) R_1X_LL w=1e-07 l=1e-07   res=0.149966
XXI2\<0\>\/XI2\<1\>\/XI2\<1\>\/XI2\<0\>\/XI2\<1\>\/XI2\<0\>\/XI2\<0\>\/XI2\<0\>\/RR1 \
 (  \
 N_SEL1\<0\>_XI2\<0\>\/XI2\<1\>\/XI2\<1\>\/XI2\<0\>\/XI2\<1\>\/XI2\<0\>\/XI2\<0\>\/XI2\<0\>\/RR1_pos \
 N_WLSEL\<833\>_XI2\<0\>\/XI2\<1\>\/XI2\<1\>\/XI2\<0\>\/XI2\<1\>\/XI2\<0\>\/XI2\<0\>\/XI2\<0\>\/RR1_neg \
 ) R_1X_LL w=1e-07 l=1e-07   res=0.149966
XXI2\<0\>\/XI2\<1\>\/XI2\<1\>\/XI2\<0\>\/XI2\<1\>\/XI2\<0\>\/XI2\<0\>\/XI2\<0\>\/RR2 \
 (  \
 N_SEL2\<0\>_XI2\<0\>\/XI2\<1\>\/XI2\<1\>\/XI2\<0\>\/XI2\<1\>\/XI2\<0\>\/XI2\<0\>\/XI2\<0\>\/RR2_pos \
 N_WLSEL\<834\>_XI2\<0\>\/XI2\<1\>\/XI2\<1\>\/XI2\<0\>\/XI2\<1\>\/XI2\<0\>\/XI2\<0\>\/XI2\<0\>\/RR2_neg \
 ) R_1X_LL w=1e-07 l=1e-07   res=0.149966
XXI2\<0\>\/XI2\<1\>\/XI2\<1\>\/XI2\<0\>\/XI2\<1\>\/XI2\<0\>\/XI2\<0\>\/XI2\<0\>\/RR3 \
 (  \
 N_SEL3\<1\>_XI2\<0\>\/XI2\<1\>\/XI2\<1\>\/XI2\<0\>\/XI2\<1\>\/XI2\<0\>\/XI2\<0\>\/XI2\<0\>\/RR3_pos \
 N_WLSEL\<835\>_XI2\<0\>\/XI2\<1\>\/XI2\<1\>\/XI2\<0\>\/XI2\<1\>\/XI2\<0\>\/XI2\<0\>\/XI2\<0\>\/RR3_neg \
 ) R_1X_LL w=1e-07 l=1e-07   res=0.149966
XXI2\<0\>\/XI2\<1\>\/XI2\<1\>\/XI2\<0\>\/XI2\<1\>\/XI2\<0\>\/XI2\<0\>\/XI2\<0\>\/RR4 \
 (  \
 N_SEL4\<0\>_XI2\<0\>\/XI2\<1\>\/XI2\<1\>\/XI2\<0\>\/XI2\<1\>\/XI2\<0\>\/XI2\<0\>\/XI2\<0\>\/RR4_pos \
 N_WLSEL\<836\>_XI2\<0\>\/XI2\<1\>\/XI2\<1\>\/XI2\<0\>\/XI2\<1\>\/XI2\<0\>\/XI2\<0\>\/XI2\<0\>\/RR4_neg \
 ) R_1X_LL w=1e-07 l=1e-07   res=0.149966
XXI2\<0\>\/XI2\<1\>\/XI2\<1\>\/XI2\<0\>\/XI2\<1\>\/XI2\<0\>\/XI2\<0\>\/XI2\<0\>\/RR7 \
 (  \
 N_SEL5\<1\>_XI2\<0\>\/XI2\<1\>\/XI2\<1\>\/XI2\<0\>\/XI2\<1\>\/XI2\<0\>\/XI2\<0\>\/XI2\<0\>\/RR7_pos \
 N_WLSEL\<837\>_XI2\<0\>\/XI2\<1\>\/XI2\<1\>\/XI2\<0\>\/XI2\<1\>\/XI2\<0\>\/XI2\<0\>\/XI2\<0\>\/RR7_neg \
 ) R_1X_LL w=1e-07 l=1e-07   res=0.149966
XXI2\<0\>\/XI2\<1\>\/XI2\<1\>\/XI2\<0\>\/XI2\<1\>\/XI2\<0\>\/XI2\<0\>\/XI2\<0\>\/RR6 \
 (  \
 N_SEL6\<1\>_XI2\<0\>\/XI2\<1\>\/XI2\<1\>\/XI2\<0\>\/XI2\<1\>\/XI2\<0\>\/XI2\<0\>\/XI2\<0\>\/RR6_pos \
 N_WLSEL\<838\>_XI2\<0\>\/XI2\<1\>\/XI2\<1\>\/XI2\<0\>\/XI2\<1\>\/XI2\<0\>\/XI2\<0\>\/XI2\<0\>\/RR6_neg \
 ) R_1X_LL w=1e-07 l=1e-07   res=0.149966
XXI2\<0\>\/XI2\<1\>\/XI2\<1\>\/XI2\<0\>\/XI2\<1\>\/XI2\<0\>\/XI2\<0\>\/XI2\<0\>\/RR5 \
 (  \
 N_SEL7\<0\>_XI2\<0\>\/XI2\<1\>\/XI2\<1\>\/XI2\<0\>\/XI2\<1\>\/XI2\<0\>\/XI2\<0\>\/XI2\<0\>\/RR5_pos \
 N_WLSEL\<839\>_XI2\<0\>\/XI2\<1\>\/XI2\<1\>\/XI2\<0\>\/XI2\<1\>\/XI2\<0\>\/XI2\<0\>\/XI2\<0\>\/RR5_neg \
 ) R_1X_LL w=1e-07 l=1e-07   res=0.149966
XXI2\<0\>\/XI2\<1\>\/XI2\<1\>\/XI2\<0\>\/XI2\<1\>\/XI2\<0\>\/XI2\<0\>\/XI2\<1\>\/RR0 \
 (  \
 N_SEL0\<1\>_XI2\<0\>\/XI2\<1\>\/XI2\<1\>\/XI2\<0\>\/XI2\<1\>\/XI2\<0\>\/XI2\<0\>\/XI2\<1\>\/RR0_pos \
 N_WLSEL\<840\>_XI2\<0\>\/XI2\<1\>\/XI2\<1\>\/XI2\<0\>\/XI2\<1\>\/XI2\<0\>\/XI2\<0\>\/XI2\<1\>\/RR0_neg \
 ) R_1X_LL w=1e-07 l=1e-07   res=0.149966
XXI2\<0\>\/XI2\<1\>\/XI2\<1\>\/XI2\<0\>\/XI2\<1\>\/XI2\<0\>\/XI2\<0\>\/XI2\<1\>\/RR1 \
 (  \
 N_SEL1\<0\>_XI2\<0\>\/XI2\<1\>\/XI2\<1\>\/XI2\<0\>\/XI2\<1\>\/XI2\<0\>\/XI2\<0\>\/XI2\<1\>\/RR1_pos \
 N_WLSEL\<841\>_XI2\<0\>\/XI2\<1\>\/XI2\<1\>\/XI2\<0\>\/XI2\<1\>\/XI2\<0\>\/XI2\<0\>\/XI2\<1\>\/RR1_neg \
 ) R_1X_LL w=1e-07 l=1e-07   res=0.149966
XXI2\<0\>\/XI2\<1\>\/XI2\<1\>\/XI2\<0\>\/XI2\<1\>\/XI2\<0\>\/XI2\<0\>\/XI2\<1\>\/RR2 \
 (  \
 N_SEL2\<0\>_XI2\<0\>\/XI2\<1\>\/XI2\<1\>\/XI2\<0\>\/XI2\<1\>\/XI2\<0\>\/XI2\<0\>\/XI2\<1\>\/RR2_pos \
 N_WLSEL\<842\>_XI2\<0\>\/XI2\<1\>\/XI2\<1\>\/XI2\<0\>\/XI2\<1\>\/XI2\<0\>\/XI2\<0\>\/XI2\<1\>\/RR2_neg \
 ) R_1X_LL w=1e-07 l=1e-07   res=0.149966
XXI2\<0\>\/XI2\<1\>\/XI2\<1\>\/XI2\<0\>\/XI2\<1\>\/XI2\<0\>\/XI2\<0\>\/XI2\<1\>\/RR3 \
 (  \
 N_SEL3\<1\>_XI2\<0\>\/XI2\<1\>\/XI2\<1\>\/XI2\<0\>\/XI2\<1\>\/XI2\<0\>\/XI2\<0\>\/XI2\<1\>\/RR3_pos \
 N_WLSEL\<843\>_XI2\<0\>\/XI2\<1\>\/XI2\<1\>\/XI2\<0\>\/XI2\<1\>\/XI2\<0\>\/XI2\<0\>\/XI2\<1\>\/RR3_neg \
 ) R_1X_LL w=1e-07 l=1e-07   res=0.149966
XXI2\<0\>\/XI2\<1\>\/XI2\<1\>\/XI2\<0\>\/XI2\<1\>\/XI2\<0\>\/XI2\<0\>\/XI2\<1\>\/RR4 \
 (  \
 N_SEL4\<0\>_XI2\<0\>\/XI2\<1\>\/XI2\<1\>\/XI2\<0\>\/XI2\<1\>\/XI2\<0\>\/XI2\<0\>\/XI2\<1\>\/RR4_pos \
 N_WLSEL\<844\>_XI2\<0\>\/XI2\<1\>\/XI2\<1\>\/XI2\<0\>\/XI2\<1\>\/XI2\<0\>\/XI2\<0\>\/XI2\<1\>\/RR4_neg \
 ) R_1X_LL w=1e-07 l=1e-07   res=0.149966
XXI2\<0\>\/XI2\<1\>\/XI2\<1\>\/XI2\<0\>\/XI2\<1\>\/XI2\<0\>\/XI2\<0\>\/XI2\<1\>\/RR7 \
 (  \
 N_SEL5\<1\>_XI2\<0\>\/XI2\<1\>\/XI2\<1\>\/XI2\<0\>\/XI2\<1\>\/XI2\<0\>\/XI2\<0\>\/XI2\<1\>\/RR7_pos \
 N_WLSEL\<845\>_XI2\<0\>\/XI2\<1\>\/XI2\<1\>\/XI2\<0\>\/XI2\<1\>\/XI2\<0\>\/XI2\<0\>\/XI2\<1\>\/RR7_neg \
 ) R_1X_LL w=1e-07 l=1e-07   res=0.149966
XXI2\<0\>\/XI2\<1\>\/XI2\<1\>\/XI2\<0\>\/XI2\<1\>\/XI2\<0\>\/XI2\<0\>\/XI2\<1\>\/RR6 \
 (  \
 N_SEL6\<1\>_XI2\<0\>\/XI2\<1\>\/XI2\<1\>\/XI2\<0\>\/XI2\<1\>\/XI2\<0\>\/XI2\<0\>\/XI2\<1\>\/RR6_pos \
 N_WLSEL\<846\>_XI2\<0\>\/XI2\<1\>\/XI2\<1\>\/XI2\<0\>\/XI2\<1\>\/XI2\<0\>\/XI2\<0\>\/XI2\<1\>\/RR6_neg \
 ) R_1X_LL w=1e-07 l=1e-07   res=0.149966
XXI2\<0\>\/XI2\<1\>\/XI2\<1\>\/XI2\<0\>\/XI2\<1\>\/XI2\<0\>\/XI2\<0\>\/XI2\<1\>\/RR5 \
 (  \
 N_SEL7\<0\>_XI2\<0\>\/XI2\<1\>\/XI2\<1\>\/XI2\<0\>\/XI2\<1\>\/XI2\<0\>\/XI2\<0\>\/XI2\<1\>\/RR5_pos \
 N_WLSEL\<847\>_XI2\<0\>\/XI2\<1\>\/XI2\<1\>\/XI2\<0\>\/XI2\<1\>\/XI2\<0\>\/XI2\<0\>\/XI2\<1\>\/RR5_neg \
 ) R_1X_LL w=1e-07 l=1e-07   res=0.149966
XXI2\<0\>\/XI2\<1\>\/XI2\<1\>\/XI2\<0\>\/XI2\<1\>\/XI2\<0\>\/XI2\<1\>\/XI2\<0\>\/RR0 \
 (  \
 N_SEL0\<0\>_XI2\<0\>\/XI2\<1\>\/XI2\<1\>\/XI2\<0\>\/XI2\<1\>\/XI2\<0\>\/XI2\<1\>\/XI2\<0\>\/RR0_pos \
 N_WLSEL\<848\>_XI2\<0\>\/XI2\<1\>\/XI2\<1\>\/XI2\<0\>\/XI2\<1\>\/XI2\<0\>\/XI2\<1\>\/XI2\<0\>\/RR0_neg \
 ) R_1X_LL w=1e-07 l=1e-07   res=0.149966
XXI2\<0\>\/XI2\<1\>\/XI2\<1\>\/XI2\<0\>\/XI2\<1\>\/XI2\<0\>\/XI2\<1\>\/XI2\<0\>\/RR1 \
 (  \
 N_SEL1\<1\>_XI2\<0\>\/XI2\<1\>\/XI2\<1\>\/XI2\<0\>\/XI2\<1\>\/XI2\<0\>\/XI2\<1\>\/XI2\<0\>\/RR1_pos \
 N_WLSEL\<849\>_XI2\<0\>\/XI2\<1\>\/XI2\<1\>\/XI2\<0\>\/XI2\<1\>\/XI2\<0\>\/XI2\<1\>\/XI2\<0\>\/RR1_neg \
 ) R_1X_LL w=1e-07 l=1e-07   res=0.149966
XXI2\<0\>\/XI2\<1\>\/XI2\<1\>\/XI2\<0\>\/XI2\<1\>\/XI2\<0\>\/XI2\<1\>\/XI2\<0\>\/RR2 \
 (  \
 N_SEL2\<0\>_XI2\<0\>\/XI2\<1\>\/XI2\<1\>\/XI2\<0\>\/XI2\<1\>\/XI2\<0\>\/XI2\<1\>\/XI2\<0\>\/RR2_pos \
 N_WLSEL\<850\>_XI2\<0\>\/XI2\<1\>\/XI2\<1\>\/XI2\<0\>\/XI2\<1\>\/XI2\<0\>\/XI2\<1\>\/XI2\<0\>\/RR2_neg \
 ) R_1X_LL w=1e-07 l=1e-07   res=0.149966
XXI2\<0\>\/XI2\<1\>\/XI2\<1\>\/XI2\<0\>\/XI2\<1\>\/XI2\<0\>\/XI2\<1\>\/XI2\<0\>\/RR3 \
 (  \
 N_SEL3\<1\>_XI2\<0\>\/XI2\<1\>\/XI2\<1\>\/XI2\<0\>\/XI2\<1\>\/XI2\<0\>\/XI2\<1\>\/XI2\<0\>\/RR3_pos \
 N_WLSEL\<851\>_XI2\<0\>\/XI2\<1\>\/XI2\<1\>\/XI2\<0\>\/XI2\<1\>\/XI2\<0\>\/XI2\<1\>\/XI2\<0\>\/RR3_neg \
 ) R_1X_LL w=1e-07 l=1e-07   res=0.149966
XXI2\<0\>\/XI2\<1\>\/XI2\<1\>\/XI2\<0\>\/XI2\<1\>\/XI2\<0\>\/XI2\<1\>\/XI2\<0\>\/RR4 \
 (  \
 N_SEL4\<0\>_XI2\<0\>\/XI2\<1\>\/XI2\<1\>\/XI2\<0\>\/XI2\<1\>\/XI2\<0\>\/XI2\<1\>\/XI2\<0\>\/RR4_pos \
 N_WLSEL\<852\>_XI2\<0\>\/XI2\<1\>\/XI2\<1\>\/XI2\<0\>\/XI2\<1\>\/XI2\<0\>\/XI2\<1\>\/XI2\<0\>\/RR4_neg \
 ) R_1X_LL w=1e-07 l=1e-07   res=0.149966
XXI2\<0\>\/XI2\<1\>\/XI2\<1\>\/XI2\<0\>\/XI2\<1\>\/XI2\<0\>\/XI2\<1\>\/XI2\<0\>\/RR7 \
 (  \
 N_SEL5\<1\>_XI2\<0\>\/XI2\<1\>\/XI2\<1\>\/XI2\<0\>\/XI2\<1\>\/XI2\<0\>\/XI2\<1\>\/XI2\<0\>\/RR7_pos \
 N_WLSEL\<853\>_XI2\<0\>\/XI2\<1\>\/XI2\<1\>\/XI2\<0\>\/XI2\<1\>\/XI2\<0\>\/XI2\<1\>\/XI2\<0\>\/RR7_neg \
 ) R_1X_LL w=1e-07 l=1e-07   res=0.149966
XXI2\<0\>\/XI2\<1\>\/XI2\<1\>\/XI2\<0\>\/XI2\<1\>\/XI2\<0\>\/XI2\<1\>\/XI2\<0\>\/RR6 \
 (  \
 N_SEL6\<1\>_XI2\<0\>\/XI2\<1\>\/XI2\<1\>\/XI2\<0\>\/XI2\<1\>\/XI2\<0\>\/XI2\<1\>\/XI2\<0\>\/RR6_pos \
 N_WLSEL\<854\>_XI2\<0\>\/XI2\<1\>\/XI2\<1\>\/XI2\<0\>\/XI2\<1\>\/XI2\<0\>\/XI2\<1\>\/XI2\<0\>\/RR6_neg \
 ) R_1X_LL w=1e-07 l=1e-07   res=0.149966
XXI2\<0\>\/XI2\<1\>\/XI2\<1\>\/XI2\<0\>\/XI2\<1\>\/XI2\<0\>\/XI2\<1\>\/XI2\<0\>\/RR5 \
 (  \
 N_SEL7\<0\>_XI2\<0\>\/XI2\<1\>\/XI2\<1\>\/XI2\<0\>\/XI2\<1\>\/XI2\<0\>\/XI2\<1\>\/XI2\<0\>\/RR5_pos \
 N_WLSEL\<855\>_XI2\<0\>\/XI2\<1\>\/XI2\<1\>\/XI2\<0\>\/XI2\<1\>\/XI2\<0\>\/XI2\<1\>\/XI2\<0\>\/RR5_neg \
 ) R_1X_LL w=1e-07 l=1e-07   res=0.149966
XXI2\<0\>\/XI2\<1\>\/XI2\<1\>\/XI2\<0\>\/XI2\<1\>\/XI2\<0\>\/XI2\<1\>\/XI2\<1\>\/RR0 \
 (  \
 N_SEL0\<1\>_XI2\<0\>\/XI2\<1\>\/XI2\<1\>\/XI2\<0\>\/XI2\<1\>\/XI2\<0\>\/XI2\<1\>\/XI2\<1\>\/RR0_pos \
 N_WLSEL\<856\>_XI2\<0\>\/XI2\<1\>\/XI2\<1\>\/XI2\<0\>\/XI2\<1\>\/XI2\<0\>\/XI2\<1\>\/XI2\<1\>\/RR0_neg \
 ) R_1X_LL w=1e-07 l=1e-07   res=0.149966
XXI2\<0\>\/XI2\<1\>\/XI2\<1\>\/XI2\<0\>\/XI2\<1\>\/XI2\<0\>\/XI2\<1\>\/XI2\<1\>\/RR1 \
 (  \
 N_SEL1\<1\>_XI2\<0\>\/XI2\<1\>\/XI2\<1\>\/XI2\<0\>\/XI2\<1\>\/XI2\<0\>\/XI2\<1\>\/XI2\<1\>\/RR1_pos \
 N_WLSEL\<857\>_XI2\<0\>\/XI2\<1\>\/XI2\<1\>\/XI2\<0\>\/XI2\<1\>\/XI2\<0\>\/XI2\<1\>\/XI2\<1\>\/RR1_neg \
 ) R_1X_LL w=1e-07 l=1e-07   res=0.149966
XXI2\<0\>\/XI2\<1\>\/XI2\<1\>\/XI2\<0\>\/XI2\<1\>\/XI2\<0\>\/XI2\<1\>\/XI2\<1\>\/RR2 \
 (  \
 N_SEL2\<0\>_XI2\<0\>\/XI2\<1\>\/XI2\<1\>\/XI2\<0\>\/XI2\<1\>\/XI2\<0\>\/XI2\<1\>\/XI2\<1\>\/RR2_pos \
 N_WLSEL\<858\>_XI2\<0\>\/XI2\<1\>\/XI2\<1\>\/XI2\<0\>\/XI2\<1\>\/XI2\<0\>\/XI2\<1\>\/XI2\<1\>\/RR2_neg \
 ) R_1X_LL w=1e-07 l=1e-07   res=0.149966
XXI2\<0\>\/XI2\<1\>\/XI2\<1\>\/XI2\<0\>\/XI2\<1\>\/XI2\<0\>\/XI2\<1\>\/XI2\<1\>\/RR3 \
 (  \
 N_SEL3\<1\>_XI2\<0\>\/XI2\<1\>\/XI2\<1\>\/XI2\<0\>\/XI2\<1\>\/XI2\<0\>\/XI2\<1\>\/XI2\<1\>\/RR3_pos \
 N_WLSEL\<859\>_XI2\<0\>\/XI2\<1\>\/XI2\<1\>\/XI2\<0\>\/XI2\<1\>\/XI2\<0\>\/XI2\<1\>\/XI2\<1\>\/RR3_neg \
 ) R_1X_LL w=1e-07 l=1e-07   res=0.149966
XXI2\<0\>\/XI2\<1\>\/XI2\<1\>\/XI2\<0\>\/XI2\<1\>\/XI2\<0\>\/XI2\<1\>\/XI2\<1\>\/RR4 \
 (  \
 N_SEL4\<0\>_XI2\<0\>\/XI2\<1\>\/XI2\<1\>\/XI2\<0\>\/XI2\<1\>\/XI2\<0\>\/XI2\<1\>\/XI2\<1\>\/RR4_pos \
 N_WLSEL\<860\>_XI2\<0\>\/XI2\<1\>\/XI2\<1\>\/XI2\<0\>\/XI2\<1\>\/XI2\<0\>\/XI2\<1\>\/XI2\<1\>\/RR4_neg \
 ) R_1X_LL w=1e-07 l=1e-07   res=0.149966
XXI2\<0\>\/XI2\<1\>\/XI2\<1\>\/XI2\<0\>\/XI2\<1\>\/XI2\<0\>\/XI2\<1\>\/XI2\<1\>\/RR7 \
 (  \
 N_SEL5\<1\>_XI2\<0\>\/XI2\<1\>\/XI2\<1\>\/XI2\<0\>\/XI2\<1\>\/XI2\<0\>\/XI2\<1\>\/XI2\<1\>\/RR7_pos \
 N_WLSEL\<861\>_XI2\<0\>\/XI2\<1\>\/XI2\<1\>\/XI2\<0\>\/XI2\<1\>\/XI2\<0\>\/XI2\<1\>\/XI2\<1\>\/RR7_neg \
 ) R_1X_LL w=1e-07 l=1e-07   res=0.149966
XXI2\<0\>\/XI2\<1\>\/XI2\<1\>\/XI2\<0\>\/XI2\<1\>\/XI2\<0\>\/XI2\<1\>\/XI2\<1\>\/RR6 \
 (  \
 N_SEL6\<1\>_XI2\<0\>\/XI2\<1\>\/XI2\<1\>\/XI2\<0\>\/XI2\<1\>\/XI2\<0\>\/XI2\<1\>\/XI2\<1\>\/RR6_pos \
 N_WLSEL\<862\>_XI2\<0\>\/XI2\<1\>\/XI2\<1\>\/XI2\<0\>\/XI2\<1\>\/XI2\<0\>\/XI2\<1\>\/XI2\<1\>\/RR6_neg \
 ) R_1X_LL w=1e-07 l=1e-07   res=0.149966
XXI2\<0\>\/XI2\<0\>\/XI2\<1\>\/XI2\<0\>\/XI2\<0\>\/XI2\<0\>\/XI2\<0\>\/XI2\<1\>\/RR5 \
 (  \
 N_SEL7\<0\>_XI2\<0\>\/XI2\<0\>\/XI2\<1\>\/XI2\<0\>\/XI2\<0\>\/XI2\<0\>\/XI2\<0\>\/XI2\<1\>\/RR5_pos \
 N_WLSEL\<271\>_XI2\<0\>\/XI2\<0\>\/XI2\<1\>\/XI2\<0\>\/XI2\<0\>\/XI2\<0\>\/XI2\<0\>\/XI2\<1\>\/RR5_neg \
 ) R_1X_LL w=1e-07 l=1e-07   res=0.149966
XXI2\<0\>\/XI2\<0\>\/XI2\<1\>\/XI2\<0\>\/XI2\<0\>\/XI2\<0\>\/XI2\<1\>\/XI2\<0\>\/RR0 \
 (  \
 N_SEL0\<0\>_XI2\<0\>\/XI2\<0\>\/XI2\<1\>\/XI2\<0\>\/XI2\<0\>\/XI2\<0\>\/XI2\<1\>\/XI2\<0\>\/RR0_pos \
 N_WLSEL\<272\>_XI2\<0\>\/XI2\<0\>\/XI2\<1\>\/XI2\<0\>\/XI2\<0\>\/XI2\<0\>\/XI2\<1\>\/XI2\<0\>\/RR0_neg \
 ) R_1X_LL w=1e-07 l=1e-07   res=0.149966
XXI2\<0\>\/XI2\<0\>\/XI2\<1\>\/XI2\<0\>\/XI2\<0\>\/XI2\<0\>\/XI2\<1\>\/XI2\<0\>\/RR1 \
 (  \
 N_SEL1\<1\>_XI2\<0\>\/XI2\<0\>\/XI2\<1\>\/XI2\<0\>\/XI2\<0\>\/XI2\<0\>\/XI2\<1\>\/XI2\<0\>\/RR1_pos \
 N_WLSEL\<273\>_XI2\<0\>\/XI2\<0\>\/XI2\<1\>\/XI2\<0\>\/XI2\<0\>\/XI2\<0\>\/XI2\<1\>\/XI2\<0\>\/RR1_neg \
 ) R_1X_LL w=1e-07 l=1e-07   res=0.149966
XXI2\<0\>\/XI2\<0\>\/XI2\<1\>\/XI2\<0\>\/XI2\<0\>\/XI2\<0\>\/XI2\<1\>\/XI2\<0\>\/RR2 \
 (  \
 N_SEL2\<0\>_XI2\<0\>\/XI2\<0\>\/XI2\<1\>\/XI2\<0\>\/XI2\<0\>\/XI2\<0\>\/XI2\<1\>\/XI2\<0\>\/RR2_pos \
 N_WLSEL\<274\>_XI2\<0\>\/XI2\<0\>\/XI2\<1\>\/XI2\<0\>\/XI2\<0\>\/XI2\<0\>\/XI2\<1\>\/XI2\<0\>\/RR2_neg \
 ) R_1X_LL w=1e-07 l=1e-07   res=0.149966
XXI2\<0\>\/XI2\<0\>\/XI2\<1\>\/XI2\<0\>\/XI2\<0\>\/XI2\<0\>\/XI2\<1\>\/XI2\<0\>\/RR3 \
 (  \
 N_SEL3\<0\>_XI2\<0\>\/XI2\<0\>\/XI2\<1\>\/XI2\<0\>\/XI2\<0\>\/XI2\<0\>\/XI2\<1\>\/XI2\<0\>\/RR3_pos \
 N_WLSEL\<275\>_XI2\<0\>\/XI2\<0\>\/XI2\<1\>\/XI2\<0\>\/XI2\<0\>\/XI2\<0\>\/XI2\<1\>\/XI2\<0\>\/RR3_neg \
 ) R_1X_LL w=1e-07 l=1e-07   res=0.149966
XXI2\<0\>\/XI2\<0\>\/XI2\<1\>\/XI2\<0\>\/XI2\<0\>\/XI2\<0\>\/XI2\<1\>\/XI2\<0\>\/RR4 \
 (  \
 N_SEL4\<0\>_XI2\<0\>\/XI2\<0\>\/XI2\<1\>\/XI2\<0\>\/XI2\<0\>\/XI2\<0\>\/XI2\<1\>\/XI2\<0\>\/RR4_pos \
 N_WLSEL\<276\>_XI2\<0\>\/XI2\<0\>\/XI2\<1\>\/XI2\<0\>\/XI2\<0\>\/XI2\<0\>\/XI2\<1\>\/XI2\<0\>\/RR4_neg \
 ) R_1X_LL w=1e-07 l=1e-07   res=0.149966
XXI2\<0\>\/XI2\<0\>\/XI2\<1\>\/XI2\<0\>\/XI2\<0\>\/XI2\<0\>\/XI2\<1\>\/XI2\<0\>\/RR7 \
 (  \
 N_SEL5\<1\>_XI2\<0\>\/XI2\<0\>\/XI2\<1\>\/XI2\<0\>\/XI2\<0\>\/XI2\<0\>\/XI2\<1\>\/XI2\<0\>\/RR7_pos \
 N_WLSEL\<277\>_XI2\<0\>\/XI2\<0\>\/XI2\<1\>\/XI2\<0\>\/XI2\<0\>\/XI2\<0\>\/XI2\<1\>\/XI2\<0\>\/RR7_neg \
 ) R_1X_LL w=1e-07 l=1e-07   res=0.149966
XXI2\<0\>\/XI2\<0\>\/XI2\<1\>\/XI2\<0\>\/XI2\<0\>\/XI2\<0\>\/XI2\<1\>\/XI2\<0\>\/RR6 \
 (  \
 N_SEL6\<0\>_XI2\<0\>\/XI2\<0\>\/XI2\<1\>\/XI2\<0\>\/XI2\<0\>\/XI2\<0\>\/XI2\<1\>\/XI2\<0\>\/RR6_pos \
 N_WLSEL\<278\>_XI2\<0\>\/XI2\<0\>\/XI2\<1\>\/XI2\<0\>\/XI2\<0\>\/XI2\<0\>\/XI2\<1\>\/XI2\<0\>\/RR6_neg \
 ) R_1X_LL w=1e-07 l=1e-07   res=0.149966
XXI2\<0\>\/XI2\<0\>\/XI2\<1\>\/XI2\<0\>\/XI2\<0\>\/XI2\<0\>\/XI2\<1\>\/XI2\<0\>\/RR5 \
 (  \
 N_SEL7\<0\>_XI2\<0\>\/XI2\<0\>\/XI2\<1\>\/XI2\<0\>\/XI2\<0\>\/XI2\<0\>\/XI2\<1\>\/XI2\<0\>\/RR5_pos \
 N_WLSEL\<279\>_XI2\<0\>\/XI2\<0\>\/XI2\<1\>\/XI2\<0\>\/XI2\<0\>\/XI2\<0\>\/XI2\<1\>\/XI2\<0\>\/RR5_neg \
 ) R_1X_LL w=1e-07 l=1e-07   res=0.149966
XXI2\<0\>\/XI2\<0\>\/XI2\<1\>\/XI2\<0\>\/XI2\<0\>\/XI2\<0\>\/XI2\<1\>\/XI2\<1\>\/RR0 \
 (  \
 N_SEL0\<1\>_XI2\<0\>\/XI2\<0\>\/XI2\<1\>\/XI2\<0\>\/XI2\<0\>\/XI2\<0\>\/XI2\<1\>\/XI2\<1\>\/RR0_pos \
 N_WLSEL\<280\>_XI2\<0\>\/XI2\<0\>\/XI2\<1\>\/XI2\<0\>\/XI2\<0\>\/XI2\<0\>\/XI2\<1\>\/XI2\<1\>\/RR0_neg \
 ) R_1X_LL w=1e-07 l=1e-07   res=0.149966
XXI2\<0\>\/XI2\<0\>\/XI2\<1\>\/XI2\<0\>\/XI2\<0\>\/XI2\<0\>\/XI2\<1\>\/XI2\<1\>\/RR1 \
 (  \
 N_SEL1\<1\>_XI2\<0\>\/XI2\<0\>\/XI2\<1\>\/XI2\<0\>\/XI2\<0\>\/XI2\<0\>\/XI2\<1\>\/XI2\<1\>\/RR1_pos \
 N_WLSEL\<281\>_XI2\<0\>\/XI2\<0\>\/XI2\<1\>\/XI2\<0\>\/XI2\<0\>\/XI2\<0\>\/XI2\<1\>\/XI2\<1\>\/RR1_neg \
 ) R_1X_LL w=1e-07 l=1e-07   res=0.149966
XXI2\<0\>\/XI2\<0\>\/XI2\<1\>\/XI2\<0\>\/XI2\<0\>\/XI2\<0\>\/XI2\<1\>\/XI2\<1\>\/RR2 \
 (  \
 N_SEL2\<0\>_XI2\<0\>\/XI2\<0\>\/XI2\<1\>\/XI2\<0\>\/XI2\<0\>\/XI2\<0\>\/XI2\<1\>\/XI2\<1\>\/RR2_pos \
 N_WLSEL\<282\>_XI2\<0\>\/XI2\<0\>\/XI2\<1\>\/XI2\<0\>\/XI2\<0\>\/XI2\<0\>\/XI2\<1\>\/XI2\<1\>\/RR2_neg \
 ) R_1X_LL w=1e-07 l=1e-07   res=0.149966
XXI2\<0\>\/XI2\<0\>\/XI2\<1\>\/XI2\<0\>\/XI2\<0\>\/XI2\<0\>\/XI2\<1\>\/XI2\<1\>\/RR3 \
 (  \
 N_SEL3\<0\>_XI2\<0\>\/XI2\<0\>\/XI2\<1\>\/XI2\<0\>\/XI2\<0\>\/XI2\<0\>\/XI2\<1\>\/XI2\<1\>\/RR3_pos \
 N_WLSEL\<283\>_XI2\<0\>\/XI2\<0\>\/XI2\<1\>\/XI2\<0\>\/XI2\<0\>\/XI2\<0\>\/XI2\<1\>\/XI2\<1\>\/RR3_neg \
 ) R_1X_LL w=1e-07 l=1e-07   res=0.149966
XXI2\<0\>\/XI2\<0\>\/XI2\<1\>\/XI2\<0\>\/XI2\<0\>\/XI2\<0\>\/XI2\<1\>\/XI2\<1\>\/RR4 \
 (  \
 N_SEL4\<0\>_XI2\<0\>\/XI2\<0\>\/XI2\<1\>\/XI2\<0\>\/XI2\<0\>\/XI2\<0\>\/XI2\<1\>\/XI2\<1\>\/RR4_pos \
 N_WLSEL\<284\>_XI2\<0\>\/XI2\<0\>\/XI2\<1\>\/XI2\<0\>\/XI2\<0\>\/XI2\<0\>\/XI2\<1\>\/XI2\<1\>\/RR4_neg \
 ) R_1X_LL w=1e-07 l=1e-07   res=0.149966
XXI2\<0\>\/XI2\<0\>\/XI2\<1\>\/XI2\<0\>\/XI2\<0\>\/XI2\<0\>\/XI2\<1\>\/XI2\<1\>\/RR7 \
 (  \
 N_SEL5\<1\>_XI2\<0\>\/XI2\<0\>\/XI2\<1\>\/XI2\<0\>\/XI2\<0\>\/XI2\<0\>\/XI2\<1\>\/XI2\<1\>\/RR7_pos \
 N_WLSEL\<285\>_XI2\<0\>\/XI2\<0\>\/XI2\<1\>\/XI2\<0\>\/XI2\<0\>\/XI2\<0\>\/XI2\<1\>\/XI2\<1\>\/RR7_neg \
 ) R_1X_LL w=1e-07 l=1e-07   res=0.149966
XXI2\<0\>\/XI2\<0\>\/XI2\<1\>\/XI2\<0\>\/XI2\<0\>\/XI2\<0\>\/XI2\<1\>\/XI2\<1\>\/RR6 \
 (  \
 N_SEL6\<0\>_XI2\<0\>\/XI2\<0\>\/XI2\<1\>\/XI2\<0\>\/XI2\<0\>\/XI2\<0\>\/XI2\<1\>\/XI2\<1\>\/RR6_pos \
 N_WLSEL\<286\>_XI2\<0\>\/XI2\<0\>\/XI2\<1\>\/XI2\<0\>\/XI2\<0\>\/XI2\<0\>\/XI2\<1\>\/XI2\<1\>\/RR6_neg \
 ) R_1X_LL w=1e-07 l=1e-07   res=0.149966
XXI2\<0\>\/XI2\<0\>\/XI2\<1\>\/XI2\<0\>\/XI2\<0\>\/XI2\<0\>\/XI2\<1\>\/XI2\<1\>\/RR5 \
 (  \
 N_SEL7\<0\>_XI2\<0\>\/XI2\<0\>\/XI2\<1\>\/XI2\<0\>\/XI2\<0\>\/XI2\<0\>\/XI2\<1\>\/XI2\<1\>\/RR5_pos \
 N_WLSEL\<287\>_XI2\<0\>\/XI2\<0\>\/XI2\<1\>\/XI2\<0\>\/XI2\<0\>\/XI2\<0\>\/XI2\<1\>\/XI2\<1\>\/RR5_neg \
 ) R_1X_LL w=1e-07 l=1e-07   res=0.149966
XXI2\<0\>\/XI2\<0\>\/XI2\<1\>\/XI2\<0\>\/XI2\<0\>\/XI2\<1\>\/XI2\<0\>\/XI2\<0\>\/RR0 \
 (  \
 N_SEL0\<0\>_XI2\<0\>\/XI2\<0\>\/XI2\<1\>\/XI2\<0\>\/XI2\<0\>\/XI2\<1\>\/XI2\<0\>\/XI2\<0\>\/RR0_pos \
 N_WLSEL\<288\>_XI2\<0\>\/XI2\<0\>\/XI2\<1\>\/XI2\<0\>\/XI2\<0\>\/XI2\<1\>\/XI2\<0\>\/XI2\<0\>\/RR0_neg \
 ) R_1X_LL w=1e-07 l=1e-07   res=0.149966
XXI2\<0\>\/XI2\<0\>\/XI2\<1\>\/XI2\<0\>\/XI2\<0\>\/XI2\<1\>\/XI2\<0\>\/XI2\<0\>\/RR1 \
 (  \
 N_SEL1\<0\>_XI2\<0\>\/XI2\<0\>\/XI2\<1\>\/XI2\<0\>\/XI2\<0\>\/XI2\<1\>\/XI2\<0\>\/XI2\<0\>\/RR1_pos \
 N_WLSEL\<289\>_XI2\<0\>\/XI2\<0\>\/XI2\<1\>\/XI2\<0\>\/XI2\<0\>\/XI2\<1\>\/XI2\<0\>\/XI2\<0\>\/RR1_neg \
 ) R_1X_LL w=1e-07 l=1e-07   res=0.149966
XXI2\<0\>\/XI2\<0\>\/XI2\<1\>\/XI2\<0\>\/XI2\<0\>\/XI2\<1\>\/XI2\<0\>\/XI2\<0\>\/RR2 \
 (  \
 N_SEL2\<1\>_XI2\<0\>\/XI2\<0\>\/XI2\<1\>\/XI2\<0\>\/XI2\<0\>\/XI2\<1\>\/XI2\<0\>\/XI2\<0\>\/RR2_pos \
 N_WLSEL\<290\>_XI2\<0\>\/XI2\<0\>\/XI2\<1\>\/XI2\<0\>\/XI2\<0\>\/XI2\<1\>\/XI2\<0\>\/XI2\<0\>\/RR2_neg \
 ) R_1X_LL w=1e-07 l=1e-07   res=0.149966
XXI2\<0\>\/XI2\<0\>\/XI2\<1\>\/XI2\<0\>\/XI2\<0\>\/XI2\<1\>\/XI2\<0\>\/XI2\<0\>\/RR3 \
 (  \
 N_SEL3\<0\>_XI2\<0\>\/XI2\<0\>\/XI2\<1\>\/XI2\<0\>\/XI2\<0\>\/XI2\<1\>\/XI2\<0\>\/XI2\<0\>\/RR3_pos \
 N_WLSEL\<291\>_XI2\<0\>\/XI2\<0\>\/XI2\<1\>\/XI2\<0\>\/XI2\<0\>\/XI2\<1\>\/XI2\<0\>\/XI2\<0\>\/RR3_neg \
 ) R_1X_LL w=1e-07 l=1e-07   res=0.149966
XXI2\<0\>\/XI2\<0\>\/XI2\<1\>\/XI2\<0\>\/XI2\<0\>\/XI2\<1\>\/XI2\<0\>\/XI2\<0\>\/RR4 \
 (  \
 N_SEL4\<0\>_XI2\<0\>\/XI2\<0\>\/XI2\<1\>\/XI2\<0\>\/XI2\<0\>\/XI2\<1\>\/XI2\<0\>\/XI2\<0\>\/RR4_pos \
 N_WLSEL\<292\>_XI2\<0\>\/XI2\<0\>\/XI2\<1\>\/XI2\<0\>\/XI2\<0\>\/XI2\<1\>\/XI2\<0\>\/XI2\<0\>\/RR4_neg \
 ) R_1X_LL w=1e-07 l=1e-07   res=0.149966
XXI2\<0\>\/XI2\<0\>\/XI2\<1\>\/XI2\<0\>\/XI2\<0\>\/XI2\<1\>\/XI2\<0\>\/XI2\<0\>\/RR7 \
 (  \
 N_SEL5\<1\>_XI2\<0\>\/XI2\<0\>\/XI2\<1\>\/XI2\<0\>\/XI2\<0\>\/XI2\<1\>\/XI2\<0\>\/XI2\<0\>\/RR7_pos \
 N_WLSEL\<293\>_XI2\<0\>\/XI2\<0\>\/XI2\<1\>\/XI2\<0\>\/XI2\<0\>\/XI2\<1\>\/XI2\<0\>\/XI2\<0\>\/RR7_neg \
 ) R_1X_LL w=1e-07 l=1e-07   res=0.149966
XXI2\<0\>\/XI2\<0\>\/XI2\<1\>\/XI2\<0\>\/XI2\<0\>\/XI2\<1\>\/XI2\<0\>\/XI2\<0\>\/RR6 \
 (  \
 N_SEL6\<0\>_XI2\<0\>\/XI2\<0\>\/XI2\<1\>\/XI2\<0\>\/XI2\<0\>\/XI2\<1\>\/XI2\<0\>\/XI2\<0\>\/RR6_pos \
 N_WLSEL\<294\>_XI2\<0\>\/XI2\<0\>\/XI2\<1\>\/XI2\<0\>\/XI2\<0\>\/XI2\<1\>\/XI2\<0\>\/XI2\<0\>\/RR6_neg \
 ) R_1X_LL w=1e-07 l=1e-07   res=0.149966
XXI2\<0\>\/XI2\<0\>\/XI2\<1\>\/XI2\<0\>\/XI2\<0\>\/XI2\<1\>\/XI2\<0\>\/XI2\<0\>\/RR5 \
 (  \
 N_SEL7\<0\>_XI2\<0\>\/XI2\<0\>\/XI2\<1\>\/XI2\<0\>\/XI2\<0\>\/XI2\<1\>\/XI2\<0\>\/XI2\<0\>\/RR5_pos \
 N_WLSEL\<295\>_XI2\<0\>\/XI2\<0\>\/XI2\<1\>\/XI2\<0\>\/XI2\<0\>\/XI2\<1\>\/XI2\<0\>\/XI2\<0\>\/RR5_neg \
 ) R_1X_LL w=1e-07 l=1e-07   res=0.149966
XXI2\<0\>\/XI2\<0\>\/XI2\<1\>\/XI2\<0\>\/XI2\<0\>\/XI2\<1\>\/XI2\<0\>\/XI2\<1\>\/RR0 \
 (  \
 N_SEL0\<1\>_XI2\<0\>\/XI2\<0\>\/XI2\<1\>\/XI2\<0\>\/XI2\<0\>\/XI2\<1\>\/XI2\<0\>\/XI2\<1\>\/RR0_pos \
 N_WLSEL\<296\>_XI2\<0\>\/XI2\<0\>\/XI2\<1\>\/XI2\<0\>\/XI2\<0\>\/XI2\<1\>\/XI2\<0\>\/XI2\<1\>\/RR0_neg \
 ) R_1X_LL w=1e-07 l=1e-07   res=0.149966
XXI2\<0\>\/XI2\<0\>\/XI2\<1\>\/XI2\<0\>\/XI2\<0\>\/XI2\<1\>\/XI2\<0\>\/XI2\<1\>\/RR1 \
 (  \
 N_SEL1\<0\>_XI2\<0\>\/XI2\<0\>\/XI2\<1\>\/XI2\<0\>\/XI2\<0\>\/XI2\<1\>\/XI2\<0\>\/XI2\<1\>\/RR1_pos \
 N_WLSEL\<297\>_XI2\<0\>\/XI2\<0\>\/XI2\<1\>\/XI2\<0\>\/XI2\<0\>\/XI2\<1\>\/XI2\<0\>\/XI2\<1\>\/RR1_neg \
 ) R_1X_LL w=1e-07 l=1e-07   res=0.149966
XXI2\<0\>\/XI2\<0\>\/XI2\<1\>\/XI2\<0\>\/XI2\<0\>\/XI2\<1\>\/XI2\<0\>\/XI2\<1\>\/RR2 \
 (  \
 N_SEL2\<1\>_XI2\<0\>\/XI2\<0\>\/XI2\<1\>\/XI2\<0\>\/XI2\<0\>\/XI2\<1\>\/XI2\<0\>\/XI2\<1\>\/RR2_pos \
 N_WLSEL\<298\>_XI2\<0\>\/XI2\<0\>\/XI2\<1\>\/XI2\<0\>\/XI2\<0\>\/XI2\<1\>\/XI2\<0\>\/XI2\<1\>\/RR2_neg \
 ) R_1X_LL w=1e-07 l=1e-07   res=0.149966
XXI2\<0\>\/XI2\<0\>\/XI2\<1\>\/XI2\<0\>\/XI2\<0\>\/XI2\<1\>\/XI2\<0\>\/XI2\<1\>\/RR3 \
 (  \
 N_SEL3\<0\>_XI2\<0\>\/XI2\<0\>\/XI2\<1\>\/XI2\<0\>\/XI2\<0\>\/XI2\<1\>\/XI2\<0\>\/XI2\<1\>\/RR3_pos \
 N_WLSEL\<299\>_XI2\<0\>\/XI2\<0\>\/XI2\<1\>\/XI2\<0\>\/XI2\<0\>\/XI2\<1\>\/XI2\<0\>\/XI2\<1\>\/RR3_neg \
 ) R_1X_LL w=1e-07 l=1e-07   res=0.149966
XXI2\<0\>\/XI2\<0\>\/XI2\<1\>\/XI2\<0\>\/XI2\<0\>\/XI2\<1\>\/XI2\<0\>\/XI2\<1\>\/RR4 \
 (  \
 N_SEL4\<0\>_XI2\<0\>\/XI2\<0\>\/XI2\<1\>\/XI2\<0\>\/XI2\<0\>\/XI2\<1\>\/XI2\<0\>\/XI2\<1\>\/RR4_pos \
 N_WLSEL\<300\>_XI2\<0\>\/XI2\<0\>\/XI2\<1\>\/XI2\<0\>\/XI2\<0\>\/XI2\<1\>\/XI2\<0\>\/XI2\<1\>\/RR4_neg \
 ) R_1X_LL w=1e-07 l=1e-07   res=0.149966
XXI2\<0\>\/XI2\<0\>\/XI2\<1\>\/XI2\<0\>\/XI2\<0\>\/XI2\<1\>\/XI2\<0\>\/XI2\<1\>\/RR7 \
 (  \
 N_SEL5\<1\>_XI2\<0\>\/XI2\<0\>\/XI2\<1\>\/XI2\<0\>\/XI2\<0\>\/XI2\<1\>\/XI2\<0\>\/XI2\<1\>\/RR7_pos \
 N_WLSEL\<301\>_XI2\<0\>\/XI2\<0\>\/XI2\<1\>\/XI2\<0\>\/XI2\<0\>\/XI2\<1\>\/XI2\<0\>\/XI2\<1\>\/RR7_neg \
 ) R_1X_LL w=1e-07 l=1e-07   res=0.149966
XXI2\<0\>\/XI2\<0\>\/XI2\<1\>\/XI2\<0\>\/XI2\<0\>\/XI2\<1\>\/XI2\<0\>\/XI2\<1\>\/RR6 \
 (  \
 N_SEL6\<0\>_XI2\<0\>\/XI2\<0\>\/XI2\<1\>\/XI2\<0\>\/XI2\<0\>\/XI2\<1\>\/XI2\<0\>\/XI2\<1\>\/RR6_pos \
 N_WLSEL\<302\>_XI2\<0\>\/XI2\<0\>\/XI2\<1\>\/XI2\<0\>\/XI2\<0\>\/XI2\<1\>\/XI2\<0\>\/XI2\<1\>\/RR6_neg \
 ) R_1X_LL w=1e-07 l=1e-07   res=0.149966
XXI2\<0\>\/XI2\<0\>\/XI2\<1\>\/XI2\<0\>\/XI2\<0\>\/XI2\<1\>\/XI2\<0\>\/XI2\<1\>\/RR5 \
 (  \
 N_SEL7\<0\>_XI2\<0\>\/XI2\<0\>\/XI2\<1\>\/XI2\<0\>\/XI2\<0\>\/XI2\<1\>\/XI2\<0\>\/XI2\<1\>\/RR5_pos \
 N_WLSEL\<303\>_XI2\<0\>\/XI2\<0\>\/XI2\<1\>\/XI2\<0\>\/XI2\<0\>\/XI2\<1\>\/XI2\<0\>\/XI2\<1\>\/RR5_neg \
 ) R_1X_LL w=1e-07 l=1e-07   res=0.149966
XXI2\<0\>\/XI2\<0\>\/XI2\<1\>\/XI2\<0\>\/XI2\<0\>\/XI2\<1\>\/XI2\<1\>\/XI2\<0\>\/RR0 \
 (  \
 N_SEL0\<0\>_XI2\<0\>\/XI2\<0\>\/XI2\<1\>\/XI2\<0\>\/XI2\<0\>\/XI2\<1\>\/XI2\<1\>\/XI2\<0\>\/RR0_pos \
 N_WLSEL\<304\>_XI2\<0\>\/XI2\<0\>\/XI2\<1\>\/XI2\<0\>\/XI2\<0\>\/XI2\<1\>\/XI2\<1\>\/XI2\<0\>\/RR0_neg \
 ) R_1X_LL w=1e-07 l=1e-07   res=0.149966
XXI2\<0\>\/XI2\<0\>\/XI2\<1\>\/XI2\<0\>\/XI2\<0\>\/XI2\<1\>\/XI2\<1\>\/XI2\<0\>\/RR1 \
 (  \
 N_SEL1\<1\>_XI2\<0\>\/XI2\<0\>\/XI2\<1\>\/XI2\<0\>\/XI2\<0\>\/XI2\<1\>\/XI2\<1\>\/XI2\<0\>\/RR1_pos \
 N_WLSEL\<305\>_XI2\<0\>\/XI2\<0\>\/XI2\<1\>\/XI2\<0\>\/XI2\<0\>\/XI2\<1\>\/XI2\<1\>\/XI2\<0\>\/RR1_neg \
 ) R_1X_LL w=1e-07 l=1e-07   res=0.149966
XXI2\<0\>\/XI2\<0\>\/XI2\<1\>\/XI2\<0\>\/XI2\<0\>\/XI2\<1\>\/XI2\<1\>\/XI2\<0\>\/RR2 \
 (  \
 N_SEL2\<1\>_XI2\<0\>\/XI2\<0\>\/XI2\<1\>\/XI2\<0\>\/XI2\<0\>\/XI2\<1\>\/XI2\<1\>\/XI2\<0\>\/RR2_pos \
 N_WLSEL\<306\>_XI2\<0\>\/XI2\<0\>\/XI2\<1\>\/XI2\<0\>\/XI2\<0\>\/XI2\<1\>\/XI2\<1\>\/XI2\<0\>\/RR2_neg \
 ) R_1X_LL w=1e-07 l=1e-07   res=0.149966
XXI2\<0\>\/XI2\<0\>\/XI2\<1\>\/XI2\<0\>\/XI2\<0\>\/XI2\<1\>\/XI2\<1\>\/XI2\<0\>\/RR3 \
 (  \
 N_SEL3\<0\>_XI2\<0\>\/XI2\<0\>\/XI2\<1\>\/XI2\<0\>\/XI2\<0\>\/XI2\<1\>\/XI2\<1\>\/XI2\<0\>\/RR3_pos \
 N_WLSEL\<307\>_XI2\<0\>\/XI2\<0\>\/XI2\<1\>\/XI2\<0\>\/XI2\<0\>\/XI2\<1\>\/XI2\<1\>\/XI2\<0\>\/RR3_neg \
 ) R_1X_LL w=1e-07 l=1e-07   res=0.149966
XXI2\<0\>\/XI2\<0\>\/XI2\<1\>\/XI2\<0\>\/XI2\<0\>\/XI2\<1\>\/XI2\<1\>\/XI2\<0\>\/RR4 \
 (  \
 N_SEL4\<0\>_XI2\<0\>\/XI2\<0\>\/XI2\<1\>\/XI2\<0\>\/XI2\<0\>\/XI2\<1\>\/XI2\<1\>\/XI2\<0\>\/RR4_pos \
 N_WLSEL\<308\>_XI2\<0\>\/XI2\<0\>\/XI2\<1\>\/XI2\<0\>\/XI2\<0\>\/XI2\<1\>\/XI2\<1\>\/XI2\<0\>\/RR4_neg \
 ) R_1X_LL w=1e-07 l=1e-07   res=0.149966
XXI2\<0\>\/XI2\<0\>\/XI2\<1\>\/XI2\<0\>\/XI2\<0\>\/XI2\<1\>\/XI2\<1\>\/XI2\<0\>\/RR7 \
 (  \
 N_SEL5\<1\>_XI2\<0\>\/XI2\<0\>\/XI2\<1\>\/XI2\<0\>\/XI2\<0\>\/XI2\<1\>\/XI2\<1\>\/XI2\<0\>\/RR7_pos \
 N_WLSEL\<309\>_XI2\<0\>\/XI2\<0\>\/XI2\<1\>\/XI2\<0\>\/XI2\<0\>\/XI2\<1\>\/XI2\<1\>\/XI2\<0\>\/RR7_neg \
 ) R_1X_LL w=1e-07 l=1e-07   res=0.149966
XXI2\<0\>\/XI2\<0\>\/XI2\<1\>\/XI2\<0\>\/XI2\<0\>\/XI2\<1\>\/XI2\<1\>\/XI2\<0\>\/RR6 \
 (  \
 N_SEL6\<0\>_XI2\<0\>\/XI2\<0\>\/XI2\<1\>\/XI2\<0\>\/XI2\<0\>\/XI2\<1\>\/XI2\<1\>\/XI2\<0\>\/RR6_pos \
 N_WLSEL\<310\>_XI2\<0\>\/XI2\<0\>\/XI2\<1\>\/XI2\<0\>\/XI2\<0\>\/XI2\<1\>\/XI2\<1\>\/XI2\<0\>\/RR6_neg \
 ) R_1X_LL w=1e-07 l=1e-07   res=0.149966
XXI2\<0\>\/XI2\<0\>\/XI2\<1\>\/XI2\<0\>\/XI2\<0\>\/XI2\<1\>\/XI2\<1\>\/XI2\<0\>\/RR5 \
 (  \
 N_SEL7\<0\>_XI2\<0\>\/XI2\<0\>\/XI2\<1\>\/XI2\<0\>\/XI2\<0\>\/XI2\<1\>\/XI2\<1\>\/XI2\<0\>\/RR5_pos \
 N_WLSEL\<311\>_XI2\<0\>\/XI2\<0\>\/XI2\<1\>\/XI2\<0\>\/XI2\<0\>\/XI2\<1\>\/XI2\<1\>\/XI2\<0\>\/RR5_neg \
 ) R_1X_LL w=1e-07 l=1e-07   res=0.149966
XXI2\<0\>\/XI2\<0\>\/XI2\<1\>\/XI2\<0\>\/XI2\<0\>\/XI2\<1\>\/XI2\<1\>\/XI2\<1\>\/RR0 \
 (  \
 N_SEL0\<1\>_XI2\<0\>\/XI2\<0\>\/XI2\<1\>\/XI2\<0\>\/XI2\<0\>\/XI2\<1\>\/XI2\<1\>\/XI2\<1\>\/RR0_pos \
 N_WLSEL\<312\>_XI2\<0\>\/XI2\<0\>\/XI2\<1\>\/XI2\<0\>\/XI2\<0\>\/XI2\<1\>\/XI2\<1\>\/XI2\<1\>\/RR0_neg \
 ) R_1X_LL w=1e-07 l=1e-07   res=0.149966
XXI2\<0\>\/XI2\<0\>\/XI2\<1\>\/XI2\<0\>\/XI2\<0\>\/XI2\<1\>\/XI2\<1\>\/XI2\<1\>\/RR1 \
 (  \
 N_SEL1\<1\>_XI2\<0\>\/XI2\<0\>\/XI2\<1\>\/XI2\<0\>\/XI2\<0\>\/XI2\<1\>\/XI2\<1\>\/XI2\<1\>\/RR1_pos \
 N_WLSEL\<313\>_XI2\<0\>\/XI2\<0\>\/XI2\<1\>\/XI2\<0\>\/XI2\<0\>\/XI2\<1\>\/XI2\<1\>\/XI2\<1\>\/RR1_neg \
 ) R_1X_LL w=1e-07 l=1e-07   res=0.149966
XXI2\<0\>\/XI2\<0\>\/XI2\<1\>\/XI2\<0\>\/XI2\<0\>\/XI2\<1\>\/XI2\<1\>\/XI2\<1\>\/RR2 \
 (  \
 N_SEL2\<1\>_XI2\<0\>\/XI2\<0\>\/XI2\<1\>\/XI2\<0\>\/XI2\<0\>\/XI2\<1\>\/XI2\<1\>\/XI2\<1\>\/RR2_pos \
 N_WLSEL\<314\>_XI2\<0\>\/XI2\<0\>\/XI2\<1\>\/XI2\<0\>\/XI2\<0\>\/XI2\<1\>\/XI2\<1\>\/XI2\<1\>\/RR2_neg \
 ) R_1X_LL w=1e-07 l=1e-07   res=0.149966
XXI2\<0\>\/XI2\<0\>\/XI2\<1\>\/XI2\<0\>\/XI2\<0\>\/XI2\<1\>\/XI2\<1\>\/XI2\<1\>\/RR3 \
 (  \
 N_SEL3\<0\>_XI2\<0\>\/XI2\<0\>\/XI2\<1\>\/XI2\<0\>\/XI2\<0\>\/XI2\<1\>\/XI2\<1\>\/XI2\<1\>\/RR3_pos \
 N_WLSEL\<315\>_XI2\<0\>\/XI2\<0\>\/XI2\<1\>\/XI2\<0\>\/XI2\<0\>\/XI2\<1\>\/XI2\<1\>\/XI2\<1\>\/RR3_neg \
 ) R_1X_LL w=1e-07 l=1e-07   res=0.149966
XXI2\<0\>\/XI2\<0\>\/XI2\<1\>\/XI2\<0\>\/XI2\<0\>\/XI2\<1\>\/XI2\<1\>\/XI2\<1\>\/RR4 \
 (  \
 N_SEL4\<0\>_XI2\<0\>\/XI2\<0\>\/XI2\<1\>\/XI2\<0\>\/XI2\<0\>\/XI2\<1\>\/XI2\<1\>\/XI2\<1\>\/RR4_pos \
 N_WLSEL\<316\>_XI2\<0\>\/XI2\<0\>\/XI2\<1\>\/XI2\<0\>\/XI2\<0\>\/XI2\<1\>\/XI2\<1\>\/XI2\<1\>\/RR4_neg \
 ) R_1X_LL w=1e-07 l=1e-07   res=0.149966
XXI2\<0\>\/XI2\<0\>\/XI2\<1\>\/XI2\<0\>\/XI2\<0\>\/XI2\<1\>\/XI2\<1\>\/XI2\<1\>\/RR7 \
 (  \
 N_SEL5\<1\>_XI2\<0\>\/XI2\<0\>\/XI2\<1\>\/XI2\<0\>\/XI2\<0\>\/XI2\<1\>\/XI2\<1\>\/XI2\<1\>\/RR7_pos \
 N_WLSEL\<317\>_XI2\<0\>\/XI2\<0\>\/XI2\<1\>\/XI2\<0\>\/XI2\<0\>\/XI2\<1\>\/XI2\<1\>\/XI2\<1\>\/RR7_neg \
 ) R_1X_LL w=1e-07 l=1e-07   res=0.149966
XXI2\<0\>\/XI2\<0\>\/XI2\<1\>\/XI2\<0\>\/XI2\<0\>\/XI2\<1\>\/XI2\<1\>\/XI2\<1\>\/RR6 \
 (  \
 N_SEL6\<0\>_XI2\<0\>\/XI2\<0\>\/XI2\<1\>\/XI2\<0\>\/XI2\<0\>\/XI2\<1\>\/XI2\<1\>\/XI2\<1\>\/RR6_pos \
 N_WLSEL\<318\>_XI2\<0\>\/XI2\<0\>\/XI2\<1\>\/XI2\<0\>\/XI2\<0\>\/XI2\<1\>\/XI2\<1\>\/XI2\<1\>\/RR6_neg \
 ) R_1X_LL w=1e-07 l=1e-07   res=0.149966
XXI2\<0\>\/XI2\<0\>\/XI2\<1\>\/XI2\<0\>\/XI2\<0\>\/XI2\<1\>\/XI2\<1\>\/XI2\<1\>\/RR5 \
 (  \
 N_SEL7\<0\>_XI2\<0\>\/XI2\<0\>\/XI2\<1\>\/XI2\<0\>\/XI2\<0\>\/XI2\<1\>\/XI2\<1\>\/XI2\<1\>\/RR5_pos \
 N_WLSEL\<319\>_XI2\<0\>\/XI2\<0\>\/XI2\<1\>\/XI2\<0\>\/XI2\<0\>\/XI2\<1\>\/XI2\<1\>\/XI2\<1\>\/RR5_neg \
 ) R_1X_LL w=1e-07 l=1e-07   res=0.149966
XXI2\<0\>\/XI2\<0\>\/XI2\<1\>\/XI2\<0\>\/XI2\<1\>\/XI2\<0\>\/XI2\<0\>\/XI2\<0\>\/RR0 \
 (  \
 N_SEL0\<0\>_XI2\<0\>\/XI2\<0\>\/XI2\<1\>\/XI2\<0\>\/XI2\<1\>\/XI2\<0\>\/XI2\<0\>\/XI2\<0\>\/RR0_pos \
 N_WLSEL\<320\>_XI2\<0\>\/XI2\<0\>\/XI2\<1\>\/XI2\<0\>\/XI2\<1\>\/XI2\<0\>\/XI2\<0\>\/XI2\<0\>\/RR0_neg \
 ) R_1X_LL w=1e-07 l=1e-07   res=0.149966
XXI2\<0\>\/XI2\<0\>\/XI2\<1\>\/XI2\<0\>\/XI2\<1\>\/XI2\<0\>\/XI2\<0\>\/XI2\<0\>\/RR1 \
 (  \
 N_SEL1\<0\>_XI2\<0\>\/XI2\<0\>\/XI2\<1\>\/XI2\<0\>\/XI2\<1\>\/XI2\<0\>\/XI2\<0\>\/XI2\<0\>\/RR1_pos \
 N_WLSEL\<321\>_XI2\<0\>\/XI2\<0\>\/XI2\<1\>\/XI2\<0\>\/XI2\<1\>\/XI2\<0\>\/XI2\<0\>\/XI2\<0\>\/RR1_neg \
 ) R_1X_LL w=1e-07 l=1e-07   res=0.149966
XXI2\<0\>\/XI2\<0\>\/XI2\<1\>\/XI2\<0\>\/XI2\<1\>\/XI2\<0\>\/XI2\<0\>\/XI2\<0\>\/RR2 \
 (  \
 N_SEL2\<0\>_XI2\<0\>\/XI2\<0\>\/XI2\<1\>\/XI2\<0\>\/XI2\<1\>\/XI2\<0\>\/XI2\<0\>\/XI2\<0\>\/RR2_pos \
 N_WLSEL\<322\>_XI2\<0\>\/XI2\<0\>\/XI2\<1\>\/XI2\<0\>\/XI2\<1\>\/XI2\<0\>\/XI2\<0\>\/XI2\<0\>\/RR2_neg \
 ) R_1X_LL w=1e-07 l=1e-07   res=0.149966
XXI2\<0\>\/XI2\<0\>\/XI2\<1\>\/XI2\<0\>\/XI2\<1\>\/XI2\<0\>\/XI2\<0\>\/XI2\<0\>\/RR3 \
 (  \
 N_SEL3\<1\>_XI2\<0\>\/XI2\<0\>\/XI2\<1\>\/XI2\<0\>\/XI2\<1\>\/XI2\<0\>\/XI2\<0\>\/XI2\<0\>\/RR3_pos \
 N_WLSEL\<323\>_XI2\<0\>\/XI2\<0\>\/XI2\<1\>\/XI2\<0\>\/XI2\<1\>\/XI2\<0\>\/XI2\<0\>\/XI2\<0\>\/RR3_neg \
 ) R_1X_LL w=1e-07 l=1e-07   res=0.149966
XXI2\<0\>\/XI2\<0\>\/XI2\<1\>\/XI2\<0\>\/XI2\<1\>\/XI2\<0\>\/XI2\<0\>\/XI2\<0\>\/RR4 \
 (  \
 N_SEL4\<0\>_XI2\<0\>\/XI2\<0\>\/XI2\<1\>\/XI2\<0\>\/XI2\<1\>\/XI2\<0\>\/XI2\<0\>\/XI2\<0\>\/RR4_pos \
 N_WLSEL\<324\>_XI2\<0\>\/XI2\<0\>\/XI2\<1\>\/XI2\<0\>\/XI2\<1\>\/XI2\<0\>\/XI2\<0\>\/XI2\<0\>\/RR4_neg \
 ) R_1X_LL w=1e-07 l=1e-07   res=0.149966
XXI2\<0\>\/XI2\<0\>\/XI2\<1\>\/XI2\<0\>\/XI2\<1\>\/XI2\<0\>\/XI2\<0\>\/XI2\<0\>\/RR7 \
 (  \
 N_SEL5\<1\>_XI2\<0\>\/XI2\<0\>\/XI2\<1\>\/XI2\<0\>\/XI2\<1\>\/XI2\<0\>\/XI2\<0\>\/XI2\<0\>\/RR7_pos \
 N_WLSEL\<325\>_XI2\<0\>\/XI2\<0\>\/XI2\<1\>\/XI2\<0\>\/XI2\<1\>\/XI2\<0\>\/XI2\<0\>\/XI2\<0\>\/RR7_neg \
 ) R_1X_LL w=1e-07 l=1e-07   res=0.149966
XXI2\<0\>\/XI2\<0\>\/XI2\<1\>\/XI2\<0\>\/XI2\<1\>\/XI2\<0\>\/XI2\<0\>\/XI2\<0\>\/RR6 \
 (  \
 N_SEL6\<0\>_XI2\<0\>\/XI2\<0\>\/XI2\<1\>\/XI2\<0\>\/XI2\<1\>\/XI2\<0\>\/XI2\<0\>\/XI2\<0\>\/RR6_pos \
 N_WLSEL\<326\>_XI2\<0\>\/XI2\<0\>\/XI2\<1\>\/XI2\<0\>\/XI2\<1\>\/XI2\<0\>\/XI2\<0\>\/XI2\<0\>\/RR6_neg \
 ) R_1X_LL w=1e-07 l=1e-07   res=0.149966
XXI2\<0\>\/XI2\<0\>\/XI2\<1\>\/XI2\<0\>\/XI2\<1\>\/XI2\<0\>\/XI2\<0\>\/XI2\<0\>\/RR5 \
 (  \
 N_SEL7\<0\>_XI2\<0\>\/XI2\<0\>\/XI2\<1\>\/XI2\<0\>\/XI2\<1\>\/XI2\<0\>\/XI2\<0\>\/XI2\<0\>\/RR5_pos \
 N_WLSEL\<327\>_XI2\<0\>\/XI2\<0\>\/XI2\<1\>\/XI2\<0\>\/XI2\<1\>\/XI2\<0\>\/XI2\<0\>\/XI2\<0\>\/RR5_neg \
 ) R_1X_LL w=1e-07 l=1e-07   res=0.149966
XXI2\<0\>\/XI2\<0\>\/XI2\<1\>\/XI2\<0\>\/XI2\<1\>\/XI2\<0\>\/XI2\<0\>\/XI2\<1\>\/RR0 \
 (  \
 N_SEL0\<1\>_XI2\<0\>\/XI2\<0\>\/XI2\<1\>\/XI2\<0\>\/XI2\<1\>\/XI2\<0\>\/XI2\<0\>\/XI2\<1\>\/RR0_pos \
 N_WLSEL\<328\>_XI2\<0\>\/XI2\<0\>\/XI2\<1\>\/XI2\<0\>\/XI2\<1\>\/XI2\<0\>\/XI2\<0\>\/XI2\<1\>\/RR0_neg \
 ) R_1X_LL w=1e-07 l=1e-07   res=0.149966
XXI2\<0\>\/XI2\<0\>\/XI2\<1\>\/XI2\<0\>\/XI2\<1\>\/XI2\<0\>\/XI2\<0\>\/XI2\<1\>\/RR1 \
 (  \
 N_SEL1\<0\>_XI2\<0\>\/XI2\<0\>\/XI2\<1\>\/XI2\<0\>\/XI2\<1\>\/XI2\<0\>\/XI2\<0\>\/XI2\<1\>\/RR1_pos \
 N_WLSEL\<329\>_XI2\<0\>\/XI2\<0\>\/XI2\<1\>\/XI2\<0\>\/XI2\<1\>\/XI2\<0\>\/XI2\<0\>\/XI2\<1\>\/RR1_neg \
 ) R_1X_LL w=1e-07 l=1e-07   res=0.149966
XXI2\<0\>\/XI2\<0\>\/XI2\<1\>\/XI2\<0\>\/XI2\<1\>\/XI2\<0\>\/XI2\<0\>\/XI2\<1\>\/RR2 \
 (  \
 N_SEL2\<0\>_XI2\<0\>\/XI2\<0\>\/XI2\<1\>\/XI2\<0\>\/XI2\<1\>\/XI2\<0\>\/XI2\<0\>\/XI2\<1\>\/RR2_pos \
 N_WLSEL\<330\>_XI2\<0\>\/XI2\<0\>\/XI2\<1\>\/XI2\<0\>\/XI2\<1\>\/XI2\<0\>\/XI2\<0\>\/XI2\<1\>\/RR2_neg \
 ) R_1X_LL w=1e-07 l=1e-07   res=0.149966
XXI2\<0\>\/XI2\<0\>\/XI2\<1\>\/XI2\<0\>\/XI2\<1\>\/XI2\<0\>\/XI2\<0\>\/XI2\<1\>\/RR3 \
 (  \
 N_SEL3\<1\>_XI2\<0\>\/XI2\<0\>\/XI2\<1\>\/XI2\<0\>\/XI2\<1\>\/XI2\<0\>\/XI2\<0\>\/XI2\<1\>\/RR3_pos \
 N_WLSEL\<331\>_XI2\<0\>\/XI2\<0\>\/XI2\<1\>\/XI2\<0\>\/XI2\<1\>\/XI2\<0\>\/XI2\<0\>\/XI2\<1\>\/RR3_neg \
 ) R_1X_LL w=1e-07 l=1e-07   res=0.149966
XXI2\<0\>\/XI2\<0\>\/XI2\<1\>\/XI2\<0\>\/XI2\<1\>\/XI2\<0\>\/XI2\<0\>\/XI2\<1\>\/RR4 \
 (  \
 N_SEL4\<0\>_XI2\<0\>\/XI2\<0\>\/XI2\<1\>\/XI2\<0\>\/XI2\<1\>\/XI2\<0\>\/XI2\<0\>\/XI2\<1\>\/RR4_pos \
 N_WLSEL\<332\>_XI2\<0\>\/XI2\<0\>\/XI2\<1\>\/XI2\<0\>\/XI2\<1\>\/XI2\<0\>\/XI2\<0\>\/XI2\<1\>\/RR4_neg \
 ) R_1X_LL w=1e-07 l=1e-07   res=0.149966
XXI2\<0\>\/XI2\<0\>\/XI2\<1\>\/XI2\<0\>\/XI2\<1\>\/XI2\<0\>\/XI2\<0\>\/XI2\<1\>\/RR7 \
 (  \
 N_SEL5\<1\>_XI2\<0\>\/XI2\<0\>\/XI2\<1\>\/XI2\<0\>\/XI2\<1\>\/XI2\<0\>\/XI2\<0\>\/XI2\<1\>\/RR7_pos \
 N_WLSEL\<333\>_XI2\<0\>\/XI2\<0\>\/XI2\<1\>\/XI2\<0\>\/XI2\<1\>\/XI2\<0\>\/XI2\<0\>\/XI2\<1\>\/RR7_neg \
 ) R_1X_LL w=1e-07 l=1e-07   res=0.149966
XXI2\<0\>\/XI2\<0\>\/XI2\<1\>\/XI2\<0\>\/XI2\<1\>\/XI2\<0\>\/XI2\<0\>\/XI2\<1\>\/RR6 \
 (  \
 N_SEL6\<0\>_XI2\<0\>\/XI2\<0\>\/XI2\<1\>\/XI2\<0\>\/XI2\<1\>\/XI2\<0\>\/XI2\<0\>\/XI2\<1\>\/RR6_pos \
 N_WLSEL\<334\>_XI2\<0\>\/XI2\<0\>\/XI2\<1\>\/XI2\<0\>\/XI2\<1\>\/XI2\<0\>\/XI2\<0\>\/XI2\<1\>\/RR6_neg \
 ) R_1X_LL w=1e-07 l=1e-07   res=0.149966
XXI2\<0\>\/XI2\<0\>\/XI2\<1\>\/XI2\<0\>\/XI2\<1\>\/XI2\<0\>\/XI2\<0\>\/XI2\<1\>\/RR5 \
 (  \
 N_SEL7\<0\>_XI2\<0\>\/XI2\<0\>\/XI2\<1\>\/XI2\<0\>\/XI2\<1\>\/XI2\<0\>\/XI2\<0\>\/XI2\<1\>\/RR5_pos \
 N_WLSEL\<335\>_XI2\<0\>\/XI2\<0\>\/XI2\<1\>\/XI2\<0\>\/XI2\<1\>\/XI2\<0\>\/XI2\<0\>\/XI2\<1\>\/RR5_neg \
 ) R_1X_LL w=1e-07 l=1e-07   res=0.149966
XXI2\<0\>\/XI2\<0\>\/XI2\<1\>\/XI2\<0\>\/XI2\<1\>\/XI2\<0\>\/XI2\<1\>\/XI2\<0\>\/RR0 \
 (  \
 N_SEL0\<0\>_XI2\<0\>\/XI2\<0\>\/XI2\<1\>\/XI2\<0\>\/XI2\<1\>\/XI2\<0\>\/XI2\<1\>\/XI2\<0\>\/RR0_pos \
 N_WLSEL\<336\>_XI2\<0\>\/XI2\<0\>\/XI2\<1\>\/XI2\<0\>\/XI2\<1\>\/XI2\<0\>\/XI2\<1\>\/XI2\<0\>\/RR0_neg \
 ) R_1X_LL w=1e-07 l=1e-07   res=0.149966
XXI2\<0\>\/XI2\<0\>\/XI2\<1\>\/XI2\<0\>\/XI2\<1\>\/XI2\<0\>\/XI2\<1\>\/XI2\<0\>\/RR1 \
 (  \
 N_SEL1\<1\>_XI2\<0\>\/XI2\<0\>\/XI2\<1\>\/XI2\<0\>\/XI2\<1\>\/XI2\<0\>\/XI2\<1\>\/XI2\<0\>\/RR1_pos \
 N_WLSEL\<337\>_XI2\<0\>\/XI2\<0\>\/XI2\<1\>\/XI2\<0\>\/XI2\<1\>\/XI2\<0\>\/XI2\<1\>\/XI2\<0\>\/RR1_neg \
 ) R_1X_LL w=1e-07 l=1e-07   res=0.149966
XXI2\<0\>\/XI2\<0\>\/XI2\<1\>\/XI2\<0\>\/XI2\<1\>\/XI2\<0\>\/XI2\<1\>\/XI2\<0\>\/RR2 \
 (  \
 N_SEL2\<0\>_XI2\<0\>\/XI2\<0\>\/XI2\<1\>\/XI2\<0\>\/XI2\<1\>\/XI2\<0\>\/XI2\<1\>\/XI2\<0\>\/RR2_pos \
 N_WLSEL\<338\>_XI2\<0\>\/XI2\<0\>\/XI2\<1\>\/XI2\<0\>\/XI2\<1\>\/XI2\<0\>\/XI2\<1\>\/XI2\<0\>\/RR2_neg \
 ) R_1X_LL w=1e-07 l=1e-07   res=0.149966
XXI2\<0\>\/XI2\<0\>\/XI2\<1\>\/XI2\<0\>\/XI2\<1\>\/XI2\<0\>\/XI2\<1\>\/XI2\<0\>\/RR3 \
 (  \
 N_SEL3\<1\>_XI2\<0\>\/XI2\<0\>\/XI2\<1\>\/XI2\<0\>\/XI2\<1\>\/XI2\<0\>\/XI2\<1\>\/XI2\<0\>\/RR3_pos \
 N_WLSEL\<339\>_XI2\<0\>\/XI2\<0\>\/XI2\<1\>\/XI2\<0\>\/XI2\<1\>\/XI2\<0\>\/XI2\<1\>\/XI2\<0\>\/RR3_neg \
 ) R_1X_LL w=1e-07 l=1e-07   res=0.149966
XXI2\<0\>\/XI2\<0\>\/XI2\<1\>\/XI2\<0\>\/XI2\<1\>\/XI2\<0\>\/XI2\<1\>\/XI2\<0\>\/RR4 \
 (  \
 N_SEL4\<0\>_XI2\<0\>\/XI2\<0\>\/XI2\<1\>\/XI2\<0\>\/XI2\<1\>\/XI2\<0\>\/XI2\<1\>\/XI2\<0\>\/RR4_pos \
 N_WLSEL\<340\>_XI2\<0\>\/XI2\<0\>\/XI2\<1\>\/XI2\<0\>\/XI2\<1\>\/XI2\<0\>\/XI2\<1\>\/XI2\<0\>\/RR4_neg \
 ) R_1X_LL w=1e-07 l=1e-07   res=0.149966
XXI2\<0\>\/XI2\<0\>\/XI2\<1\>\/XI2\<0\>\/XI2\<1\>\/XI2\<0\>\/XI2\<1\>\/XI2\<0\>\/RR7 \
 (  \
 N_SEL5\<1\>_XI2\<0\>\/XI2\<0\>\/XI2\<1\>\/XI2\<0\>\/XI2\<1\>\/XI2\<0\>\/XI2\<1\>\/XI2\<0\>\/RR7_pos \
 N_WLSEL\<341\>_XI2\<0\>\/XI2\<0\>\/XI2\<1\>\/XI2\<0\>\/XI2\<1\>\/XI2\<0\>\/XI2\<1\>\/XI2\<0\>\/RR7_neg \
 ) R_1X_LL w=1e-07 l=1e-07   res=0.149966
XXI2\<0\>\/XI2\<0\>\/XI2\<1\>\/XI2\<0\>\/XI2\<1\>\/XI2\<0\>\/XI2\<1\>\/XI2\<0\>\/RR6 \
 (  \
 N_SEL6\<0\>_XI2\<0\>\/XI2\<0\>\/XI2\<1\>\/XI2\<0\>\/XI2\<1\>\/XI2\<0\>\/XI2\<1\>\/XI2\<0\>\/RR6_pos \
 N_WLSEL\<342\>_XI2\<0\>\/XI2\<0\>\/XI2\<1\>\/XI2\<0\>\/XI2\<1\>\/XI2\<0\>\/XI2\<1\>\/XI2\<0\>\/RR6_neg \
 ) R_1X_LL w=1e-07 l=1e-07   res=0.149966
XXI2\<0\>\/XI2\<0\>\/XI2\<1\>\/XI2\<0\>\/XI2\<1\>\/XI2\<0\>\/XI2\<1\>\/XI2\<0\>\/RR5 \
 (  \
 N_SEL7\<0\>_XI2\<0\>\/XI2\<0\>\/XI2\<1\>\/XI2\<0\>\/XI2\<1\>\/XI2\<0\>\/XI2\<1\>\/XI2\<0\>\/RR5_pos \
 N_WLSEL\<343\>_XI2\<0\>\/XI2\<0\>\/XI2\<1\>\/XI2\<0\>\/XI2\<1\>\/XI2\<0\>\/XI2\<1\>\/XI2\<0\>\/RR5_neg \
 ) R_1X_LL w=1e-07 l=1e-07   res=0.149966
XXI2\<0\>\/XI2\<0\>\/XI2\<1\>\/XI2\<0\>\/XI2\<1\>\/XI2\<0\>\/XI2\<1\>\/XI2\<1\>\/RR0 \
 (  \
 N_SEL0\<1\>_XI2\<0\>\/XI2\<0\>\/XI2\<1\>\/XI2\<0\>\/XI2\<1\>\/XI2\<0\>\/XI2\<1\>\/XI2\<1\>\/RR0_pos \
 N_WLSEL\<344\>_XI2\<0\>\/XI2\<0\>\/XI2\<1\>\/XI2\<0\>\/XI2\<1\>\/XI2\<0\>\/XI2\<1\>\/XI2\<1\>\/RR0_neg \
 ) R_1X_LL w=1e-07 l=1e-07   res=0.149966
XXI2\<0\>\/XI2\<0\>\/XI2\<1\>\/XI2\<0\>\/XI2\<1\>\/XI2\<0\>\/XI2\<1\>\/XI2\<1\>\/RR1 \
 (  \
 N_SEL1\<1\>_XI2\<0\>\/XI2\<0\>\/XI2\<1\>\/XI2\<0\>\/XI2\<1\>\/XI2\<0\>\/XI2\<1\>\/XI2\<1\>\/RR1_pos \
 N_WLSEL\<345\>_XI2\<0\>\/XI2\<0\>\/XI2\<1\>\/XI2\<0\>\/XI2\<1\>\/XI2\<0\>\/XI2\<1\>\/XI2\<1\>\/RR1_neg \
 ) R_1X_LL w=1e-07 l=1e-07   res=0.149966
XXI2\<0\>\/XI2\<0\>\/XI2\<1\>\/XI2\<0\>\/XI2\<1\>\/XI2\<0\>\/XI2\<1\>\/XI2\<1\>\/RR2 \
 (  \
 N_SEL2\<0\>_XI2\<0\>\/XI2\<0\>\/XI2\<1\>\/XI2\<0\>\/XI2\<1\>\/XI2\<0\>\/XI2\<1\>\/XI2\<1\>\/RR2_pos \
 N_WLSEL\<346\>_XI2\<0\>\/XI2\<0\>\/XI2\<1\>\/XI2\<0\>\/XI2\<1\>\/XI2\<0\>\/XI2\<1\>\/XI2\<1\>\/RR2_neg \
 ) R_1X_LL w=1e-07 l=1e-07   res=0.149966
XXI2\<0\>\/XI2\<0\>\/XI2\<1\>\/XI2\<0\>\/XI2\<1\>\/XI2\<0\>\/XI2\<1\>\/XI2\<1\>\/RR3 \
 (  \
 N_SEL3\<1\>_XI2\<0\>\/XI2\<0\>\/XI2\<1\>\/XI2\<0\>\/XI2\<1\>\/XI2\<0\>\/XI2\<1\>\/XI2\<1\>\/RR3_pos \
 N_WLSEL\<347\>_XI2\<0\>\/XI2\<0\>\/XI2\<1\>\/XI2\<0\>\/XI2\<1\>\/XI2\<0\>\/XI2\<1\>\/XI2\<1\>\/RR3_neg \
 ) R_1X_LL w=1e-07 l=1e-07   res=0.149966
XXI2\<0\>\/XI2\<0\>\/XI2\<1\>\/XI2\<0\>\/XI2\<1\>\/XI2\<0\>\/XI2\<1\>\/XI2\<1\>\/RR4 \
 (  \
 N_SEL4\<0\>_XI2\<0\>\/XI2\<0\>\/XI2\<1\>\/XI2\<0\>\/XI2\<1\>\/XI2\<0\>\/XI2\<1\>\/XI2\<1\>\/RR4_pos \
 N_WLSEL\<348\>_XI2\<0\>\/XI2\<0\>\/XI2\<1\>\/XI2\<0\>\/XI2\<1\>\/XI2\<0\>\/XI2\<1\>\/XI2\<1\>\/RR4_neg \
 ) R_1X_LL w=1e-07 l=1e-07   res=0.149966
XXI2\<0\>\/XI2\<0\>\/XI2\<1\>\/XI2\<0\>\/XI2\<1\>\/XI2\<0\>\/XI2\<1\>\/XI2\<1\>\/RR7 \
 (  \
 N_SEL5\<1\>_XI2\<0\>\/XI2\<0\>\/XI2\<1\>\/XI2\<0\>\/XI2\<1\>\/XI2\<0\>\/XI2\<1\>\/XI2\<1\>\/RR7_pos \
 N_WLSEL\<349\>_XI2\<0\>\/XI2\<0\>\/XI2\<1\>\/XI2\<0\>\/XI2\<1\>\/XI2\<0\>\/XI2\<1\>\/XI2\<1\>\/RR7_neg \
 ) R_1X_LL w=1e-07 l=1e-07   res=0.149966
XXI2\<0\>\/XI2\<0\>\/XI2\<1\>\/XI2\<0\>\/XI2\<1\>\/XI2\<0\>\/XI2\<1\>\/XI2\<1\>\/RR6 \
 (  \
 N_SEL6\<0\>_XI2\<0\>\/XI2\<0\>\/XI2\<1\>\/XI2\<0\>\/XI2\<1\>\/XI2\<0\>\/XI2\<1\>\/XI2\<1\>\/RR6_pos \
 N_WLSEL\<350\>_XI2\<0\>\/XI2\<0\>\/XI2\<1\>\/XI2\<0\>\/XI2\<1\>\/XI2\<0\>\/XI2\<1\>\/XI2\<1\>\/RR6_neg \
 ) R_1X_LL w=1e-07 l=1e-07   res=0.149966
XXI2\<1\>\/XI2\<1\>\/XI2\<0\>\/XI2\<1\>\/XI2\<0\>\/XI2\<1\>\/XI2\<1\>\/XI2\<1\>\/RR6 \
 (  \
 N_SEL6\<1\>_XI2\<1\>\/XI2\<1\>\/XI2\<0\>\/XI2\<1\>\/XI2\<0\>\/XI2\<1\>\/XI2\<1\>\/XI2\<1\>\/RR6_pos \
 N_WLSEL\<1726\>_XI2\<1\>\/XI2\<1\>\/XI2\<0\>\/XI2\<1\>\/XI2\<0\>\/XI2\<1\>\/XI2\<1\>\/XI2\<1\>\/RR6_neg \
 ) R_1X_LL w=1e-07 l=1e-07   res=0.149966
XXI2\<1\>\/XI2\<1\>\/XI2\<0\>\/XI2\<1\>\/XI2\<0\>\/XI2\<1\>\/XI2\<1\>\/XI2\<1\>\/RR5 \
 (  \
 N_SEL7\<1\>_XI2\<1\>\/XI2\<1\>\/XI2\<0\>\/XI2\<1\>\/XI2\<0\>\/XI2\<1\>\/XI2\<1\>\/XI2\<1\>\/RR5_pos \
 N_WLSEL\<1727\>_XI2\<1\>\/XI2\<1\>\/XI2\<0\>\/XI2\<1\>\/XI2\<0\>\/XI2\<1\>\/XI2\<1\>\/XI2\<1\>\/RR5_neg \
 ) R_1X_LL w=1e-07 l=1e-07   res=0.149966
XXI2\<1\>\/XI2\<1\>\/XI2\<0\>\/XI2\<1\>\/XI2\<1\>\/XI2\<0\>\/XI2\<0\>\/XI2\<0\>\/RR0 \
 (  \
 N_SEL0\<0\>_XI2\<1\>\/XI2\<1\>\/XI2\<0\>\/XI2\<1\>\/XI2\<1\>\/XI2\<0\>\/XI2\<0\>\/XI2\<0\>\/RR0_pos \
 N_WLSEL\<1728\>_XI2\<1\>\/XI2\<1\>\/XI2\<0\>\/XI2\<1\>\/XI2\<1\>\/XI2\<0\>\/XI2\<0\>\/XI2\<0\>\/RR0_neg \
 ) R_1X_LL w=1e-07 l=1e-07   res=0.149966
XXI2\<1\>\/XI2\<1\>\/XI2\<0\>\/XI2\<1\>\/XI2\<1\>\/XI2\<0\>\/XI2\<0\>\/XI2\<0\>\/RR1 \
 (  \
 N_SEL1\<0\>_XI2\<1\>\/XI2\<1\>\/XI2\<0\>\/XI2\<1\>\/XI2\<1\>\/XI2\<0\>\/XI2\<0\>\/XI2\<0\>\/RR1_pos \
 N_WLSEL\<1729\>_XI2\<1\>\/XI2\<1\>\/XI2\<0\>\/XI2\<1\>\/XI2\<1\>\/XI2\<0\>\/XI2\<0\>\/XI2\<0\>\/RR1_neg \
 ) R_1X_LL w=1e-07 l=1e-07   res=0.149966
XXI2\<1\>\/XI2\<1\>\/XI2\<0\>\/XI2\<1\>\/XI2\<1\>\/XI2\<0\>\/XI2\<0\>\/XI2\<0\>\/RR2 \
 (  \
 N_SEL2\<0\>_XI2\<1\>\/XI2\<1\>\/XI2\<0\>\/XI2\<1\>\/XI2\<1\>\/XI2\<0\>\/XI2\<0\>\/XI2\<0\>\/RR2_pos \
 N_WLSEL\<1730\>_XI2\<1\>\/XI2\<1\>\/XI2\<0\>\/XI2\<1\>\/XI2\<1\>\/XI2\<0\>\/XI2\<0\>\/XI2\<0\>\/RR2_neg \
 ) R_1X_LL w=1e-07 l=1e-07   res=0.149966
XXI2\<1\>\/XI2\<1\>\/XI2\<0\>\/XI2\<1\>\/XI2\<1\>\/XI2\<0\>\/XI2\<0\>\/XI2\<0\>\/RR3 \
 (  \
 N_SEL3\<1\>_XI2\<1\>\/XI2\<1\>\/XI2\<0\>\/XI2\<1\>\/XI2\<1\>\/XI2\<0\>\/XI2\<0\>\/XI2\<0\>\/RR3_pos \
 N_WLSEL\<1731\>_XI2\<1\>\/XI2\<1\>\/XI2\<0\>\/XI2\<1\>\/XI2\<1\>\/XI2\<0\>\/XI2\<0\>\/XI2\<0\>\/RR3_neg \
 ) R_1X_LL w=1e-07 l=1e-07   res=0.149966
XXI2\<1\>\/XI2\<1\>\/XI2\<0\>\/XI2\<1\>\/XI2\<1\>\/XI2\<0\>\/XI2\<0\>\/XI2\<0\>\/RR4 \
 (  \
 N_SEL4\<1\>_XI2\<1\>\/XI2\<1\>\/XI2\<0\>\/XI2\<1\>\/XI2\<1\>\/XI2\<0\>\/XI2\<0\>\/XI2\<0\>\/RR4_pos \
 N_WLSEL\<1732\>_XI2\<1\>\/XI2\<1\>\/XI2\<0\>\/XI2\<1\>\/XI2\<1\>\/XI2\<0\>\/XI2\<0\>\/XI2\<0\>\/RR4_neg \
 ) R_1X_LL w=1e-07 l=1e-07   res=0.149966
XXI2\<1\>\/XI2\<1\>\/XI2\<0\>\/XI2\<1\>\/XI2\<1\>\/XI2\<0\>\/XI2\<0\>\/XI2\<0\>\/RR7 \
 (  \
 N_SEL5\<0\>_XI2\<1\>\/XI2\<1\>\/XI2\<0\>\/XI2\<1\>\/XI2\<1\>\/XI2\<0\>\/XI2\<0\>\/XI2\<0\>\/RR7_pos \
 N_WLSEL\<1733\>_XI2\<1\>\/XI2\<1\>\/XI2\<0\>\/XI2\<1\>\/XI2\<1\>\/XI2\<0\>\/XI2\<0\>\/XI2\<0\>\/RR7_neg \
 ) R_1X_LL w=1e-07 l=1e-07   res=0.149966
XXI2\<1\>\/XI2\<1\>\/XI2\<0\>\/XI2\<1\>\/XI2\<1\>\/XI2\<0\>\/XI2\<0\>\/XI2\<0\>\/RR6 \
 (  \
 N_SEL6\<1\>_XI2\<1\>\/XI2\<1\>\/XI2\<0\>\/XI2\<1\>\/XI2\<1\>\/XI2\<0\>\/XI2\<0\>\/XI2\<0\>\/RR6_pos \
 N_WLSEL\<1734\>_XI2\<1\>\/XI2\<1\>\/XI2\<0\>\/XI2\<1\>\/XI2\<1\>\/XI2\<0\>\/XI2\<0\>\/XI2\<0\>\/RR6_neg \
 ) R_1X_LL w=1e-07 l=1e-07   res=0.149966
XXI2\<1\>\/XI2\<1\>\/XI2\<0\>\/XI2\<1\>\/XI2\<1\>\/XI2\<0\>\/XI2\<0\>\/XI2\<0\>\/RR5 \
 (  \
 N_SEL7\<1\>_XI2\<1\>\/XI2\<1\>\/XI2\<0\>\/XI2\<1\>\/XI2\<1\>\/XI2\<0\>\/XI2\<0\>\/XI2\<0\>\/RR5_pos \
 N_WLSEL\<1735\>_XI2\<1\>\/XI2\<1\>\/XI2\<0\>\/XI2\<1\>\/XI2\<1\>\/XI2\<0\>\/XI2\<0\>\/XI2\<0\>\/RR5_neg \
 ) R_1X_LL w=1e-07 l=1e-07   res=0.149966
XXI2\<1\>\/XI2\<1\>\/XI2\<0\>\/XI2\<1\>\/XI2\<1\>\/XI2\<0\>\/XI2\<0\>\/XI2\<1\>\/RR0 \
 (  \
 N_SEL0\<1\>_XI2\<1\>\/XI2\<1\>\/XI2\<0\>\/XI2\<1\>\/XI2\<1\>\/XI2\<0\>\/XI2\<0\>\/XI2\<1\>\/RR0_pos \
 N_WLSEL\<1736\>_XI2\<1\>\/XI2\<1\>\/XI2\<0\>\/XI2\<1\>\/XI2\<1\>\/XI2\<0\>\/XI2\<0\>\/XI2\<1\>\/RR0_neg \
 ) R_1X_LL w=1e-07 l=1e-07   res=0.149966
XXI2\<1\>\/XI2\<1\>\/XI2\<0\>\/XI2\<1\>\/XI2\<1\>\/XI2\<0\>\/XI2\<0\>\/XI2\<1\>\/RR1 \
 (  \
 N_SEL1\<0\>_XI2\<1\>\/XI2\<1\>\/XI2\<0\>\/XI2\<1\>\/XI2\<1\>\/XI2\<0\>\/XI2\<0\>\/XI2\<1\>\/RR1_pos \
 N_WLSEL\<1737\>_XI2\<1\>\/XI2\<1\>\/XI2\<0\>\/XI2\<1\>\/XI2\<1\>\/XI2\<0\>\/XI2\<0\>\/XI2\<1\>\/RR1_neg \
 ) R_1X_LL w=1e-07 l=1e-07   res=0.149966
XXI2\<1\>\/XI2\<1\>\/XI2\<0\>\/XI2\<1\>\/XI2\<1\>\/XI2\<0\>\/XI2\<0\>\/XI2\<1\>\/RR2 \
 (  \
 N_SEL2\<0\>_XI2\<1\>\/XI2\<1\>\/XI2\<0\>\/XI2\<1\>\/XI2\<1\>\/XI2\<0\>\/XI2\<0\>\/XI2\<1\>\/RR2_pos \
 N_WLSEL\<1738\>_XI2\<1\>\/XI2\<1\>\/XI2\<0\>\/XI2\<1\>\/XI2\<1\>\/XI2\<0\>\/XI2\<0\>\/XI2\<1\>\/RR2_neg \
 ) R_1X_LL w=1e-07 l=1e-07   res=0.149966
XXI2\<1\>\/XI2\<1\>\/XI2\<0\>\/XI2\<1\>\/XI2\<1\>\/XI2\<0\>\/XI2\<0\>\/XI2\<1\>\/RR3 \
 (  \
 N_SEL3\<1\>_XI2\<1\>\/XI2\<1\>\/XI2\<0\>\/XI2\<1\>\/XI2\<1\>\/XI2\<0\>\/XI2\<0\>\/XI2\<1\>\/RR3_pos \
 N_WLSEL\<1739\>_XI2\<1\>\/XI2\<1\>\/XI2\<0\>\/XI2\<1\>\/XI2\<1\>\/XI2\<0\>\/XI2\<0\>\/XI2\<1\>\/RR3_neg \
 ) R_1X_LL w=1e-07 l=1e-07   res=0.149966
XXI2\<1\>\/XI2\<1\>\/XI2\<0\>\/XI2\<1\>\/XI2\<1\>\/XI2\<0\>\/XI2\<0\>\/XI2\<1\>\/RR4 \
 (  \
 N_SEL4\<1\>_XI2\<1\>\/XI2\<1\>\/XI2\<0\>\/XI2\<1\>\/XI2\<1\>\/XI2\<0\>\/XI2\<0\>\/XI2\<1\>\/RR4_pos \
 N_WLSEL\<1740\>_XI2\<1\>\/XI2\<1\>\/XI2\<0\>\/XI2\<1\>\/XI2\<1\>\/XI2\<0\>\/XI2\<0\>\/XI2\<1\>\/RR4_neg \
 ) R_1X_LL w=1e-07 l=1e-07   res=0.149966
XXI2\<1\>\/XI2\<1\>\/XI2\<0\>\/XI2\<1\>\/XI2\<1\>\/XI2\<0\>\/XI2\<0\>\/XI2\<1\>\/RR7 \
 (  \
 N_SEL5\<0\>_XI2\<1\>\/XI2\<1\>\/XI2\<0\>\/XI2\<1\>\/XI2\<1\>\/XI2\<0\>\/XI2\<0\>\/XI2\<1\>\/RR7_pos \
 N_WLSEL\<1741\>_XI2\<1\>\/XI2\<1\>\/XI2\<0\>\/XI2\<1\>\/XI2\<1\>\/XI2\<0\>\/XI2\<0\>\/XI2\<1\>\/RR7_neg \
 ) R_1X_LL w=1e-07 l=1e-07   res=0.149966
XXI2\<1\>\/XI2\<1\>\/XI2\<0\>\/XI2\<1\>\/XI2\<1\>\/XI2\<0\>\/XI2\<0\>\/XI2\<1\>\/RR6 \
 (  \
 N_SEL6\<1\>_XI2\<1\>\/XI2\<1\>\/XI2\<0\>\/XI2\<1\>\/XI2\<1\>\/XI2\<0\>\/XI2\<0\>\/XI2\<1\>\/RR6_pos \
 N_WLSEL\<1742\>_XI2\<1\>\/XI2\<1\>\/XI2\<0\>\/XI2\<1\>\/XI2\<1\>\/XI2\<0\>\/XI2\<0\>\/XI2\<1\>\/RR6_neg \
 ) R_1X_LL w=1e-07 l=1e-07   res=0.149966
XXI2\<1\>\/XI2\<1\>\/XI2\<0\>\/XI2\<1\>\/XI2\<1\>\/XI2\<0\>\/XI2\<0\>\/XI2\<1\>\/RR5 \
 (  \
 N_SEL7\<1\>_XI2\<1\>\/XI2\<1\>\/XI2\<0\>\/XI2\<1\>\/XI2\<1\>\/XI2\<0\>\/XI2\<0\>\/XI2\<1\>\/RR5_pos \
 N_WLSEL\<1743\>_XI2\<1\>\/XI2\<1\>\/XI2\<0\>\/XI2\<1\>\/XI2\<1\>\/XI2\<0\>\/XI2\<0\>\/XI2\<1\>\/RR5_neg \
 ) R_1X_LL w=1e-07 l=1e-07   res=0.149966
XXI2\<1\>\/XI2\<1\>\/XI2\<0\>\/XI2\<1\>\/XI2\<1\>\/XI2\<0\>\/XI2\<1\>\/XI2\<0\>\/RR0 \
 (  \
 N_SEL0\<0\>_XI2\<1\>\/XI2\<1\>\/XI2\<0\>\/XI2\<1\>\/XI2\<1\>\/XI2\<0\>\/XI2\<1\>\/XI2\<0\>\/RR0_pos \
 N_WLSEL\<1744\>_XI2\<1\>\/XI2\<1\>\/XI2\<0\>\/XI2\<1\>\/XI2\<1\>\/XI2\<0\>\/XI2\<1\>\/XI2\<0\>\/RR0_neg \
 ) R_1X_LL w=1e-07 l=1e-07   res=0.149966
XXI2\<1\>\/XI2\<1\>\/XI2\<0\>\/XI2\<1\>\/XI2\<1\>\/XI2\<0\>\/XI2\<1\>\/XI2\<0\>\/RR1 \
 (  \
 N_SEL1\<1\>_XI2\<1\>\/XI2\<1\>\/XI2\<0\>\/XI2\<1\>\/XI2\<1\>\/XI2\<0\>\/XI2\<1\>\/XI2\<0\>\/RR1_pos \
 N_WLSEL\<1745\>_XI2\<1\>\/XI2\<1\>\/XI2\<0\>\/XI2\<1\>\/XI2\<1\>\/XI2\<0\>\/XI2\<1\>\/XI2\<0\>\/RR1_neg \
 ) R_1X_LL w=1e-07 l=1e-07   res=0.149966
XXI2\<1\>\/XI2\<1\>\/XI2\<0\>\/XI2\<1\>\/XI2\<1\>\/XI2\<0\>\/XI2\<1\>\/XI2\<0\>\/RR2 \
 (  \
 N_SEL2\<0\>_XI2\<1\>\/XI2\<1\>\/XI2\<0\>\/XI2\<1\>\/XI2\<1\>\/XI2\<0\>\/XI2\<1\>\/XI2\<0\>\/RR2_pos \
 N_WLSEL\<1746\>_XI2\<1\>\/XI2\<1\>\/XI2\<0\>\/XI2\<1\>\/XI2\<1\>\/XI2\<0\>\/XI2\<1\>\/XI2\<0\>\/RR2_neg \
 ) R_1X_LL w=1e-07 l=1e-07   res=0.149966
XXI2\<1\>\/XI2\<1\>\/XI2\<0\>\/XI2\<1\>\/XI2\<1\>\/XI2\<0\>\/XI2\<1\>\/XI2\<0\>\/RR3 \
 (  \
 N_SEL3\<1\>_XI2\<1\>\/XI2\<1\>\/XI2\<0\>\/XI2\<1\>\/XI2\<1\>\/XI2\<0\>\/XI2\<1\>\/XI2\<0\>\/RR3_pos \
 N_WLSEL\<1747\>_XI2\<1\>\/XI2\<1\>\/XI2\<0\>\/XI2\<1\>\/XI2\<1\>\/XI2\<0\>\/XI2\<1\>\/XI2\<0\>\/RR3_neg \
 ) R_1X_LL w=1e-07 l=1e-07   res=0.149966
XXI2\<1\>\/XI2\<1\>\/XI2\<0\>\/XI2\<1\>\/XI2\<1\>\/XI2\<0\>\/XI2\<1\>\/XI2\<0\>\/RR4 \
 (  \
 N_SEL4\<1\>_XI2\<1\>\/XI2\<1\>\/XI2\<0\>\/XI2\<1\>\/XI2\<1\>\/XI2\<0\>\/XI2\<1\>\/XI2\<0\>\/RR4_pos \
 N_WLSEL\<1748\>_XI2\<1\>\/XI2\<1\>\/XI2\<0\>\/XI2\<1\>\/XI2\<1\>\/XI2\<0\>\/XI2\<1\>\/XI2\<0\>\/RR4_neg \
 ) R_1X_LL w=1e-07 l=1e-07   res=0.149966
XXI2\<1\>\/XI2\<1\>\/XI2\<0\>\/XI2\<1\>\/XI2\<1\>\/XI2\<0\>\/XI2\<1\>\/XI2\<0\>\/RR7 \
 (  \
 N_SEL5\<0\>_XI2\<1\>\/XI2\<1\>\/XI2\<0\>\/XI2\<1\>\/XI2\<1\>\/XI2\<0\>\/XI2\<1\>\/XI2\<0\>\/RR7_pos \
 N_WLSEL\<1749\>_XI2\<1\>\/XI2\<1\>\/XI2\<0\>\/XI2\<1\>\/XI2\<1\>\/XI2\<0\>\/XI2\<1\>\/XI2\<0\>\/RR7_neg \
 ) R_1X_LL w=1e-07 l=1e-07   res=0.149966
XXI2\<1\>\/XI2\<1\>\/XI2\<0\>\/XI2\<1\>\/XI2\<1\>\/XI2\<0\>\/XI2\<1\>\/XI2\<0\>\/RR6 \
 (  \
 N_SEL6\<1\>_XI2\<1\>\/XI2\<1\>\/XI2\<0\>\/XI2\<1\>\/XI2\<1\>\/XI2\<0\>\/XI2\<1\>\/XI2\<0\>\/RR6_pos \
 N_WLSEL\<1750\>_XI2\<1\>\/XI2\<1\>\/XI2\<0\>\/XI2\<1\>\/XI2\<1\>\/XI2\<0\>\/XI2\<1\>\/XI2\<0\>\/RR6_neg \
 ) R_1X_LL w=1e-07 l=1e-07   res=0.149966
XXI2\<1\>\/XI2\<1\>\/XI2\<0\>\/XI2\<1\>\/XI2\<1\>\/XI2\<0\>\/XI2\<1\>\/XI2\<0\>\/RR5 \
 (  \
 N_SEL7\<1\>_XI2\<1\>\/XI2\<1\>\/XI2\<0\>\/XI2\<1\>\/XI2\<1\>\/XI2\<0\>\/XI2\<1\>\/XI2\<0\>\/RR5_pos \
 N_WLSEL\<1751\>_XI2\<1\>\/XI2\<1\>\/XI2\<0\>\/XI2\<1\>\/XI2\<1\>\/XI2\<0\>\/XI2\<1\>\/XI2\<0\>\/RR5_neg \
 ) R_1X_LL w=1e-07 l=1e-07   res=0.149966
XXI2\<1\>\/XI2\<1\>\/XI2\<0\>\/XI2\<1\>\/XI2\<1\>\/XI2\<0\>\/XI2\<1\>\/XI2\<1\>\/RR0 \
 (  \
 N_SEL0\<1\>_XI2\<1\>\/XI2\<1\>\/XI2\<0\>\/XI2\<1\>\/XI2\<1\>\/XI2\<0\>\/XI2\<1\>\/XI2\<1\>\/RR0_pos \
 N_WLSEL\<1752\>_XI2\<1\>\/XI2\<1\>\/XI2\<0\>\/XI2\<1\>\/XI2\<1\>\/XI2\<0\>\/XI2\<1\>\/XI2\<1\>\/RR0_neg \
 ) R_1X_LL w=1e-07 l=1e-07   res=0.149966
XXI2\<1\>\/XI2\<1\>\/XI2\<0\>\/XI2\<1\>\/XI2\<1\>\/XI2\<0\>\/XI2\<1\>\/XI2\<1\>\/RR1 \
 (  \
 N_SEL1\<1\>_XI2\<1\>\/XI2\<1\>\/XI2\<0\>\/XI2\<1\>\/XI2\<1\>\/XI2\<0\>\/XI2\<1\>\/XI2\<1\>\/RR1_pos \
 N_WLSEL\<1753\>_XI2\<1\>\/XI2\<1\>\/XI2\<0\>\/XI2\<1\>\/XI2\<1\>\/XI2\<0\>\/XI2\<1\>\/XI2\<1\>\/RR1_neg \
 ) R_1X_LL w=1e-07 l=1e-07   res=0.149966
XXI2\<1\>\/XI2\<1\>\/XI2\<0\>\/XI2\<1\>\/XI2\<1\>\/XI2\<0\>\/XI2\<1\>\/XI2\<1\>\/RR2 \
 (  \
 N_SEL2\<0\>_XI2\<1\>\/XI2\<1\>\/XI2\<0\>\/XI2\<1\>\/XI2\<1\>\/XI2\<0\>\/XI2\<1\>\/XI2\<1\>\/RR2_pos \
 N_WLSEL\<1754\>_XI2\<1\>\/XI2\<1\>\/XI2\<0\>\/XI2\<1\>\/XI2\<1\>\/XI2\<0\>\/XI2\<1\>\/XI2\<1\>\/RR2_neg \
 ) R_1X_LL w=1e-07 l=1e-07   res=0.149966
XXI2\<1\>\/XI2\<1\>\/XI2\<0\>\/XI2\<1\>\/XI2\<1\>\/XI2\<0\>\/XI2\<1\>\/XI2\<1\>\/RR3 \
 (  \
 N_SEL3\<1\>_XI2\<1\>\/XI2\<1\>\/XI2\<0\>\/XI2\<1\>\/XI2\<1\>\/XI2\<0\>\/XI2\<1\>\/XI2\<1\>\/RR3_pos \
 N_WLSEL\<1755\>_XI2\<1\>\/XI2\<1\>\/XI2\<0\>\/XI2\<1\>\/XI2\<1\>\/XI2\<0\>\/XI2\<1\>\/XI2\<1\>\/RR3_neg \
 ) R_1X_LL w=1e-07 l=1e-07   res=0.149966
XXI2\<1\>\/XI2\<1\>\/XI2\<0\>\/XI2\<1\>\/XI2\<1\>\/XI2\<0\>\/XI2\<1\>\/XI2\<1\>\/RR4 \
 (  \
 N_SEL4\<1\>_XI2\<1\>\/XI2\<1\>\/XI2\<0\>\/XI2\<1\>\/XI2\<1\>\/XI2\<0\>\/XI2\<1\>\/XI2\<1\>\/RR4_pos \
 N_WLSEL\<1756\>_XI2\<1\>\/XI2\<1\>\/XI2\<0\>\/XI2\<1\>\/XI2\<1\>\/XI2\<0\>\/XI2\<1\>\/XI2\<1\>\/RR4_neg \
 ) R_1X_LL w=1e-07 l=1e-07   res=0.149966
XXI2\<1\>\/XI2\<1\>\/XI2\<0\>\/XI2\<1\>\/XI2\<1\>\/XI2\<0\>\/XI2\<1\>\/XI2\<1\>\/RR7 \
 (  \
 N_SEL5\<0\>_XI2\<1\>\/XI2\<1\>\/XI2\<0\>\/XI2\<1\>\/XI2\<1\>\/XI2\<0\>\/XI2\<1\>\/XI2\<1\>\/RR7_pos \
 N_WLSEL\<1757\>_XI2\<1\>\/XI2\<1\>\/XI2\<0\>\/XI2\<1\>\/XI2\<1\>\/XI2\<0\>\/XI2\<1\>\/XI2\<1\>\/RR7_neg \
 ) R_1X_LL w=1e-07 l=1e-07   res=0.149966
XXI2\<1\>\/XI2\<1\>\/XI2\<0\>\/XI2\<1\>\/XI2\<1\>\/XI2\<0\>\/XI2\<1\>\/XI2\<1\>\/RR6 \
 (  \
 N_SEL6\<1\>_XI2\<1\>\/XI2\<1\>\/XI2\<0\>\/XI2\<1\>\/XI2\<1\>\/XI2\<0\>\/XI2\<1\>\/XI2\<1\>\/RR6_pos \
 N_WLSEL\<1758\>_XI2\<1\>\/XI2\<1\>\/XI2\<0\>\/XI2\<1\>\/XI2\<1\>\/XI2\<0\>\/XI2\<1\>\/XI2\<1\>\/RR6_neg \
 ) R_1X_LL w=1e-07 l=1e-07   res=0.149966
XXI2\<1\>\/XI2\<1\>\/XI2\<0\>\/XI2\<1\>\/XI2\<1\>\/XI2\<0\>\/XI2\<1\>\/XI2\<1\>\/RR5 \
 (  \
 N_SEL7\<1\>_XI2\<1\>\/XI2\<1\>\/XI2\<0\>\/XI2\<1\>\/XI2\<1\>\/XI2\<0\>\/XI2\<1\>\/XI2\<1\>\/RR5_pos \
 N_WLSEL\<1759\>_XI2\<1\>\/XI2\<1\>\/XI2\<0\>\/XI2\<1\>\/XI2\<1\>\/XI2\<0\>\/XI2\<1\>\/XI2\<1\>\/RR5_neg \
 ) R_1X_LL w=1e-07 l=1e-07   res=0.149966
XXI2\<1\>\/XI2\<1\>\/XI2\<0\>\/XI2\<1\>\/XI2\<1\>\/XI2\<1\>\/XI2\<0\>\/XI2\<0\>\/RR0 \
 (  \
 N_SEL0\<0\>_XI2\<1\>\/XI2\<1\>\/XI2\<0\>\/XI2\<1\>\/XI2\<1\>\/XI2\<1\>\/XI2\<0\>\/XI2\<0\>\/RR0_pos \
 N_WLSEL\<1760\>_XI2\<1\>\/XI2\<1\>\/XI2\<0\>\/XI2\<1\>\/XI2\<1\>\/XI2\<1\>\/XI2\<0\>\/XI2\<0\>\/RR0_neg \
 ) R_1X_LL w=1e-07 l=1e-07   res=0.149966
XXI2\<1\>\/XI2\<1\>\/XI2\<0\>\/XI2\<1\>\/XI2\<1\>\/XI2\<1\>\/XI2\<0\>\/XI2\<0\>\/RR1 \
 (  \
 N_SEL1\<0\>_XI2\<1\>\/XI2\<1\>\/XI2\<0\>\/XI2\<1\>\/XI2\<1\>\/XI2\<1\>\/XI2\<0\>\/XI2\<0\>\/RR1_pos \
 N_WLSEL\<1761\>_XI2\<1\>\/XI2\<1\>\/XI2\<0\>\/XI2\<1\>\/XI2\<1\>\/XI2\<1\>\/XI2\<0\>\/XI2\<0\>\/RR1_neg \
 ) R_1X_LL w=1e-07 l=1e-07   res=0.149966
XXI2\<1\>\/XI2\<1\>\/XI2\<0\>\/XI2\<1\>\/XI2\<1\>\/XI2\<1\>\/XI2\<0\>\/XI2\<0\>\/RR2 \
 (  \
 N_SEL2\<1\>_XI2\<1\>\/XI2\<1\>\/XI2\<0\>\/XI2\<1\>\/XI2\<1\>\/XI2\<1\>\/XI2\<0\>\/XI2\<0\>\/RR2_pos \
 N_WLSEL\<1762\>_XI2\<1\>\/XI2\<1\>\/XI2\<0\>\/XI2\<1\>\/XI2\<1\>\/XI2\<1\>\/XI2\<0\>\/XI2\<0\>\/RR2_neg \
 ) R_1X_LL w=1e-07 l=1e-07   res=0.149966
XXI2\<1\>\/XI2\<1\>\/XI2\<0\>\/XI2\<1\>\/XI2\<1\>\/XI2\<1\>\/XI2\<0\>\/XI2\<0\>\/RR3 \
 (  \
 N_SEL3\<1\>_XI2\<1\>\/XI2\<1\>\/XI2\<0\>\/XI2\<1\>\/XI2\<1\>\/XI2\<1\>\/XI2\<0\>\/XI2\<0\>\/RR3_pos \
 N_WLSEL\<1763\>_XI2\<1\>\/XI2\<1\>\/XI2\<0\>\/XI2\<1\>\/XI2\<1\>\/XI2\<1\>\/XI2\<0\>\/XI2\<0\>\/RR3_neg \
 ) R_1X_LL w=1e-07 l=1e-07   res=0.149966
XXI2\<1\>\/XI2\<1\>\/XI2\<0\>\/XI2\<1\>\/XI2\<1\>\/XI2\<1\>\/XI2\<0\>\/XI2\<0\>\/RR4 \
 (  \
 N_SEL4\<1\>_XI2\<1\>\/XI2\<1\>\/XI2\<0\>\/XI2\<1\>\/XI2\<1\>\/XI2\<1\>\/XI2\<0\>\/XI2\<0\>\/RR4_pos \
 N_WLSEL\<1764\>_XI2\<1\>\/XI2\<1\>\/XI2\<0\>\/XI2\<1\>\/XI2\<1\>\/XI2\<1\>\/XI2\<0\>\/XI2\<0\>\/RR4_neg \
 ) R_1X_LL w=1e-07 l=1e-07   res=0.149966
XXI2\<1\>\/XI2\<1\>\/XI2\<0\>\/XI2\<1\>\/XI2\<1\>\/XI2\<1\>\/XI2\<0\>\/XI2\<0\>\/RR7 \
 (  \
 N_SEL5\<0\>_XI2\<1\>\/XI2\<1\>\/XI2\<0\>\/XI2\<1\>\/XI2\<1\>\/XI2\<1\>\/XI2\<0\>\/XI2\<0\>\/RR7_pos \
 N_WLSEL\<1765\>_XI2\<1\>\/XI2\<1\>\/XI2\<0\>\/XI2\<1\>\/XI2\<1\>\/XI2\<1\>\/XI2\<0\>\/XI2\<0\>\/RR7_neg \
 ) R_1X_LL w=1e-07 l=1e-07   res=0.149966
XXI2\<1\>\/XI2\<1\>\/XI2\<0\>\/XI2\<1\>\/XI2\<1\>\/XI2\<1\>\/XI2\<0\>\/XI2\<0\>\/RR6 \
 (  \
 N_SEL6\<1\>_XI2\<1\>\/XI2\<1\>\/XI2\<0\>\/XI2\<1\>\/XI2\<1\>\/XI2\<1\>\/XI2\<0\>\/XI2\<0\>\/RR6_pos \
 N_WLSEL\<1766\>_XI2\<1\>\/XI2\<1\>\/XI2\<0\>\/XI2\<1\>\/XI2\<1\>\/XI2\<1\>\/XI2\<0\>\/XI2\<0\>\/RR6_neg \
 ) R_1X_LL w=1e-07 l=1e-07   res=0.149966
XXI2\<1\>\/XI2\<1\>\/XI2\<0\>\/XI2\<1\>\/XI2\<1\>\/XI2\<1\>\/XI2\<0\>\/XI2\<0\>\/RR5 \
 (  \
 N_SEL7\<1\>_XI2\<1\>\/XI2\<1\>\/XI2\<0\>\/XI2\<1\>\/XI2\<1\>\/XI2\<1\>\/XI2\<0\>\/XI2\<0\>\/RR5_pos \
 N_WLSEL\<1767\>_XI2\<1\>\/XI2\<1\>\/XI2\<0\>\/XI2\<1\>\/XI2\<1\>\/XI2\<1\>\/XI2\<0\>\/XI2\<0\>\/RR5_neg \
 ) R_1X_LL w=1e-07 l=1e-07   res=0.149966
XXI2\<1\>\/XI2\<1\>\/XI2\<0\>\/XI2\<1\>\/XI2\<1\>\/XI2\<1\>\/XI2\<0\>\/XI2\<1\>\/RR0 \
 (  \
 N_SEL0\<1\>_XI2\<1\>\/XI2\<1\>\/XI2\<0\>\/XI2\<1\>\/XI2\<1\>\/XI2\<1\>\/XI2\<0\>\/XI2\<1\>\/RR0_pos \
 N_WLSEL\<1768\>_XI2\<1\>\/XI2\<1\>\/XI2\<0\>\/XI2\<1\>\/XI2\<1\>\/XI2\<1\>\/XI2\<0\>\/XI2\<1\>\/RR0_neg \
 ) R_1X_LL w=1e-07 l=1e-07   res=0.149966
XXI2\<1\>\/XI2\<1\>\/XI2\<0\>\/XI2\<1\>\/XI2\<1\>\/XI2\<1\>\/XI2\<0\>\/XI2\<1\>\/RR1 \
 (  \
 N_SEL1\<0\>_XI2\<1\>\/XI2\<1\>\/XI2\<0\>\/XI2\<1\>\/XI2\<1\>\/XI2\<1\>\/XI2\<0\>\/XI2\<1\>\/RR1_pos \
 N_WLSEL\<1769\>_XI2\<1\>\/XI2\<1\>\/XI2\<0\>\/XI2\<1\>\/XI2\<1\>\/XI2\<1\>\/XI2\<0\>\/XI2\<1\>\/RR1_neg \
 ) R_1X_LL w=1e-07 l=1e-07   res=0.149966
XXI2\<1\>\/XI2\<1\>\/XI2\<0\>\/XI2\<1\>\/XI2\<1\>\/XI2\<1\>\/XI2\<0\>\/XI2\<1\>\/RR2 \
 (  \
 N_SEL2\<1\>_XI2\<1\>\/XI2\<1\>\/XI2\<0\>\/XI2\<1\>\/XI2\<1\>\/XI2\<1\>\/XI2\<0\>\/XI2\<1\>\/RR2_pos \
 N_WLSEL\<1770\>_XI2\<1\>\/XI2\<1\>\/XI2\<0\>\/XI2\<1\>\/XI2\<1\>\/XI2\<1\>\/XI2\<0\>\/XI2\<1\>\/RR2_neg \
 ) R_1X_LL w=1e-07 l=1e-07   res=0.149966
XXI2\<1\>\/XI2\<1\>\/XI2\<0\>\/XI2\<1\>\/XI2\<1\>\/XI2\<1\>\/XI2\<0\>\/XI2\<1\>\/RR3 \
 (  \
 N_SEL3\<1\>_XI2\<1\>\/XI2\<1\>\/XI2\<0\>\/XI2\<1\>\/XI2\<1\>\/XI2\<1\>\/XI2\<0\>\/XI2\<1\>\/RR3_pos \
 N_WLSEL\<1771\>_XI2\<1\>\/XI2\<1\>\/XI2\<0\>\/XI2\<1\>\/XI2\<1\>\/XI2\<1\>\/XI2\<0\>\/XI2\<1\>\/RR3_neg \
 ) R_1X_LL w=1e-07 l=1e-07   res=0.149966
XXI2\<1\>\/XI2\<1\>\/XI2\<0\>\/XI2\<1\>\/XI2\<1\>\/XI2\<1\>\/XI2\<0\>\/XI2\<1\>\/RR4 \
 (  \
 N_SEL4\<1\>_XI2\<1\>\/XI2\<1\>\/XI2\<0\>\/XI2\<1\>\/XI2\<1\>\/XI2\<1\>\/XI2\<0\>\/XI2\<1\>\/RR4_pos \
 N_WLSEL\<1772\>_XI2\<1\>\/XI2\<1\>\/XI2\<0\>\/XI2\<1\>\/XI2\<1\>\/XI2\<1\>\/XI2\<0\>\/XI2\<1\>\/RR4_neg \
 ) R_1X_LL w=1e-07 l=1e-07   res=0.149966
XXI2\<1\>\/XI2\<1\>\/XI2\<0\>\/XI2\<1\>\/XI2\<1\>\/XI2\<1\>\/XI2\<0\>\/XI2\<1\>\/RR7 \
 (  \
 N_SEL5\<0\>_XI2\<1\>\/XI2\<1\>\/XI2\<0\>\/XI2\<1\>\/XI2\<1\>\/XI2\<1\>\/XI2\<0\>\/XI2\<1\>\/RR7_pos \
 N_WLSEL\<1773\>_XI2\<1\>\/XI2\<1\>\/XI2\<0\>\/XI2\<1\>\/XI2\<1\>\/XI2\<1\>\/XI2\<0\>\/XI2\<1\>\/RR7_neg \
 ) R_1X_LL w=1e-07 l=1e-07   res=0.149966
XXI2\<1\>\/XI2\<1\>\/XI2\<0\>\/XI2\<1\>\/XI2\<1\>\/XI2\<1\>\/XI2\<0\>\/XI2\<1\>\/RR6 \
 (  \
 N_SEL6\<1\>_XI2\<1\>\/XI2\<1\>\/XI2\<0\>\/XI2\<1\>\/XI2\<1\>\/XI2\<1\>\/XI2\<0\>\/XI2\<1\>\/RR6_pos \
 N_WLSEL\<1774\>_XI2\<1\>\/XI2\<1\>\/XI2\<0\>\/XI2\<1\>\/XI2\<1\>\/XI2\<1\>\/XI2\<0\>\/XI2\<1\>\/RR6_neg \
 ) R_1X_LL w=1e-07 l=1e-07   res=0.149966
XXI2\<1\>\/XI2\<1\>\/XI2\<0\>\/XI2\<1\>\/XI2\<1\>\/XI2\<1\>\/XI2\<0\>\/XI2\<1\>\/RR5 \
 (  \
 N_SEL7\<1\>_XI2\<1\>\/XI2\<1\>\/XI2\<0\>\/XI2\<1\>\/XI2\<1\>\/XI2\<1\>\/XI2\<0\>\/XI2\<1\>\/RR5_pos \
 N_WLSEL\<1775\>_XI2\<1\>\/XI2\<1\>\/XI2\<0\>\/XI2\<1\>\/XI2\<1\>\/XI2\<1\>\/XI2\<0\>\/XI2\<1\>\/RR5_neg \
 ) R_1X_LL w=1e-07 l=1e-07   res=0.149966
XXI2\<1\>\/XI2\<1\>\/XI2\<0\>\/XI2\<1\>\/XI2\<1\>\/XI2\<1\>\/XI2\<1\>\/XI2\<0\>\/RR0 \
 (  \
 N_SEL0\<0\>_XI2\<1\>\/XI2\<1\>\/XI2\<0\>\/XI2\<1\>\/XI2\<1\>\/XI2\<1\>\/XI2\<1\>\/XI2\<0\>\/RR0_pos \
 N_WLSEL\<1776\>_XI2\<1\>\/XI2\<1\>\/XI2\<0\>\/XI2\<1\>\/XI2\<1\>\/XI2\<1\>\/XI2\<1\>\/XI2\<0\>\/RR0_neg \
 ) R_1X_LL w=1e-07 l=1e-07   res=0.149966
XXI2\<1\>\/XI2\<1\>\/XI2\<0\>\/XI2\<1\>\/XI2\<1\>\/XI2\<1\>\/XI2\<1\>\/XI2\<0\>\/RR1 \
 (  \
 N_SEL1\<1\>_XI2\<1\>\/XI2\<1\>\/XI2\<0\>\/XI2\<1\>\/XI2\<1\>\/XI2\<1\>\/XI2\<1\>\/XI2\<0\>\/RR1_pos \
 N_WLSEL\<1777\>_XI2\<1\>\/XI2\<1\>\/XI2\<0\>\/XI2\<1\>\/XI2\<1\>\/XI2\<1\>\/XI2\<1\>\/XI2\<0\>\/RR1_neg \
 ) R_1X_LL w=1e-07 l=1e-07   res=0.149966
XXI2\<1\>\/XI2\<1\>\/XI2\<0\>\/XI2\<1\>\/XI2\<1\>\/XI2\<1\>\/XI2\<1\>\/XI2\<0\>\/RR2 \
 (  \
 N_SEL2\<1\>_XI2\<1\>\/XI2\<1\>\/XI2\<0\>\/XI2\<1\>\/XI2\<1\>\/XI2\<1\>\/XI2\<1\>\/XI2\<0\>\/RR2_pos \
 N_WLSEL\<1778\>_XI2\<1\>\/XI2\<1\>\/XI2\<0\>\/XI2\<1\>\/XI2\<1\>\/XI2\<1\>\/XI2\<1\>\/XI2\<0\>\/RR2_neg \
 ) R_1X_LL w=1e-07 l=1e-07   res=0.149966
XXI2\<1\>\/XI2\<1\>\/XI2\<0\>\/XI2\<1\>\/XI2\<1\>\/XI2\<1\>\/XI2\<1\>\/XI2\<0\>\/RR3 \
 (  \
 N_SEL3\<1\>_XI2\<1\>\/XI2\<1\>\/XI2\<0\>\/XI2\<1\>\/XI2\<1\>\/XI2\<1\>\/XI2\<1\>\/XI2\<0\>\/RR3_pos \
 N_WLSEL\<1779\>_XI2\<1\>\/XI2\<1\>\/XI2\<0\>\/XI2\<1\>\/XI2\<1\>\/XI2\<1\>\/XI2\<1\>\/XI2\<0\>\/RR3_neg \
 ) R_1X_LL w=1e-07 l=1e-07   res=0.149966
XXI2\<1\>\/XI2\<1\>\/XI2\<0\>\/XI2\<1\>\/XI2\<1\>\/XI2\<1\>\/XI2\<1\>\/XI2\<0\>\/RR4 \
 (  \
 N_SEL4\<1\>_XI2\<1\>\/XI2\<1\>\/XI2\<0\>\/XI2\<1\>\/XI2\<1\>\/XI2\<1\>\/XI2\<1\>\/XI2\<0\>\/RR4_pos \
 N_WLSEL\<1780\>_XI2\<1\>\/XI2\<1\>\/XI2\<0\>\/XI2\<1\>\/XI2\<1\>\/XI2\<1\>\/XI2\<1\>\/XI2\<0\>\/RR4_neg \
 ) R_1X_LL w=1e-07 l=1e-07   res=0.149966
XXI2\<1\>\/XI2\<1\>\/XI2\<0\>\/XI2\<1\>\/XI2\<1\>\/XI2\<1\>\/XI2\<1\>\/XI2\<0\>\/RR7 \
 (  \
 N_SEL5\<0\>_XI2\<1\>\/XI2\<1\>\/XI2\<0\>\/XI2\<1\>\/XI2\<1\>\/XI2\<1\>\/XI2\<1\>\/XI2\<0\>\/RR7_pos \
 N_WLSEL\<1781\>_XI2\<1\>\/XI2\<1\>\/XI2\<0\>\/XI2\<1\>\/XI2\<1\>\/XI2\<1\>\/XI2\<1\>\/XI2\<0\>\/RR7_neg \
 ) R_1X_LL w=1e-07 l=1e-07   res=0.149966
XXI2\<1\>\/XI2\<1\>\/XI2\<0\>\/XI2\<1\>\/XI2\<1\>\/XI2\<1\>\/XI2\<1\>\/XI2\<0\>\/RR6 \
 (  \
 N_SEL6\<1\>_XI2\<1\>\/XI2\<1\>\/XI2\<0\>\/XI2\<1\>\/XI2\<1\>\/XI2\<1\>\/XI2\<1\>\/XI2\<0\>\/RR6_pos \
 N_WLSEL\<1782\>_XI2\<1\>\/XI2\<1\>\/XI2\<0\>\/XI2\<1\>\/XI2\<1\>\/XI2\<1\>\/XI2\<1\>\/XI2\<0\>\/RR6_neg \
 ) R_1X_LL w=1e-07 l=1e-07   res=0.149966
XXI2\<1\>\/XI2\<1\>\/XI2\<0\>\/XI2\<1\>\/XI2\<1\>\/XI2\<1\>\/XI2\<1\>\/XI2\<0\>\/RR5 \
 (  \
 N_SEL7\<1\>_XI2\<1\>\/XI2\<1\>\/XI2\<0\>\/XI2\<1\>\/XI2\<1\>\/XI2\<1\>\/XI2\<1\>\/XI2\<0\>\/RR5_pos \
 N_WLSEL\<1783\>_XI2\<1\>\/XI2\<1\>\/XI2\<0\>\/XI2\<1\>\/XI2\<1\>\/XI2\<1\>\/XI2\<1\>\/XI2\<0\>\/RR5_neg \
 ) R_1X_LL w=1e-07 l=1e-07   res=0.149966
XXI2\<1\>\/XI2\<1\>\/XI2\<0\>\/XI2\<1\>\/XI2\<1\>\/XI2\<1\>\/XI2\<1\>\/XI2\<1\>\/RR0 \
 (  \
 N_SEL0\<1\>_XI2\<1\>\/XI2\<1\>\/XI2\<0\>\/XI2\<1\>\/XI2\<1\>\/XI2\<1\>\/XI2\<1\>\/XI2\<1\>\/RR0_pos \
 N_WLSEL\<1784\>_XI2\<1\>\/XI2\<1\>\/XI2\<0\>\/XI2\<1\>\/XI2\<1\>\/XI2\<1\>\/XI2\<1\>\/XI2\<1\>\/RR0_neg \
 ) R_1X_LL w=1e-07 l=1e-07   res=0.149966
XXI2\<1\>\/XI2\<1\>\/XI2\<0\>\/XI2\<1\>\/XI2\<1\>\/XI2\<1\>\/XI2\<1\>\/XI2\<1\>\/RR1 \
 (  \
 N_SEL1\<1\>_XI2\<1\>\/XI2\<1\>\/XI2\<0\>\/XI2\<1\>\/XI2\<1\>\/XI2\<1\>\/XI2\<1\>\/XI2\<1\>\/RR1_pos \
 N_WLSEL\<1785\>_XI2\<1\>\/XI2\<1\>\/XI2\<0\>\/XI2\<1\>\/XI2\<1\>\/XI2\<1\>\/XI2\<1\>\/XI2\<1\>\/RR1_neg \
 ) R_1X_LL w=1e-07 l=1e-07   res=0.149966
XXI2\<1\>\/XI2\<1\>\/XI2\<0\>\/XI2\<1\>\/XI2\<1\>\/XI2\<1\>\/XI2\<1\>\/XI2\<1\>\/RR2 \
 (  \
 N_SEL2\<1\>_XI2\<1\>\/XI2\<1\>\/XI2\<0\>\/XI2\<1\>\/XI2\<1\>\/XI2\<1\>\/XI2\<1\>\/XI2\<1\>\/RR2_pos \
 N_WLSEL\<1786\>_XI2\<1\>\/XI2\<1\>\/XI2\<0\>\/XI2\<1\>\/XI2\<1\>\/XI2\<1\>\/XI2\<1\>\/XI2\<1\>\/RR2_neg \
 ) R_1X_LL w=1e-07 l=1e-07   res=0.149966
XXI2\<1\>\/XI2\<1\>\/XI2\<0\>\/XI2\<1\>\/XI2\<1\>\/XI2\<1\>\/XI2\<1\>\/XI2\<1\>\/RR3 \
 (  \
 N_SEL3\<1\>_XI2\<1\>\/XI2\<1\>\/XI2\<0\>\/XI2\<1\>\/XI2\<1\>\/XI2\<1\>\/XI2\<1\>\/XI2\<1\>\/RR3_pos \
 N_WLSEL\<1787\>_XI2\<1\>\/XI2\<1\>\/XI2\<0\>\/XI2\<1\>\/XI2\<1\>\/XI2\<1\>\/XI2\<1\>\/XI2\<1\>\/RR3_neg \
 ) R_1X_LL w=1e-07 l=1e-07   res=0.149966
XXI2\<1\>\/XI2\<1\>\/XI2\<0\>\/XI2\<1\>\/XI2\<1\>\/XI2\<1\>\/XI2\<1\>\/XI2\<1\>\/RR4 \
 (  \
 N_SEL4\<1\>_XI2\<1\>\/XI2\<1\>\/XI2\<0\>\/XI2\<1\>\/XI2\<1\>\/XI2\<1\>\/XI2\<1\>\/XI2\<1\>\/RR4_pos \
 N_WLSEL\<1788\>_XI2\<1\>\/XI2\<1\>\/XI2\<0\>\/XI2\<1\>\/XI2\<1\>\/XI2\<1\>\/XI2\<1\>\/XI2\<1\>\/RR4_neg \
 ) R_1X_LL w=1e-07 l=1e-07   res=0.149966
XXI2\<1\>\/XI2\<1\>\/XI2\<0\>\/XI2\<1\>\/XI2\<1\>\/XI2\<1\>\/XI2\<1\>\/XI2\<1\>\/RR7 \
 (  \
 N_SEL5\<0\>_XI2\<1\>\/XI2\<1\>\/XI2\<0\>\/XI2\<1\>\/XI2\<1\>\/XI2\<1\>\/XI2\<1\>\/XI2\<1\>\/RR7_pos \
 N_WLSEL\<1789\>_XI2\<1\>\/XI2\<1\>\/XI2\<0\>\/XI2\<1\>\/XI2\<1\>\/XI2\<1\>\/XI2\<1\>\/XI2\<1\>\/RR7_neg \
 ) R_1X_LL w=1e-07 l=1e-07   res=0.149966
XXI2\<1\>\/XI2\<1\>\/XI2\<0\>\/XI2\<1\>\/XI2\<1\>\/XI2\<1\>\/XI2\<1\>\/XI2\<1\>\/RR6 \
 (  \
 N_SEL6\<1\>_XI2\<1\>\/XI2\<1\>\/XI2\<0\>\/XI2\<1\>\/XI2\<1\>\/XI2\<1\>\/XI2\<1\>\/XI2\<1\>\/RR6_pos \
 N_WLSEL\<1790\>_XI2\<1\>\/XI2\<1\>\/XI2\<0\>\/XI2\<1\>\/XI2\<1\>\/XI2\<1\>\/XI2\<1\>\/XI2\<1\>\/RR6_neg \
 ) R_1X_LL w=1e-07 l=1e-07   res=0.149966
XXI2\<1\>\/XI2\<1\>\/XI2\<0\>\/XI2\<1\>\/XI2\<1\>\/XI2\<1\>\/XI2\<1\>\/XI2\<1\>\/RR5 \
 (  \
 N_SEL7\<1\>_XI2\<1\>\/XI2\<1\>\/XI2\<0\>\/XI2\<1\>\/XI2\<1\>\/XI2\<1\>\/XI2\<1\>\/XI2\<1\>\/RR5_pos \
 N_WLSEL\<1791\>_XI2\<1\>\/XI2\<1\>\/XI2\<0\>\/XI2\<1\>\/XI2\<1\>\/XI2\<1\>\/XI2\<1\>\/XI2\<1\>\/RR5_neg \
 ) R_1X_LL w=1e-07 l=1e-07   res=0.149966
XXI2\<1\>\/XI2\<1\>\/XI2\<1\>\/XI2\<0\>\/XI2\<0\>\/XI2\<0\>\/XI2\<0\>\/XI2\<0\>\/RR0 \
 (  \
 N_SEL0\<0\>_XI2\<1\>\/XI2\<1\>\/XI2\<1\>\/XI2\<0\>\/XI2\<0\>\/XI2\<0\>\/XI2\<0\>\/XI2\<0\>\/RR0_pos \
 N_WLSEL\<1792\>_XI2\<1\>\/XI2\<1\>\/XI2\<1\>\/XI2\<0\>\/XI2\<0\>\/XI2\<0\>\/XI2\<0\>\/XI2\<0\>\/RR0_neg \
 ) R_1X_LL w=1e-07 l=1e-07   res=0.149966
XXI2\<1\>\/XI2\<1\>\/XI2\<1\>\/XI2\<0\>\/XI2\<0\>\/XI2\<0\>\/XI2\<0\>\/XI2\<0\>\/RR1 \
 (  \
 N_SEL1\<0\>_XI2\<1\>\/XI2\<1\>\/XI2\<1\>\/XI2\<0\>\/XI2\<0\>\/XI2\<0\>\/XI2\<0\>\/XI2\<0\>\/RR1_pos \
 N_WLSEL\<1793\>_XI2\<1\>\/XI2\<1\>\/XI2\<1\>\/XI2\<0\>\/XI2\<0\>\/XI2\<0\>\/XI2\<0\>\/XI2\<0\>\/RR1_neg \
 ) R_1X_LL w=1e-07 l=1e-07   res=0.149966
XXI2\<1\>\/XI2\<1\>\/XI2\<1\>\/XI2\<0\>\/XI2\<0\>\/XI2\<0\>\/XI2\<0\>\/XI2\<0\>\/RR2 \
 (  \
 N_SEL2\<0\>_XI2\<1\>\/XI2\<1\>\/XI2\<1\>\/XI2\<0\>\/XI2\<0\>\/XI2\<0\>\/XI2\<0\>\/XI2\<0\>\/RR2_pos \
 N_WLSEL\<1794\>_XI2\<1\>\/XI2\<1\>\/XI2\<1\>\/XI2\<0\>\/XI2\<0\>\/XI2\<0\>\/XI2\<0\>\/XI2\<0\>\/RR2_neg \
 ) R_1X_LL w=1e-07 l=1e-07   res=0.149966
XXI2\<1\>\/XI2\<1\>\/XI2\<1\>\/XI2\<0\>\/XI2\<0\>\/XI2\<0\>\/XI2\<0\>\/XI2\<0\>\/RR3 \
 (  \
 N_SEL3\<0\>_XI2\<1\>\/XI2\<1\>\/XI2\<1\>\/XI2\<0\>\/XI2\<0\>\/XI2\<0\>\/XI2\<0\>\/XI2\<0\>\/RR3_pos \
 N_WLSEL\<1795\>_XI2\<1\>\/XI2\<1\>\/XI2\<1\>\/XI2\<0\>\/XI2\<0\>\/XI2\<0\>\/XI2\<0\>\/XI2\<0\>\/RR3_neg \
 ) R_1X_LL w=1e-07 l=1e-07   res=0.149966
XXI2\<1\>\/XI2\<1\>\/XI2\<1\>\/XI2\<0\>\/XI2\<0\>\/XI2\<0\>\/XI2\<0\>\/XI2\<0\>\/RR4 \
 (  \
 N_SEL4\<0\>_XI2\<1\>\/XI2\<1\>\/XI2\<1\>\/XI2\<0\>\/XI2\<0\>\/XI2\<0\>\/XI2\<0\>\/XI2\<0\>\/RR4_pos \
 N_WLSEL\<1796\>_XI2\<1\>\/XI2\<1\>\/XI2\<1\>\/XI2\<0\>\/XI2\<0\>\/XI2\<0\>\/XI2\<0\>\/XI2\<0\>\/RR4_neg \
 ) R_1X_LL w=1e-07 l=1e-07   res=0.149966
XXI2\<1\>\/XI2\<1\>\/XI2\<1\>\/XI2\<0\>\/XI2\<0\>\/XI2\<0\>\/XI2\<0\>\/XI2\<0\>\/RR7 \
 (  \
 N_SEL5\<1\>_XI2\<1\>\/XI2\<1\>\/XI2\<1\>\/XI2\<0\>\/XI2\<0\>\/XI2\<0\>\/XI2\<0\>\/XI2\<0\>\/RR7_pos \
 N_WLSEL\<1797\>_XI2\<1\>\/XI2\<1\>\/XI2\<1\>\/XI2\<0\>\/XI2\<0\>\/XI2\<0\>\/XI2\<0\>\/XI2\<0\>\/RR7_neg \
 ) R_1X_LL w=1e-07 l=1e-07   res=0.149966
XXI2\<1\>\/XI2\<1\>\/XI2\<1\>\/XI2\<0\>\/XI2\<0\>\/XI2\<0\>\/XI2\<0\>\/XI2\<0\>\/RR6 \
 (  \
 N_SEL6\<1\>_XI2\<1\>\/XI2\<1\>\/XI2\<1\>\/XI2\<0\>\/XI2\<0\>\/XI2\<0\>\/XI2\<0\>\/XI2\<0\>\/RR6_pos \
 N_WLSEL\<1798\>_XI2\<1\>\/XI2\<1\>\/XI2\<1\>\/XI2\<0\>\/XI2\<0\>\/XI2\<0\>\/XI2\<0\>\/XI2\<0\>\/RR6_neg \
 ) R_1X_LL w=1e-07 l=1e-07   res=0.149966
XXI2\<1\>\/XI2\<1\>\/XI2\<1\>\/XI2\<0\>\/XI2\<0\>\/XI2\<0\>\/XI2\<0\>\/XI2\<0\>\/RR5 \
 (  \
 N_SEL7\<1\>_XI2\<1\>\/XI2\<1\>\/XI2\<1\>\/XI2\<0\>\/XI2\<0\>\/XI2\<0\>\/XI2\<0\>\/XI2\<0\>\/RR5_pos \
 N_WLSEL\<1799\>_XI2\<1\>\/XI2\<1\>\/XI2\<1\>\/XI2\<0\>\/XI2\<0\>\/XI2\<0\>\/XI2\<0\>\/XI2\<0\>\/RR5_neg \
 ) R_1X_LL w=1e-07 l=1e-07   res=0.149966
XXI2\<1\>\/XI2\<1\>\/XI2\<1\>\/XI2\<0\>\/XI2\<0\>\/XI2\<0\>\/XI2\<0\>\/XI2\<1\>\/RR0 \
 (  \
 N_SEL0\<1\>_XI2\<1\>\/XI2\<1\>\/XI2\<1\>\/XI2\<0\>\/XI2\<0\>\/XI2\<0\>\/XI2\<0\>\/XI2\<1\>\/RR0_pos \
 N_WLSEL\<1800\>_XI2\<1\>\/XI2\<1\>\/XI2\<1\>\/XI2\<0\>\/XI2\<0\>\/XI2\<0\>\/XI2\<0\>\/XI2\<1\>\/RR0_neg \
 ) R_1X_LL w=1e-07 l=1e-07   res=0.149966
XXI2\<1\>\/XI2\<1\>\/XI2\<1\>\/XI2\<0\>\/XI2\<0\>\/XI2\<0\>\/XI2\<0\>\/XI2\<1\>\/RR1 \
 (  \
 N_SEL1\<0\>_XI2\<1\>\/XI2\<1\>\/XI2\<1\>\/XI2\<0\>\/XI2\<0\>\/XI2\<0\>\/XI2\<0\>\/XI2\<1\>\/RR1_pos \
 N_WLSEL\<1801\>_XI2\<1\>\/XI2\<1\>\/XI2\<1\>\/XI2\<0\>\/XI2\<0\>\/XI2\<0\>\/XI2\<0\>\/XI2\<1\>\/RR1_neg \
 ) R_1X_LL w=1e-07 l=1e-07   res=0.149966
XXI2\<1\>\/XI2\<1\>\/XI2\<1\>\/XI2\<0\>\/XI2\<0\>\/XI2\<0\>\/XI2\<0\>\/XI2\<1\>\/RR2 \
 (  \
 N_SEL2\<0\>_XI2\<1\>\/XI2\<1\>\/XI2\<1\>\/XI2\<0\>\/XI2\<0\>\/XI2\<0\>\/XI2\<0\>\/XI2\<1\>\/RR2_pos \
 N_WLSEL\<1802\>_XI2\<1\>\/XI2\<1\>\/XI2\<1\>\/XI2\<0\>\/XI2\<0\>\/XI2\<0\>\/XI2\<0\>\/XI2\<1\>\/RR2_neg \
 ) R_1X_LL w=1e-07 l=1e-07   res=0.149966
XXI2\<1\>\/XI2\<1\>\/XI2\<1\>\/XI2\<0\>\/XI2\<0\>\/XI2\<0\>\/XI2\<0\>\/XI2\<1\>\/RR3 \
 (  \
 N_SEL3\<0\>_XI2\<1\>\/XI2\<1\>\/XI2\<1\>\/XI2\<0\>\/XI2\<0\>\/XI2\<0\>\/XI2\<0\>\/XI2\<1\>\/RR3_pos \
 N_WLSEL\<1803\>_XI2\<1\>\/XI2\<1\>\/XI2\<1\>\/XI2\<0\>\/XI2\<0\>\/XI2\<0\>\/XI2\<0\>\/XI2\<1\>\/RR3_neg \
 ) R_1X_LL w=1e-07 l=1e-07   res=0.149966
XXI2\<1\>\/XI2\<1\>\/XI2\<1\>\/XI2\<0\>\/XI2\<0\>\/XI2\<0\>\/XI2\<0\>\/XI2\<1\>\/RR4 \
 (  \
 N_SEL4\<0\>_XI2\<1\>\/XI2\<1\>\/XI2\<1\>\/XI2\<0\>\/XI2\<0\>\/XI2\<0\>\/XI2\<0\>\/XI2\<1\>\/RR4_pos \
 N_WLSEL\<1804\>_XI2\<1\>\/XI2\<1\>\/XI2\<1\>\/XI2\<0\>\/XI2\<0\>\/XI2\<0\>\/XI2\<0\>\/XI2\<1\>\/RR4_neg \
 ) R_1X_LL w=1e-07 l=1e-07   res=0.149966
XXI2\<1\>\/XI2\<1\>\/XI2\<1\>\/XI2\<0\>\/XI2\<0\>\/XI2\<0\>\/XI2\<0\>\/XI2\<1\>\/RR7 \
 (  \
 N_SEL5\<1\>_XI2\<1\>\/XI2\<1\>\/XI2\<1\>\/XI2\<0\>\/XI2\<0\>\/XI2\<0\>\/XI2\<0\>\/XI2\<1\>\/RR7_pos \
 N_WLSEL\<1805\>_XI2\<1\>\/XI2\<1\>\/XI2\<1\>\/XI2\<0\>\/XI2\<0\>\/XI2\<0\>\/XI2\<0\>\/XI2\<1\>\/RR7_neg \
 ) R_1X_LL w=1e-07 l=1e-07   res=0.149966
XXI2\<1\>\/XI2\<0\>\/XI2\<0\>\/XI2\<1\>\/XI2\<0\>\/XI2\<1\>\/XI2\<1\>\/XI2\<1\>\/RR6 \
 (  \
 N_SEL6\<0\>_XI2\<1\>\/XI2\<0\>\/XI2\<0\>\/XI2\<1\>\/XI2\<0\>\/XI2\<1\>\/XI2\<1\>\/XI2\<1\>\/RR6_pos \
 N_WLSEL\<1214\>_XI2\<1\>\/XI2\<0\>\/XI2\<0\>\/XI2\<1\>\/XI2\<0\>\/XI2\<1\>\/XI2\<1\>\/XI2\<1\>\/RR6_neg \
 ) R_1X_LL w=1e-07 l=1e-07   res=0.149966
XXI2\<1\>\/XI2\<0\>\/XI2\<0\>\/XI2\<1\>\/XI2\<0\>\/XI2\<1\>\/XI2\<1\>\/XI2\<1\>\/RR5 \
 (  \
 N_SEL7\<1\>_XI2\<1\>\/XI2\<0\>\/XI2\<0\>\/XI2\<1\>\/XI2\<0\>\/XI2\<1\>\/XI2\<1\>\/XI2\<1\>\/RR5_pos \
 N_WLSEL\<1215\>_XI2\<1\>\/XI2\<0\>\/XI2\<0\>\/XI2\<1\>\/XI2\<0\>\/XI2\<1\>\/XI2\<1\>\/XI2\<1\>\/RR5_neg \
 ) R_1X_LL w=1e-07 l=1e-07   res=0.149966
XXI2\<1\>\/XI2\<0\>\/XI2\<0\>\/XI2\<1\>\/XI2\<1\>\/XI2\<0\>\/XI2\<0\>\/XI2\<0\>\/RR0 \
 (  \
 N_SEL0\<0\>_XI2\<1\>\/XI2\<0\>\/XI2\<0\>\/XI2\<1\>\/XI2\<1\>\/XI2\<0\>\/XI2\<0\>\/XI2\<0\>\/RR0_pos \
 N_WLSEL\<1216\>_XI2\<1\>\/XI2\<0\>\/XI2\<0\>\/XI2\<1\>\/XI2\<1\>\/XI2\<0\>\/XI2\<0\>\/XI2\<0\>\/RR0_neg \
 ) R_1X_LL w=1e-07 l=1e-07   res=0.149966
XXI2\<1\>\/XI2\<0\>\/XI2\<0\>\/XI2\<1\>\/XI2\<1\>\/XI2\<0\>\/XI2\<0\>\/XI2\<0\>\/RR1 \
 (  \
 N_SEL1\<0\>_XI2\<1\>\/XI2\<0\>\/XI2\<0\>\/XI2\<1\>\/XI2\<1\>\/XI2\<0\>\/XI2\<0\>\/XI2\<0\>\/RR1_pos \
 N_WLSEL\<1217\>_XI2\<1\>\/XI2\<0\>\/XI2\<0\>\/XI2\<1\>\/XI2\<1\>\/XI2\<0\>\/XI2\<0\>\/XI2\<0\>\/RR1_neg \
 ) R_1X_LL w=1e-07 l=1e-07   res=0.149966
XXI2\<1\>\/XI2\<0\>\/XI2\<0\>\/XI2\<1\>\/XI2\<1\>\/XI2\<0\>\/XI2\<0\>\/XI2\<0\>\/RR2 \
 (  \
 N_SEL2\<0\>_XI2\<1\>\/XI2\<0\>\/XI2\<0\>\/XI2\<1\>\/XI2\<1\>\/XI2\<0\>\/XI2\<0\>\/XI2\<0\>\/RR2_pos \
 N_WLSEL\<1218\>_XI2\<1\>\/XI2\<0\>\/XI2\<0\>\/XI2\<1\>\/XI2\<1\>\/XI2\<0\>\/XI2\<0\>\/XI2\<0\>\/RR2_neg \
 ) R_1X_LL w=1e-07 l=1e-07   res=0.149966
XXI2\<1\>\/XI2\<0\>\/XI2\<0\>\/XI2\<1\>\/XI2\<1\>\/XI2\<0\>\/XI2\<0\>\/XI2\<0\>\/RR3 \
 (  \
 N_SEL3\<1\>_XI2\<1\>\/XI2\<0\>\/XI2\<0\>\/XI2\<1\>\/XI2\<1\>\/XI2\<0\>\/XI2\<0\>\/XI2\<0\>\/RR3_pos \
 N_WLSEL\<1219\>_XI2\<1\>\/XI2\<0\>\/XI2\<0\>\/XI2\<1\>\/XI2\<1\>\/XI2\<0\>\/XI2\<0\>\/XI2\<0\>\/RR3_neg \
 ) R_1X_LL w=1e-07 l=1e-07   res=0.149966
XXI2\<1\>\/XI2\<0\>\/XI2\<0\>\/XI2\<1\>\/XI2\<1\>\/XI2\<0\>\/XI2\<0\>\/XI2\<0\>\/RR4 \
 (  \
 N_SEL4\<1\>_XI2\<1\>\/XI2\<0\>\/XI2\<0\>\/XI2\<1\>\/XI2\<1\>\/XI2\<0\>\/XI2\<0\>\/XI2\<0\>\/RR4_pos \
 N_WLSEL\<1220\>_XI2\<1\>\/XI2\<0\>\/XI2\<0\>\/XI2\<1\>\/XI2\<1\>\/XI2\<0\>\/XI2\<0\>\/XI2\<0\>\/RR4_neg \
 ) R_1X_LL w=1e-07 l=1e-07   res=0.149966
XXI2\<1\>\/XI2\<0\>\/XI2\<0\>\/XI2\<1\>\/XI2\<1\>\/XI2\<0\>\/XI2\<0\>\/XI2\<0\>\/RR7 \
 (  \
 N_SEL5\<0\>_XI2\<1\>\/XI2\<0\>\/XI2\<0\>\/XI2\<1\>\/XI2\<1\>\/XI2\<0\>\/XI2\<0\>\/XI2\<0\>\/RR7_pos \
 N_WLSEL\<1221\>_XI2\<1\>\/XI2\<0\>\/XI2\<0\>\/XI2\<1\>\/XI2\<1\>\/XI2\<0\>\/XI2\<0\>\/XI2\<0\>\/RR7_neg \
 ) R_1X_LL w=1e-07 l=1e-07   res=0.149966
XXI2\<1\>\/XI2\<0\>\/XI2\<0\>\/XI2\<1\>\/XI2\<1\>\/XI2\<0\>\/XI2\<0\>\/XI2\<0\>\/RR6 \
 (  \
 N_SEL6\<0\>_XI2\<1\>\/XI2\<0\>\/XI2\<0\>\/XI2\<1\>\/XI2\<1\>\/XI2\<0\>\/XI2\<0\>\/XI2\<0\>\/RR6_pos \
 N_WLSEL\<1222\>_XI2\<1\>\/XI2\<0\>\/XI2\<0\>\/XI2\<1\>\/XI2\<1\>\/XI2\<0\>\/XI2\<0\>\/XI2\<0\>\/RR6_neg \
 ) R_1X_LL w=1e-07 l=1e-07   res=0.149966
XXI2\<1\>\/XI2\<0\>\/XI2\<0\>\/XI2\<1\>\/XI2\<1\>\/XI2\<0\>\/XI2\<0\>\/XI2\<0\>\/RR5 \
 (  \
 N_SEL7\<1\>_XI2\<1\>\/XI2\<0\>\/XI2\<0\>\/XI2\<1\>\/XI2\<1\>\/XI2\<0\>\/XI2\<0\>\/XI2\<0\>\/RR5_pos \
 N_WLSEL\<1223\>_XI2\<1\>\/XI2\<0\>\/XI2\<0\>\/XI2\<1\>\/XI2\<1\>\/XI2\<0\>\/XI2\<0\>\/XI2\<0\>\/RR5_neg \
 ) R_1X_LL w=1e-07 l=1e-07   res=0.149966
XXI2\<1\>\/XI2\<0\>\/XI2\<0\>\/XI2\<1\>\/XI2\<1\>\/XI2\<0\>\/XI2\<0\>\/XI2\<1\>\/RR0 \
 (  \
 N_SEL0\<1\>_XI2\<1\>\/XI2\<0\>\/XI2\<0\>\/XI2\<1\>\/XI2\<1\>\/XI2\<0\>\/XI2\<0\>\/XI2\<1\>\/RR0_pos \
 N_WLSEL\<1224\>_XI2\<1\>\/XI2\<0\>\/XI2\<0\>\/XI2\<1\>\/XI2\<1\>\/XI2\<0\>\/XI2\<0\>\/XI2\<1\>\/RR0_neg \
 ) R_1X_LL w=1e-07 l=1e-07   res=0.149966
XXI2\<1\>\/XI2\<0\>\/XI2\<0\>\/XI2\<1\>\/XI2\<1\>\/XI2\<0\>\/XI2\<0\>\/XI2\<1\>\/RR1 \
 (  \
 N_SEL1\<0\>_XI2\<1\>\/XI2\<0\>\/XI2\<0\>\/XI2\<1\>\/XI2\<1\>\/XI2\<0\>\/XI2\<0\>\/XI2\<1\>\/RR1_pos \
 N_WLSEL\<1225\>_XI2\<1\>\/XI2\<0\>\/XI2\<0\>\/XI2\<1\>\/XI2\<1\>\/XI2\<0\>\/XI2\<0\>\/XI2\<1\>\/RR1_neg \
 ) R_1X_LL w=1e-07 l=1e-07   res=0.149966
XXI2\<1\>\/XI2\<0\>\/XI2\<0\>\/XI2\<1\>\/XI2\<1\>\/XI2\<0\>\/XI2\<0\>\/XI2\<1\>\/RR2 \
 (  \
 N_SEL2\<0\>_XI2\<1\>\/XI2\<0\>\/XI2\<0\>\/XI2\<1\>\/XI2\<1\>\/XI2\<0\>\/XI2\<0\>\/XI2\<1\>\/RR2_pos \
 N_WLSEL\<1226\>_XI2\<1\>\/XI2\<0\>\/XI2\<0\>\/XI2\<1\>\/XI2\<1\>\/XI2\<0\>\/XI2\<0\>\/XI2\<1\>\/RR2_neg \
 ) R_1X_LL w=1e-07 l=1e-07   res=0.149966
XXI2\<1\>\/XI2\<0\>\/XI2\<0\>\/XI2\<1\>\/XI2\<1\>\/XI2\<0\>\/XI2\<0\>\/XI2\<1\>\/RR3 \
 (  \
 N_SEL3\<1\>_XI2\<1\>\/XI2\<0\>\/XI2\<0\>\/XI2\<1\>\/XI2\<1\>\/XI2\<0\>\/XI2\<0\>\/XI2\<1\>\/RR3_pos \
 N_WLSEL\<1227\>_XI2\<1\>\/XI2\<0\>\/XI2\<0\>\/XI2\<1\>\/XI2\<1\>\/XI2\<0\>\/XI2\<0\>\/XI2\<1\>\/RR3_neg \
 ) R_1X_LL w=1e-07 l=1e-07   res=0.149966
XXI2\<1\>\/XI2\<0\>\/XI2\<0\>\/XI2\<1\>\/XI2\<1\>\/XI2\<0\>\/XI2\<0\>\/XI2\<1\>\/RR4 \
 (  \
 N_SEL4\<1\>_XI2\<1\>\/XI2\<0\>\/XI2\<0\>\/XI2\<1\>\/XI2\<1\>\/XI2\<0\>\/XI2\<0\>\/XI2\<1\>\/RR4_pos \
 N_WLSEL\<1228\>_XI2\<1\>\/XI2\<0\>\/XI2\<0\>\/XI2\<1\>\/XI2\<1\>\/XI2\<0\>\/XI2\<0\>\/XI2\<1\>\/RR4_neg \
 ) R_1X_LL w=1e-07 l=1e-07   res=0.149966
XXI2\<1\>\/XI2\<0\>\/XI2\<0\>\/XI2\<1\>\/XI2\<1\>\/XI2\<0\>\/XI2\<0\>\/XI2\<1\>\/RR7 \
 (  \
 N_SEL5\<0\>_XI2\<1\>\/XI2\<0\>\/XI2\<0\>\/XI2\<1\>\/XI2\<1\>\/XI2\<0\>\/XI2\<0\>\/XI2\<1\>\/RR7_pos \
 N_WLSEL\<1229\>_XI2\<1\>\/XI2\<0\>\/XI2\<0\>\/XI2\<1\>\/XI2\<1\>\/XI2\<0\>\/XI2\<0\>\/XI2\<1\>\/RR7_neg \
 ) R_1X_LL w=1e-07 l=1e-07   res=0.149966
XXI2\<1\>\/XI2\<0\>\/XI2\<0\>\/XI2\<1\>\/XI2\<1\>\/XI2\<0\>\/XI2\<0\>\/XI2\<1\>\/RR6 \
 (  \
 N_SEL6\<0\>_XI2\<1\>\/XI2\<0\>\/XI2\<0\>\/XI2\<1\>\/XI2\<1\>\/XI2\<0\>\/XI2\<0\>\/XI2\<1\>\/RR6_pos \
 N_WLSEL\<1230\>_XI2\<1\>\/XI2\<0\>\/XI2\<0\>\/XI2\<1\>\/XI2\<1\>\/XI2\<0\>\/XI2\<0\>\/XI2\<1\>\/RR6_neg \
 ) R_1X_LL w=1e-07 l=1e-07   res=0.149966
XXI2\<1\>\/XI2\<0\>\/XI2\<0\>\/XI2\<1\>\/XI2\<1\>\/XI2\<0\>\/XI2\<0\>\/XI2\<1\>\/RR5 \
 (  \
 N_SEL7\<1\>_XI2\<1\>\/XI2\<0\>\/XI2\<0\>\/XI2\<1\>\/XI2\<1\>\/XI2\<0\>\/XI2\<0\>\/XI2\<1\>\/RR5_pos \
 N_WLSEL\<1231\>_XI2\<1\>\/XI2\<0\>\/XI2\<0\>\/XI2\<1\>\/XI2\<1\>\/XI2\<0\>\/XI2\<0\>\/XI2\<1\>\/RR5_neg \
 ) R_1X_LL w=1e-07 l=1e-07   res=0.149966
XXI2\<1\>\/XI2\<0\>\/XI2\<0\>\/XI2\<1\>\/XI2\<1\>\/XI2\<0\>\/XI2\<1\>\/XI2\<0\>\/RR0 \
 (  \
 N_SEL0\<0\>_XI2\<1\>\/XI2\<0\>\/XI2\<0\>\/XI2\<1\>\/XI2\<1\>\/XI2\<0\>\/XI2\<1\>\/XI2\<0\>\/RR0_pos \
 N_WLSEL\<1232\>_XI2\<1\>\/XI2\<0\>\/XI2\<0\>\/XI2\<1\>\/XI2\<1\>\/XI2\<0\>\/XI2\<1\>\/XI2\<0\>\/RR0_neg \
 ) R_1X_LL w=1e-07 l=1e-07   res=0.149966
XXI2\<1\>\/XI2\<0\>\/XI2\<0\>\/XI2\<1\>\/XI2\<1\>\/XI2\<0\>\/XI2\<1\>\/XI2\<0\>\/RR1 \
 (  \
 N_SEL1\<1\>_XI2\<1\>\/XI2\<0\>\/XI2\<0\>\/XI2\<1\>\/XI2\<1\>\/XI2\<0\>\/XI2\<1\>\/XI2\<0\>\/RR1_pos \
 N_WLSEL\<1233\>_XI2\<1\>\/XI2\<0\>\/XI2\<0\>\/XI2\<1\>\/XI2\<1\>\/XI2\<0\>\/XI2\<1\>\/XI2\<0\>\/RR1_neg \
 ) R_1X_LL w=1e-07 l=1e-07   res=0.149966
XXI2\<1\>\/XI2\<0\>\/XI2\<0\>\/XI2\<1\>\/XI2\<1\>\/XI2\<0\>\/XI2\<1\>\/XI2\<0\>\/RR2 \
 (  \
 N_SEL2\<0\>_XI2\<1\>\/XI2\<0\>\/XI2\<0\>\/XI2\<1\>\/XI2\<1\>\/XI2\<0\>\/XI2\<1\>\/XI2\<0\>\/RR2_pos \
 N_WLSEL\<1234\>_XI2\<1\>\/XI2\<0\>\/XI2\<0\>\/XI2\<1\>\/XI2\<1\>\/XI2\<0\>\/XI2\<1\>\/XI2\<0\>\/RR2_neg \
 ) R_1X_LL w=1e-07 l=1e-07   res=0.149966
XXI2\<1\>\/XI2\<0\>\/XI2\<0\>\/XI2\<1\>\/XI2\<1\>\/XI2\<0\>\/XI2\<1\>\/XI2\<0\>\/RR3 \
 (  \
 N_SEL3\<1\>_XI2\<1\>\/XI2\<0\>\/XI2\<0\>\/XI2\<1\>\/XI2\<1\>\/XI2\<0\>\/XI2\<1\>\/XI2\<0\>\/RR3_pos \
 N_WLSEL\<1235\>_XI2\<1\>\/XI2\<0\>\/XI2\<0\>\/XI2\<1\>\/XI2\<1\>\/XI2\<0\>\/XI2\<1\>\/XI2\<0\>\/RR3_neg \
 ) R_1X_LL w=1e-07 l=1e-07   res=0.149966
XXI2\<1\>\/XI2\<0\>\/XI2\<0\>\/XI2\<1\>\/XI2\<1\>\/XI2\<0\>\/XI2\<1\>\/XI2\<0\>\/RR4 \
 (  \
 N_SEL4\<1\>_XI2\<1\>\/XI2\<0\>\/XI2\<0\>\/XI2\<1\>\/XI2\<1\>\/XI2\<0\>\/XI2\<1\>\/XI2\<0\>\/RR4_pos \
 N_WLSEL\<1236\>_XI2\<1\>\/XI2\<0\>\/XI2\<0\>\/XI2\<1\>\/XI2\<1\>\/XI2\<0\>\/XI2\<1\>\/XI2\<0\>\/RR4_neg \
 ) R_1X_LL w=1e-07 l=1e-07   res=0.149966
XXI2\<1\>\/XI2\<0\>\/XI2\<0\>\/XI2\<1\>\/XI2\<1\>\/XI2\<0\>\/XI2\<1\>\/XI2\<0\>\/RR7 \
 (  \
 N_SEL5\<0\>_XI2\<1\>\/XI2\<0\>\/XI2\<0\>\/XI2\<1\>\/XI2\<1\>\/XI2\<0\>\/XI2\<1\>\/XI2\<0\>\/RR7_pos \
 N_WLSEL\<1237\>_XI2\<1\>\/XI2\<0\>\/XI2\<0\>\/XI2\<1\>\/XI2\<1\>\/XI2\<0\>\/XI2\<1\>\/XI2\<0\>\/RR7_neg \
 ) R_1X_LL w=1e-07 l=1e-07   res=0.149966
XXI2\<1\>\/XI2\<0\>\/XI2\<0\>\/XI2\<1\>\/XI2\<1\>\/XI2\<0\>\/XI2\<1\>\/XI2\<0\>\/RR6 \
 (  \
 N_SEL6\<0\>_XI2\<1\>\/XI2\<0\>\/XI2\<0\>\/XI2\<1\>\/XI2\<1\>\/XI2\<0\>\/XI2\<1\>\/XI2\<0\>\/RR6_pos \
 N_WLSEL\<1238\>_XI2\<1\>\/XI2\<0\>\/XI2\<0\>\/XI2\<1\>\/XI2\<1\>\/XI2\<0\>\/XI2\<1\>\/XI2\<0\>\/RR6_neg \
 ) R_1X_LL w=1e-07 l=1e-07   res=0.149966
XXI2\<1\>\/XI2\<0\>\/XI2\<0\>\/XI2\<1\>\/XI2\<1\>\/XI2\<0\>\/XI2\<1\>\/XI2\<0\>\/RR5 \
 (  \
 N_SEL7\<1\>_XI2\<1\>\/XI2\<0\>\/XI2\<0\>\/XI2\<1\>\/XI2\<1\>\/XI2\<0\>\/XI2\<1\>\/XI2\<0\>\/RR5_pos \
 N_WLSEL\<1239\>_XI2\<1\>\/XI2\<0\>\/XI2\<0\>\/XI2\<1\>\/XI2\<1\>\/XI2\<0\>\/XI2\<1\>\/XI2\<0\>\/RR5_neg \
 ) R_1X_LL w=1e-07 l=1e-07   res=0.149966
XXI2\<1\>\/XI2\<0\>\/XI2\<0\>\/XI2\<1\>\/XI2\<1\>\/XI2\<0\>\/XI2\<1\>\/XI2\<1\>\/RR0 \
 (  \
 N_SEL0\<1\>_XI2\<1\>\/XI2\<0\>\/XI2\<0\>\/XI2\<1\>\/XI2\<1\>\/XI2\<0\>\/XI2\<1\>\/XI2\<1\>\/RR0_pos \
 N_WLSEL\<1240\>_XI2\<1\>\/XI2\<0\>\/XI2\<0\>\/XI2\<1\>\/XI2\<1\>\/XI2\<0\>\/XI2\<1\>\/XI2\<1\>\/RR0_neg \
 ) R_1X_LL w=1e-07 l=1e-07   res=0.149966
XXI2\<1\>\/XI2\<0\>\/XI2\<0\>\/XI2\<1\>\/XI2\<1\>\/XI2\<0\>\/XI2\<1\>\/XI2\<1\>\/RR1 \
 (  \
 N_SEL1\<1\>_XI2\<1\>\/XI2\<0\>\/XI2\<0\>\/XI2\<1\>\/XI2\<1\>\/XI2\<0\>\/XI2\<1\>\/XI2\<1\>\/RR1_pos \
 N_WLSEL\<1241\>_XI2\<1\>\/XI2\<0\>\/XI2\<0\>\/XI2\<1\>\/XI2\<1\>\/XI2\<0\>\/XI2\<1\>\/XI2\<1\>\/RR1_neg \
 ) R_1X_LL w=1e-07 l=1e-07   res=0.149966
XXI2\<1\>\/XI2\<0\>\/XI2\<0\>\/XI2\<1\>\/XI2\<1\>\/XI2\<0\>\/XI2\<1\>\/XI2\<1\>\/RR2 \
 (  \
 N_SEL2\<0\>_XI2\<1\>\/XI2\<0\>\/XI2\<0\>\/XI2\<1\>\/XI2\<1\>\/XI2\<0\>\/XI2\<1\>\/XI2\<1\>\/RR2_pos \
 N_WLSEL\<1242\>_XI2\<1\>\/XI2\<0\>\/XI2\<0\>\/XI2\<1\>\/XI2\<1\>\/XI2\<0\>\/XI2\<1\>\/XI2\<1\>\/RR2_neg \
 ) R_1X_LL w=1e-07 l=1e-07   res=0.149966
XXI2\<1\>\/XI2\<0\>\/XI2\<0\>\/XI2\<1\>\/XI2\<1\>\/XI2\<0\>\/XI2\<1\>\/XI2\<1\>\/RR3 \
 (  \
 N_SEL3\<1\>_XI2\<1\>\/XI2\<0\>\/XI2\<0\>\/XI2\<1\>\/XI2\<1\>\/XI2\<0\>\/XI2\<1\>\/XI2\<1\>\/RR3_pos \
 N_WLSEL\<1243\>_XI2\<1\>\/XI2\<0\>\/XI2\<0\>\/XI2\<1\>\/XI2\<1\>\/XI2\<0\>\/XI2\<1\>\/XI2\<1\>\/RR3_neg \
 ) R_1X_LL w=1e-07 l=1e-07   res=0.149966
XXI2\<1\>\/XI2\<0\>\/XI2\<0\>\/XI2\<1\>\/XI2\<1\>\/XI2\<0\>\/XI2\<1\>\/XI2\<1\>\/RR4 \
 (  \
 N_SEL4\<1\>_XI2\<1\>\/XI2\<0\>\/XI2\<0\>\/XI2\<1\>\/XI2\<1\>\/XI2\<0\>\/XI2\<1\>\/XI2\<1\>\/RR4_pos \
 N_WLSEL\<1244\>_XI2\<1\>\/XI2\<0\>\/XI2\<0\>\/XI2\<1\>\/XI2\<1\>\/XI2\<0\>\/XI2\<1\>\/XI2\<1\>\/RR4_neg \
 ) R_1X_LL w=1e-07 l=1e-07   res=0.149966
XXI2\<1\>\/XI2\<0\>\/XI2\<0\>\/XI2\<1\>\/XI2\<1\>\/XI2\<0\>\/XI2\<1\>\/XI2\<1\>\/RR7 \
 (  \
 N_SEL5\<0\>_XI2\<1\>\/XI2\<0\>\/XI2\<0\>\/XI2\<1\>\/XI2\<1\>\/XI2\<0\>\/XI2\<1\>\/XI2\<1\>\/RR7_pos \
 N_WLSEL\<1245\>_XI2\<1\>\/XI2\<0\>\/XI2\<0\>\/XI2\<1\>\/XI2\<1\>\/XI2\<0\>\/XI2\<1\>\/XI2\<1\>\/RR7_neg \
 ) R_1X_LL w=1e-07 l=1e-07   res=0.149966
XXI2\<1\>\/XI2\<0\>\/XI2\<0\>\/XI2\<1\>\/XI2\<1\>\/XI2\<0\>\/XI2\<1\>\/XI2\<1\>\/RR6 \
 (  \
 N_SEL6\<0\>_XI2\<1\>\/XI2\<0\>\/XI2\<0\>\/XI2\<1\>\/XI2\<1\>\/XI2\<0\>\/XI2\<1\>\/XI2\<1\>\/RR6_pos \
 N_WLSEL\<1246\>_XI2\<1\>\/XI2\<0\>\/XI2\<0\>\/XI2\<1\>\/XI2\<1\>\/XI2\<0\>\/XI2\<1\>\/XI2\<1\>\/RR6_neg \
 ) R_1X_LL w=1e-07 l=1e-07   res=0.149966
XXI2\<1\>\/XI2\<0\>\/XI2\<0\>\/XI2\<1\>\/XI2\<1\>\/XI2\<0\>\/XI2\<1\>\/XI2\<1\>\/RR5 \
 (  \
 N_SEL7\<1\>_XI2\<1\>\/XI2\<0\>\/XI2\<0\>\/XI2\<1\>\/XI2\<1\>\/XI2\<0\>\/XI2\<1\>\/XI2\<1\>\/RR5_pos \
 N_WLSEL\<1247\>_XI2\<1\>\/XI2\<0\>\/XI2\<0\>\/XI2\<1\>\/XI2\<1\>\/XI2\<0\>\/XI2\<1\>\/XI2\<1\>\/RR5_neg \
 ) R_1X_LL w=1e-07 l=1e-07   res=0.149966
XXI2\<1\>\/XI2\<0\>\/XI2\<0\>\/XI2\<1\>\/XI2\<1\>\/XI2\<1\>\/XI2\<0\>\/XI2\<0\>\/RR0 \
 (  \
 N_SEL0\<0\>_XI2\<1\>\/XI2\<0\>\/XI2\<0\>\/XI2\<1\>\/XI2\<1\>\/XI2\<1\>\/XI2\<0\>\/XI2\<0\>\/RR0_pos \
 N_WLSEL\<1248\>_XI2\<1\>\/XI2\<0\>\/XI2\<0\>\/XI2\<1\>\/XI2\<1\>\/XI2\<1\>\/XI2\<0\>\/XI2\<0\>\/RR0_neg \
 ) R_1X_LL w=1e-07 l=1e-07   res=0.149966
XXI2\<1\>\/XI2\<0\>\/XI2\<0\>\/XI2\<1\>\/XI2\<1\>\/XI2\<1\>\/XI2\<0\>\/XI2\<0\>\/RR1 \
 (  \
 N_SEL1\<0\>_XI2\<1\>\/XI2\<0\>\/XI2\<0\>\/XI2\<1\>\/XI2\<1\>\/XI2\<1\>\/XI2\<0\>\/XI2\<0\>\/RR1_pos \
 N_WLSEL\<1249\>_XI2\<1\>\/XI2\<0\>\/XI2\<0\>\/XI2\<1\>\/XI2\<1\>\/XI2\<1\>\/XI2\<0\>\/XI2\<0\>\/RR1_neg \
 ) R_1X_LL w=1e-07 l=1e-07   res=0.149966
XXI2\<1\>\/XI2\<0\>\/XI2\<0\>\/XI2\<1\>\/XI2\<1\>\/XI2\<1\>\/XI2\<0\>\/XI2\<0\>\/RR2 \
 (  \
 N_SEL2\<1\>_XI2\<1\>\/XI2\<0\>\/XI2\<0\>\/XI2\<1\>\/XI2\<1\>\/XI2\<1\>\/XI2\<0\>\/XI2\<0\>\/RR2_pos \
 N_WLSEL\<1250\>_XI2\<1\>\/XI2\<0\>\/XI2\<0\>\/XI2\<1\>\/XI2\<1\>\/XI2\<1\>\/XI2\<0\>\/XI2\<0\>\/RR2_neg \
 ) R_1X_LL w=1e-07 l=1e-07   res=0.149966
XXI2\<1\>\/XI2\<0\>\/XI2\<0\>\/XI2\<1\>\/XI2\<1\>\/XI2\<1\>\/XI2\<0\>\/XI2\<0\>\/RR3 \
 (  \
 N_SEL3\<1\>_XI2\<1\>\/XI2\<0\>\/XI2\<0\>\/XI2\<1\>\/XI2\<1\>\/XI2\<1\>\/XI2\<0\>\/XI2\<0\>\/RR3_pos \
 N_WLSEL\<1251\>_XI2\<1\>\/XI2\<0\>\/XI2\<0\>\/XI2\<1\>\/XI2\<1\>\/XI2\<1\>\/XI2\<0\>\/XI2\<0\>\/RR3_neg \
 ) R_1X_LL w=1e-07 l=1e-07   res=0.149966
XXI2\<1\>\/XI2\<0\>\/XI2\<0\>\/XI2\<1\>\/XI2\<1\>\/XI2\<1\>\/XI2\<0\>\/XI2\<0\>\/RR4 \
 (  \
 N_SEL4\<1\>_XI2\<1\>\/XI2\<0\>\/XI2\<0\>\/XI2\<1\>\/XI2\<1\>\/XI2\<1\>\/XI2\<0\>\/XI2\<0\>\/RR4_pos \
 N_WLSEL\<1252\>_XI2\<1\>\/XI2\<0\>\/XI2\<0\>\/XI2\<1\>\/XI2\<1\>\/XI2\<1\>\/XI2\<0\>\/XI2\<0\>\/RR4_neg \
 ) R_1X_LL w=1e-07 l=1e-07   res=0.149966
XXI2\<1\>\/XI2\<0\>\/XI2\<0\>\/XI2\<1\>\/XI2\<1\>\/XI2\<1\>\/XI2\<0\>\/XI2\<0\>\/RR7 \
 (  \
 N_SEL5\<0\>_XI2\<1\>\/XI2\<0\>\/XI2\<0\>\/XI2\<1\>\/XI2\<1\>\/XI2\<1\>\/XI2\<0\>\/XI2\<0\>\/RR7_pos \
 N_WLSEL\<1253\>_XI2\<1\>\/XI2\<0\>\/XI2\<0\>\/XI2\<1\>\/XI2\<1\>\/XI2\<1\>\/XI2\<0\>\/XI2\<0\>\/RR7_neg \
 ) R_1X_LL w=1e-07 l=1e-07   res=0.149966
XXI2\<1\>\/XI2\<0\>\/XI2\<0\>\/XI2\<1\>\/XI2\<1\>\/XI2\<1\>\/XI2\<0\>\/XI2\<0\>\/RR6 \
 (  \
 N_SEL6\<0\>_XI2\<1\>\/XI2\<0\>\/XI2\<0\>\/XI2\<1\>\/XI2\<1\>\/XI2\<1\>\/XI2\<0\>\/XI2\<0\>\/RR6_pos \
 N_WLSEL\<1254\>_XI2\<1\>\/XI2\<0\>\/XI2\<0\>\/XI2\<1\>\/XI2\<1\>\/XI2\<1\>\/XI2\<0\>\/XI2\<0\>\/RR6_neg \
 ) R_1X_LL w=1e-07 l=1e-07   res=0.149966
XXI2\<1\>\/XI2\<0\>\/XI2\<0\>\/XI2\<1\>\/XI2\<1\>\/XI2\<1\>\/XI2\<0\>\/XI2\<0\>\/RR5 \
 (  \
 N_SEL7\<1\>_XI2\<1\>\/XI2\<0\>\/XI2\<0\>\/XI2\<1\>\/XI2\<1\>\/XI2\<1\>\/XI2\<0\>\/XI2\<0\>\/RR5_pos \
 N_WLSEL\<1255\>_XI2\<1\>\/XI2\<0\>\/XI2\<0\>\/XI2\<1\>\/XI2\<1\>\/XI2\<1\>\/XI2\<0\>\/XI2\<0\>\/RR5_neg \
 ) R_1X_LL w=1e-07 l=1e-07   res=0.149966
XXI2\<1\>\/XI2\<0\>\/XI2\<0\>\/XI2\<1\>\/XI2\<1\>\/XI2\<1\>\/XI2\<0\>\/XI2\<1\>\/RR0 \
 (  \
 N_SEL0\<1\>_XI2\<1\>\/XI2\<0\>\/XI2\<0\>\/XI2\<1\>\/XI2\<1\>\/XI2\<1\>\/XI2\<0\>\/XI2\<1\>\/RR0_pos \
 N_WLSEL\<1256\>_XI2\<1\>\/XI2\<0\>\/XI2\<0\>\/XI2\<1\>\/XI2\<1\>\/XI2\<1\>\/XI2\<0\>\/XI2\<1\>\/RR0_neg \
 ) R_1X_LL w=1e-07 l=1e-07   res=0.149966
XXI2\<1\>\/XI2\<0\>\/XI2\<0\>\/XI2\<1\>\/XI2\<1\>\/XI2\<1\>\/XI2\<0\>\/XI2\<1\>\/RR1 \
 (  \
 N_SEL1\<0\>_XI2\<1\>\/XI2\<0\>\/XI2\<0\>\/XI2\<1\>\/XI2\<1\>\/XI2\<1\>\/XI2\<0\>\/XI2\<1\>\/RR1_pos \
 N_WLSEL\<1257\>_XI2\<1\>\/XI2\<0\>\/XI2\<0\>\/XI2\<1\>\/XI2\<1\>\/XI2\<1\>\/XI2\<0\>\/XI2\<1\>\/RR1_neg \
 ) R_1X_LL w=1e-07 l=1e-07   res=0.149966
XXI2\<1\>\/XI2\<0\>\/XI2\<0\>\/XI2\<1\>\/XI2\<1\>\/XI2\<1\>\/XI2\<0\>\/XI2\<1\>\/RR2 \
 (  \
 N_SEL2\<1\>_XI2\<1\>\/XI2\<0\>\/XI2\<0\>\/XI2\<1\>\/XI2\<1\>\/XI2\<1\>\/XI2\<0\>\/XI2\<1\>\/RR2_pos \
 N_WLSEL\<1258\>_XI2\<1\>\/XI2\<0\>\/XI2\<0\>\/XI2\<1\>\/XI2\<1\>\/XI2\<1\>\/XI2\<0\>\/XI2\<1\>\/RR2_neg \
 ) R_1X_LL w=1e-07 l=1e-07   res=0.149966
XXI2\<1\>\/XI2\<0\>\/XI2\<0\>\/XI2\<1\>\/XI2\<1\>\/XI2\<1\>\/XI2\<0\>\/XI2\<1\>\/RR3 \
 (  \
 N_SEL3\<1\>_XI2\<1\>\/XI2\<0\>\/XI2\<0\>\/XI2\<1\>\/XI2\<1\>\/XI2\<1\>\/XI2\<0\>\/XI2\<1\>\/RR3_pos \
 N_WLSEL\<1259\>_XI2\<1\>\/XI2\<0\>\/XI2\<0\>\/XI2\<1\>\/XI2\<1\>\/XI2\<1\>\/XI2\<0\>\/XI2\<1\>\/RR3_neg \
 ) R_1X_LL w=1e-07 l=1e-07   res=0.149966
XXI2\<1\>\/XI2\<0\>\/XI2\<0\>\/XI2\<1\>\/XI2\<1\>\/XI2\<1\>\/XI2\<0\>\/XI2\<1\>\/RR4 \
 (  \
 N_SEL4\<1\>_XI2\<1\>\/XI2\<0\>\/XI2\<0\>\/XI2\<1\>\/XI2\<1\>\/XI2\<1\>\/XI2\<0\>\/XI2\<1\>\/RR4_pos \
 N_WLSEL\<1260\>_XI2\<1\>\/XI2\<0\>\/XI2\<0\>\/XI2\<1\>\/XI2\<1\>\/XI2\<1\>\/XI2\<0\>\/XI2\<1\>\/RR4_neg \
 ) R_1X_LL w=1e-07 l=1e-07   res=0.149966
XXI2\<1\>\/XI2\<0\>\/XI2\<0\>\/XI2\<1\>\/XI2\<1\>\/XI2\<1\>\/XI2\<0\>\/XI2\<1\>\/RR7 \
 (  \
 N_SEL5\<0\>_XI2\<1\>\/XI2\<0\>\/XI2\<0\>\/XI2\<1\>\/XI2\<1\>\/XI2\<1\>\/XI2\<0\>\/XI2\<1\>\/RR7_pos \
 N_WLSEL\<1261\>_XI2\<1\>\/XI2\<0\>\/XI2\<0\>\/XI2\<1\>\/XI2\<1\>\/XI2\<1\>\/XI2\<0\>\/XI2\<1\>\/RR7_neg \
 ) R_1X_LL w=1e-07 l=1e-07   res=0.149966
XXI2\<1\>\/XI2\<0\>\/XI2\<0\>\/XI2\<1\>\/XI2\<1\>\/XI2\<1\>\/XI2\<0\>\/XI2\<1\>\/RR6 \
 (  \
 N_SEL6\<0\>_XI2\<1\>\/XI2\<0\>\/XI2\<0\>\/XI2\<1\>\/XI2\<1\>\/XI2\<1\>\/XI2\<0\>\/XI2\<1\>\/RR6_pos \
 N_WLSEL\<1262\>_XI2\<1\>\/XI2\<0\>\/XI2\<0\>\/XI2\<1\>\/XI2\<1\>\/XI2\<1\>\/XI2\<0\>\/XI2\<1\>\/RR6_neg \
 ) R_1X_LL w=1e-07 l=1e-07   res=0.149966
XXI2\<1\>\/XI2\<0\>\/XI2\<0\>\/XI2\<1\>\/XI2\<1\>\/XI2\<1\>\/XI2\<0\>\/XI2\<1\>\/RR5 \
 (  \
 N_SEL7\<1\>_XI2\<1\>\/XI2\<0\>\/XI2\<0\>\/XI2\<1\>\/XI2\<1\>\/XI2\<1\>\/XI2\<0\>\/XI2\<1\>\/RR5_pos \
 N_WLSEL\<1263\>_XI2\<1\>\/XI2\<0\>\/XI2\<0\>\/XI2\<1\>\/XI2\<1\>\/XI2\<1\>\/XI2\<0\>\/XI2\<1\>\/RR5_neg \
 ) R_1X_LL w=1e-07 l=1e-07   res=0.149966
XXI2\<1\>\/XI2\<0\>\/XI2\<0\>\/XI2\<1\>\/XI2\<1\>\/XI2\<1\>\/XI2\<1\>\/XI2\<0\>\/RR0 \
 (  \
 N_SEL0\<0\>_XI2\<1\>\/XI2\<0\>\/XI2\<0\>\/XI2\<1\>\/XI2\<1\>\/XI2\<1\>\/XI2\<1\>\/XI2\<0\>\/RR0_pos \
 N_WLSEL\<1264\>_XI2\<1\>\/XI2\<0\>\/XI2\<0\>\/XI2\<1\>\/XI2\<1\>\/XI2\<1\>\/XI2\<1\>\/XI2\<0\>\/RR0_neg \
 ) R_1X_LL w=1e-07 l=1e-07   res=0.149966
XXI2\<1\>\/XI2\<0\>\/XI2\<0\>\/XI2\<1\>\/XI2\<1\>\/XI2\<1\>\/XI2\<1\>\/XI2\<0\>\/RR1 \
 (  \
 N_SEL1\<1\>_XI2\<1\>\/XI2\<0\>\/XI2\<0\>\/XI2\<1\>\/XI2\<1\>\/XI2\<1\>\/XI2\<1\>\/XI2\<0\>\/RR1_pos \
 N_WLSEL\<1265\>_XI2\<1\>\/XI2\<0\>\/XI2\<0\>\/XI2\<1\>\/XI2\<1\>\/XI2\<1\>\/XI2\<1\>\/XI2\<0\>\/RR1_neg \
 ) R_1X_LL w=1e-07 l=1e-07   res=0.149966
XXI2\<1\>\/XI2\<0\>\/XI2\<0\>\/XI2\<1\>\/XI2\<1\>\/XI2\<1\>\/XI2\<1\>\/XI2\<0\>\/RR2 \
 (  \
 N_SEL2\<1\>_XI2\<1\>\/XI2\<0\>\/XI2\<0\>\/XI2\<1\>\/XI2\<1\>\/XI2\<1\>\/XI2\<1\>\/XI2\<0\>\/RR2_pos \
 N_WLSEL\<1266\>_XI2\<1\>\/XI2\<0\>\/XI2\<0\>\/XI2\<1\>\/XI2\<1\>\/XI2\<1\>\/XI2\<1\>\/XI2\<0\>\/RR2_neg \
 ) R_1X_LL w=1e-07 l=1e-07   res=0.149966
XXI2\<1\>\/XI2\<0\>\/XI2\<0\>\/XI2\<1\>\/XI2\<1\>\/XI2\<1\>\/XI2\<1\>\/XI2\<0\>\/RR3 \
 (  \
 N_SEL3\<1\>_XI2\<1\>\/XI2\<0\>\/XI2\<0\>\/XI2\<1\>\/XI2\<1\>\/XI2\<1\>\/XI2\<1\>\/XI2\<0\>\/RR3_pos \
 N_WLSEL\<1267\>_XI2\<1\>\/XI2\<0\>\/XI2\<0\>\/XI2\<1\>\/XI2\<1\>\/XI2\<1\>\/XI2\<1\>\/XI2\<0\>\/RR3_neg \
 ) R_1X_LL w=1e-07 l=1e-07   res=0.149966
XXI2\<1\>\/XI2\<0\>\/XI2\<0\>\/XI2\<1\>\/XI2\<1\>\/XI2\<1\>\/XI2\<1\>\/XI2\<0\>\/RR4 \
 (  \
 N_SEL4\<1\>_XI2\<1\>\/XI2\<0\>\/XI2\<0\>\/XI2\<1\>\/XI2\<1\>\/XI2\<1\>\/XI2\<1\>\/XI2\<0\>\/RR4_pos \
 N_WLSEL\<1268\>_XI2\<1\>\/XI2\<0\>\/XI2\<0\>\/XI2\<1\>\/XI2\<1\>\/XI2\<1\>\/XI2\<1\>\/XI2\<0\>\/RR4_neg \
 ) R_1X_LL w=1e-07 l=1e-07   res=0.149966
XXI2\<1\>\/XI2\<0\>\/XI2\<0\>\/XI2\<1\>\/XI2\<1\>\/XI2\<1\>\/XI2\<1\>\/XI2\<0\>\/RR7 \
 (  \
 N_SEL5\<0\>_XI2\<1\>\/XI2\<0\>\/XI2\<0\>\/XI2\<1\>\/XI2\<1\>\/XI2\<1\>\/XI2\<1\>\/XI2\<0\>\/RR7_pos \
 N_WLSEL\<1269\>_XI2\<1\>\/XI2\<0\>\/XI2\<0\>\/XI2\<1\>\/XI2\<1\>\/XI2\<1\>\/XI2\<1\>\/XI2\<0\>\/RR7_neg \
 ) R_1X_LL w=1e-07 l=1e-07   res=0.149966
XXI2\<1\>\/XI2\<0\>\/XI2\<0\>\/XI2\<1\>\/XI2\<1\>\/XI2\<1\>\/XI2\<1\>\/XI2\<0\>\/RR6 \
 (  \
 N_SEL6\<0\>_XI2\<1\>\/XI2\<0\>\/XI2\<0\>\/XI2\<1\>\/XI2\<1\>\/XI2\<1\>\/XI2\<1\>\/XI2\<0\>\/RR6_pos \
 N_WLSEL\<1270\>_XI2\<1\>\/XI2\<0\>\/XI2\<0\>\/XI2\<1\>\/XI2\<1\>\/XI2\<1\>\/XI2\<1\>\/XI2\<0\>\/RR6_neg \
 ) R_1X_LL w=1e-07 l=1e-07   res=0.149966
XXI2\<1\>\/XI2\<0\>\/XI2\<0\>\/XI2\<1\>\/XI2\<1\>\/XI2\<1\>\/XI2\<1\>\/XI2\<0\>\/RR5 \
 (  \
 N_SEL7\<1\>_XI2\<1\>\/XI2\<0\>\/XI2\<0\>\/XI2\<1\>\/XI2\<1\>\/XI2\<1\>\/XI2\<1\>\/XI2\<0\>\/RR5_pos \
 N_WLSEL\<1271\>_XI2\<1\>\/XI2\<0\>\/XI2\<0\>\/XI2\<1\>\/XI2\<1\>\/XI2\<1\>\/XI2\<1\>\/XI2\<0\>\/RR5_neg \
 ) R_1X_LL w=1e-07 l=1e-07   res=0.149966
XXI2\<1\>\/XI2\<0\>\/XI2\<0\>\/XI2\<1\>\/XI2\<1\>\/XI2\<1\>\/XI2\<1\>\/XI2\<1\>\/RR0 \
 (  \
 N_SEL0\<1\>_XI2\<1\>\/XI2\<0\>\/XI2\<0\>\/XI2\<1\>\/XI2\<1\>\/XI2\<1\>\/XI2\<1\>\/XI2\<1\>\/RR0_pos \
 N_WLSEL\<1272\>_XI2\<1\>\/XI2\<0\>\/XI2\<0\>\/XI2\<1\>\/XI2\<1\>\/XI2\<1\>\/XI2\<1\>\/XI2\<1\>\/RR0_neg \
 ) R_1X_LL w=1e-07 l=1e-07   res=0.149966
XXI2\<1\>\/XI2\<0\>\/XI2\<0\>\/XI2\<1\>\/XI2\<1\>\/XI2\<1\>\/XI2\<1\>\/XI2\<1\>\/RR1 \
 (  \
 N_SEL1\<1\>_XI2\<1\>\/XI2\<0\>\/XI2\<0\>\/XI2\<1\>\/XI2\<1\>\/XI2\<1\>\/XI2\<1\>\/XI2\<1\>\/RR1_pos \
 N_WLSEL\<1273\>_XI2\<1\>\/XI2\<0\>\/XI2\<0\>\/XI2\<1\>\/XI2\<1\>\/XI2\<1\>\/XI2\<1\>\/XI2\<1\>\/RR1_neg \
 ) R_1X_LL w=1e-07 l=1e-07   res=0.149966
XXI2\<1\>\/XI2\<0\>\/XI2\<0\>\/XI2\<1\>\/XI2\<1\>\/XI2\<1\>\/XI2\<1\>\/XI2\<1\>\/RR2 \
 (  \
 N_SEL2\<1\>_XI2\<1\>\/XI2\<0\>\/XI2\<0\>\/XI2\<1\>\/XI2\<1\>\/XI2\<1\>\/XI2\<1\>\/XI2\<1\>\/RR2_pos \
 N_WLSEL\<1274\>_XI2\<1\>\/XI2\<0\>\/XI2\<0\>\/XI2\<1\>\/XI2\<1\>\/XI2\<1\>\/XI2\<1\>\/XI2\<1\>\/RR2_neg \
 ) R_1X_LL w=1e-07 l=1e-07   res=0.149966
XXI2\<1\>\/XI2\<0\>\/XI2\<0\>\/XI2\<1\>\/XI2\<1\>\/XI2\<1\>\/XI2\<1\>\/XI2\<1\>\/RR3 \
 (  \
 N_SEL3\<1\>_XI2\<1\>\/XI2\<0\>\/XI2\<0\>\/XI2\<1\>\/XI2\<1\>\/XI2\<1\>\/XI2\<1\>\/XI2\<1\>\/RR3_pos \
 N_WLSEL\<1275\>_XI2\<1\>\/XI2\<0\>\/XI2\<0\>\/XI2\<1\>\/XI2\<1\>\/XI2\<1\>\/XI2\<1\>\/XI2\<1\>\/RR3_neg \
 ) R_1X_LL w=1e-07 l=1e-07   res=0.149966
XXI2\<1\>\/XI2\<0\>\/XI2\<0\>\/XI2\<1\>\/XI2\<1\>\/XI2\<1\>\/XI2\<1\>\/XI2\<1\>\/RR4 \
 (  \
 N_SEL4\<1\>_XI2\<1\>\/XI2\<0\>\/XI2\<0\>\/XI2\<1\>\/XI2\<1\>\/XI2\<1\>\/XI2\<1\>\/XI2\<1\>\/RR4_pos \
 N_WLSEL\<1276\>_XI2\<1\>\/XI2\<0\>\/XI2\<0\>\/XI2\<1\>\/XI2\<1\>\/XI2\<1\>\/XI2\<1\>\/XI2\<1\>\/RR4_neg \
 ) R_1X_LL w=1e-07 l=1e-07   res=0.149966
XXI2\<1\>\/XI2\<0\>\/XI2\<0\>\/XI2\<1\>\/XI2\<1\>\/XI2\<1\>\/XI2\<1\>\/XI2\<1\>\/RR7 \
 (  \
 N_SEL5\<0\>_XI2\<1\>\/XI2\<0\>\/XI2\<0\>\/XI2\<1\>\/XI2\<1\>\/XI2\<1\>\/XI2\<1\>\/XI2\<1\>\/RR7_pos \
 N_WLSEL\<1277\>_XI2\<1\>\/XI2\<0\>\/XI2\<0\>\/XI2\<1\>\/XI2\<1\>\/XI2\<1\>\/XI2\<1\>\/XI2\<1\>\/RR7_neg \
 ) R_1X_LL w=1e-07 l=1e-07   res=0.149966
XXI2\<1\>\/XI2\<0\>\/XI2\<0\>\/XI2\<1\>\/XI2\<1\>\/XI2\<1\>\/XI2\<1\>\/XI2\<1\>\/RR6 \
 (  \
 N_SEL6\<0\>_XI2\<1\>\/XI2\<0\>\/XI2\<0\>\/XI2\<1\>\/XI2\<1\>\/XI2\<1\>\/XI2\<1\>\/XI2\<1\>\/RR6_pos \
 N_WLSEL\<1278\>_XI2\<1\>\/XI2\<0\>\/XI2\<0\>\/XI2\<1\>\/XI2\<1\>\/XI2\<1\>\/XI2\<1\>\/XI2\<1\>\/RR6_neg \
 ) R_1X_LL w=1e-07 l=1e-07   res=0.149966
XXI2\<1\>\/XI2\<0\>\/XI2\<0\>\/XI2\<1\>\/XI2\<1\>\/XI2\<1\>\/XI2\<1\>\/XI2\<1\>\/RR5 \
 (  \
 N_SEL7\<1\>_XI2\<1\>\/XI2\<0\>\/XI2\<0\>\/XI2\<1\>\/XI2\<1\>\/XI2\<1\>\/XI2\<1\>\/XI2\<1\>\/RR5_pos \
 N_WLSEL\<1279\>_XI2\<1\>\/XI2\<0\>\/XI2\<0\>\/XI2\<1\>\/XI2\<1\>\/XI2\<1\>\/XI2\<1\>\/XI2\<1\>\/RR5_neg \
 ) R_1X_LL w=1e-07 l=1e-07   res=0.149966
XXI2\<1\>\/XI2\<0\>\/XI2\<1\>\/XI2\<0\>\/XI2\<0\>\/XI2\<0\>\/XI2\<0\>\/XI2\<0\>\/RR0 \
 (  \
 N_SEL0\<0\>_XI2\<1\>\/XI2\<0\>\/XI2\<1\>\/XI2\<0\>\/XI2\<0\>\/XI2\<0\>\/XI2\<0\>\/XI2\<0\>\/RR0_pos \
 N_WLSEL\<1280\>_XI2\<1\>\/XI2\<0\>\/XI2\<1\>\/XI2\<0\>\/XI2\<0\>\/XI2\<0\>\/XI2\<0\>\/XI2\<0\>\/RR0_neg \
 ) R_1X_LL w=1e-07 l=1e-07   res=0.149966
XXI2\<1\>\/XI2\<0\>\/XI2\<1\>\/XI2\<0\>\/XI2\<0\>\/XI2\<0\>\/XI2\<0\>\/XI2\<0\>\/RR1 \
 (  \
 N_SEL1\<0\>_XI2\<1\>\/XI2\<0\>\/XI2\<1\>\/XI2\<0\>\/XI2\<0\>\/XI2\<0\>\/XI2\<0\>\/XI2\<0\>\/RR1_pos \
 N_WLSEL\<1281\>_XI2\<1\>\/XI2\<0\>\/XI2\<1\>\/XI2\<0\>\/XI2\<0\>\/XI2\<0\>\/XI2\<0\>\/XI2\<0\>\/RR1_neg \
 ) R_1X_LL w=1e-07 l=1e-07   res=0.149966
XXI2\<1\>\/XI2\<0\>\/XI2\<1\>\/XI2\<0\>\/XI2\<0\>\/XI2\<0\>\/XI2\<0\>\/XI2\<0\>\/RR2 \
 (  \
 N_SEL2\<0\>_XI2\<1\>\/XI2\<0\>\/XI2\<1\>\/XI2\<0\>\/XI2\<0\>\/XI2\<0\>\/XI2\<0\>\/XI2\<0\>\/RR2_pos \
 N_WLSEL\<1282\>_XI2\<1\>\/XI2\<0\>\/XI2\<1\>\/XI2\<0\>\/XI2\<0\>\/XI2\<0\>\/XI2\<0\>\/XI2\<0\>\/RR2_neg \
 ) R_1X_LL w=1e-07 l=1e-07   res=0.149966
XXI2\<1\>\/XI2\<0\>\/XI2\<1\>\/XI2\<0\>\/XI2\<0\>\/XI2\<0\>\/XI2\<0\>\/XI2\<0\>\/RR3 \
 (  \
 N_SEL3\<0\>_XI2\<1\>\/XI2\<0\>\/XI2\<1\>\/XI2\<0\>\/XI2\<0\>\/XI2\<0\>\/XI2\<0\>\/XI2\<0\>\/RR3_pos \
 N_WLSEL\<1283\>_XI2\<1\>\/XI2\<0\>\/XI2\<1\>\/XI2\<0\>\/XI2\<0\>\/XI2\<0\>\/XI2\<0\>\/XI2\<0\>\/RR3_neg \
 ) R_1X_LL w=1e-07 l=1e-07   res=0.149966
XXI2\<1\>\/XI2\<0\>\/XI2\<1\>\/XI2\<0\>\/XI2\<0\>\/XI2\<0\>\/XI2\<0\>\/XI2\<0\>\/RR4 \
 (  \
 N_SEL4\<0\>_XI2\<1\>\/XI2\<0\>\/XI2\<1\>\/XI2\<0\>\/XI2\<0\>\/XI2\<0\>\/XI2\<0\>\/XI2\<0\>\/RR4_pos \
 N_WLSEL\<1284\>_XI2\<1\>\/XI2\<0\>\/XI2\<1\>\/XI2\<0\>\/XI2\<0\>\/XI2\<0\>\/XI2\<0\>\/XI2\<0\>\/RR4_neg \
 ) R_1X_LL w=1e-07 l=1e-07   res=0.149966
XXI2\<1\>\/XI2\<0\>\/XI2\<1\>\/XI2\<0\>\/XI2\<0\>\/XI2\<0\>\/XI2\<0\>\/XI2\<0\>\/RR7 \
 (  \
 N_SEL5\<1\>_XI2\<1\>\/XI2\<0\>\/XI2\<1\>\/XI2\<0\>\/XI2\<0\>\/XI2\<0\>\/XI2\<0\>\/XI2\<0\>\/RR7_pos \
 N_WLSEL\<1285\>_XI2\<1\>\/XI2\<0\>\/XI2\<1\>\/XI2\<0\>\/XI2\<0\>\/XI2\<0\>\/XI2\<0\>\/XI2\<0\>\/RR7_neg \
 ) R_1X_LL w=1e-07 l=1e-07   res=0.149966
XXI2\<1\>\/XI2\<0\>\/XI2\<1\>\/XI2\<0\>\/XI2\<0\>\/XI2\<0\>\/XI2\<0\>\/XI2\<0\>\/RR6 \
 (  \
 N_SEL6\<0\>_XI2\<1\>\/XI2\<0\>\/XI2\<1\>\/XI2\<0\>\/XI2\<0\>\/XI2\<0\>\/XI2\<0\>\/XI2\<0\>\/RR6_pos \
 N_WLSEL\<1286\>_XI2\<1\>\/XI2\<0\>\/XI2\<1\>\/XI2\<0\>\/XI2\<0\>\/XI2\<0\>\/XI2\<0\>\/XI2\<0\>\/RR6_neg \
 ) R_1X_LL w=1e-07 l=1e-07   res=0.149966
XXI2\<1\>\/XI2\<0\>\/XI2\<1\>\/XI2\<0\>\/XI2\<0\>\/XI2\<0\>\/XI2\<0\>\/XI2\<0\>\/RR5 \
 (  \
 N_SEL7\<1\>_XI2\<1\>\/XI2\<0\>\/XI2\<1\>\/XI2\<0\>\/XI2\<0\>\/XI2\<0\>\/XI2\<0\>\/XI2\<0\>\/RR5_pos \
 N_WLSEL\<1287\>_XI2\<1\>\/XI2\<0\>\/XI2\<1\>\/XI2\<0\>\/XI2\<0\>\/XI2\<0\>\/XI2\<0\>\/XI2\<0\>\/RR5_neg \
 ) R_1X_LL w=1e-07 l=1e-07   res=0.149966
XXI2\<1\>\/XI2\<0\>\/XI2\<1\>\/XI2\<0\>\/XI2\<0\>\/XI2\<0\>\/XI2\<0\>\/XI2\<1\>\/RR0 \
 (  \
 N_SEL0\<1\>_XI2\<1\>\/XI2\<0\>\/XI2\<1\>\/XI2\<0\>\/XI2\<0\>\/XI2\<0\>\/XI2\<0\>\/XI2\<1\>\/RR0_pos \
 N_WLSEL\<1288\>_XI2\<1\>\/XI2\<0\>\/XI2\<1\>\/XI2\<0\>\/XI2\<0\>\/XI2\<0\>\/XI2\<0\>\/XI2\<1\>\/RR0_neg \
 ) R_1X_LL w=1e-07 l=1e-07   res=0.149966
XXI2\<1\>\/XI2\<0\>\/XI2\<1\>\/XI2\<0\>\/XI2\<0\>\/XI2\<0\>\/XI2\<0\>\/XI2\<1\>\/RR1 \
 (  \
 N_SEL1\<0\>_XI2\<1\>\/XI2\<0\>\/XI2\<1\>\/XI2\<0\>\/XI2\<0\>\/XI2\<0\>\/XI2\<0\>\/XI2\<1\>\/RR1_pos \
 N_WLSEL\<1289\>_XI2\<1\>\/XI2\<0\>\/XI2\<1\>\/XI2\<0\>\/XI2\<0\>\/XI2\<0\>\/XI2\<0\>\/XI2\<1\>\/RR1_neg \
 ) R_1X_LL w=1e-07 l=1e-07   res=0.149966
XXI2\<1\>\/XI2\<0\>\/XI2\<1\>\/XI2\<0\>\/XI2\<0\>\/XI2\<0\>\/XI2\<0\>\/XI2\<1\>\/RR2 \
 (  \
 N_SEL2\<0\>_XI2\<1\>\/XI2\<0\>\/XI2\<1\>\/XI2\<0\>\/XI2\<0\>\/XI2\<0\>\/XI2\<0\>\/XI2\<1\>\/RR2_pos \
 N_WLSEL\<1290\>_XI2\<1\>\/XI2\<0\>\/XI2\<1\>\/XI2\<0\>\/XI2\<0\>\/XI2\<0\>\/XI2\<0\>\/XI2\<1\>\/RR2_neg \
 ) R_1X_LL w=1e-07 l=1e-07   res=0.149966
XXI2\<1\>\/XI2\<0\>\/XI2\<1\>\/XI2\<0\>\/XI2\<0\>\/XI2\<0\>\/XI2\<0\>\/XI2\<1\>\/RR3 \
 (  \
 N_SEL3\<0\>_XI2\<1\>\/XI2\<0\>\/XI2\<1\>\/XI2\<0\>\/XI2\<0\>\/XI2\<0\>\/XI2\<0\>\/XI2\<1\>\/RR3_pos \
 N_WLSEL\<1291\>_XI2\<1\>\/XI2\<0\>\/XI2\<1\>\/XI2\<0\>\/XI2\<0\>\/XI2\<0\>\/XI2\<0\>\/XI2\<1\>\/RR3_neg \
 ) R_1X_LL w=1e-07 l=1e-07   res=0.149966
XXI2\<1\>\/XI2\<0\>\/XI2\<1\>\/XI2\<0\>\/XI2\<0\>\/XI2\<0\>\/XI2\<0\>\/XI2\<1\>\/RR4 \
 (  \
 N_SEL4\<0\>_XI2\<1\>\/XI2\<0\>\/XI2\<1\>\/XI2\<0\>\/XI2\<0\>\/XI2\<0\>\/XI2\<0\>\/XI2\<1\>\/RR4_pos \
 N_WLSEL\<1292\>_XI2\<1\>\/XI2\<0\>\/XI2\<1\>\/XI2\<0\>\/XI2\<0\>\/XI2\<0\>\/XI2\<0\>\/XI2\<1\>\/RR4_neg \
 ) R_1X_LL w=1e-07 l=1e-07   res=0.149966
XXI2\<1\>\/XI2\<0\>\/XI2\<1\>\/XI2\<0\>\/XI2\<0\>\/XI2\<0\>\/XI2\<0\>\/XI2\<1\>\/RR7 \
 (  \
 N_SEL5\<1\>_XI2\<1\>\/XI2\<0\>\/XI2\<1\>\/XI2\<0\>\/XI2\<0\>\/XI2\<0\>\/XI2\<0\>\/XI2\<1\>\/RR7_pos \
 N_WLSEL\<1293\>_XI2\<1\>\/XI2\<0\>\/XI2\<1\>\/XI2\<0\>\/XI2\<0\>\/XI2\<0\>\/XI2\<0\>\/XI2\<1\>\/RR7_neg \
 ) R_1X_LL w=1e-07 l=1e-07   res=0.149966
XXI2\<0\>\/XI2\<1\>\/XI2\<0\>\/XI2\<1\>\/XI2\<0\>\/XI2\<1\>\/XI2\<1\>\/XI2\<1\>\/RR6 \
 (  \
 N_SEL6\<1\>_XI2\<0\>\/XI2\<1\>\/XI2\<0\>\/XI2\<1\>\/XI2\<0\>\/XI2\<1\>\/XI2\<1\>\/XI2\<1\>\/RR6_pos \
 N_WLSEL\<702\>_XI2\<0\>\/XI2\<1\>\/XI2\<0\>\/XI2\<1\>\/XI2\<0\>\/XI2\<1\>\/XI2\<1\>\/XI2\<1\>\/RR6_neg \
 ) R_1X_LL w=1e-07 l=1e-07   res=0.149966
XXI2\<0\>\/XI2\<1\>\/XI2\<0\>\/XI2\<1\>\/XI2\<0\>\/XI2\<1\>\/XI2\<1\>\/XI2\<1\>\/RR5 \
 (  \
 N_SEL7\<0\>_XI2\<0\>\/XI2\<1\>\/XI2\<0\>\/XI2\<1\>\/XI2\<0\>\/XI2\<1\>\/XI2\<1\>\/XI2\<1\>\/RR5_pos \
 N_WLSEL\<703\>_XI2\<0\>\/XI2\<1\>\/XI2\<0\>\/XI2\<1\>\/XI2\<0\>\/XI2\<1\>\/XI2\<1\>\/XI2\<1\>\/RR5_neg \
 ) R_1X_LL w=1e-07 l=1e-07   res=0.149966
XXI2\<0\>\/XI2\<1\>\/XI2\<0\>\/XI2\<1\>\/XI2\<1\>\/XI2\<0\>\/XI2\<0\>\/XI2\<0\>\/RR0 \
 (  \
 N_SEL0\<0\>_XI2\<0\>\/XI2\<1\>\/XI2\<0\>\/XI2\<1\>\/XI2\<1\>\/XI2\<0\>\/XI2\<0\>\/XI2\<0\>\/RR0_pos \
 N_WLSEL\<704\>_XI2\<0\>\/XI2\<1\>\/XI2\<0\>\/XI2\<1\>\/XI2\<1\>\/XI2\<0\>\/XI2\<0\>\/XI2\<0\>\/RR0_neg \
 ) R_1X_LL w=1e-07 l=1e-07   res=0.149966
XXI2\<0\>\/XI2\<1\>\/XI2\<0\>\/XI2\<1\>\/XI2\<1\>\/XI2\<0\>\/XI2\<0\>\/XI2\<0\>\/RR1 \
 (  \
 N_SEL1\<0\>_XI2\<0\>\/XI2\<1\>\/XI2\<0\>\/XI2\<1\>\/XI2\<1\>\/XI2\<0\>\/XI2\<0\>\/XI2\<0\>\/RR1_pos \
 N_WLSEL\<705\>_XI2\<0\>\/XI2\<1\>\/XI2\<0\>\/XI2\<1\>\/XI2\<1\>\/XI2\<0\>\/XI2\<0\>\/XI2\<0\>\/RR1_neg \
 ) R_1X_LL w=1e-07 l=1e-07   res=0.149966
XXI2\<0\>\/XI2\<1\>\/XI2\<0\>\/XI2\<1\>\/XI2\<1\>\/XI2\<0\>\/XI2\<0\>\/XI2\<0\>\/RR2 \
 (  \
 N_SEL2\<0\>_XI2\<0\>\/XI2\<1\>\/XI2\<0\>\/XI2\<1\>\/XI2\<1\>\/XI2\<0\>\/XI2\<0\>\/XI2\<0\>\/RR2_pos \
 N_WLSEL\<706\>_XI2\<0\>\/XI2\<1\>\/XI2\<0\>\/XI2\<1\>\/XI2\<1\>\/XI2\<0\>\/XI2\<0\>\/XI2\<0\>\/RR2_neg \
 ) R_1X_LL w=1e-07 l=1e-07   res=0.149966
XXI2\<0\>\/XI2\<1\>\/XI2\<0\>\/XI2\<1\>\/XI2\<1\>\/XI2\<0\>\/XI2\<0\>\/XI2\<0\>\/RR3 \
 (  \
 N_SEL3\<1\>_XI2\<0\>\/XI2\<1\>\/XI2\<0\>\/XI2\<1\>\/XI2\<1\>\/XI2\<0\>\/XI2\<0\>\/XI2\<0\>\/RR3_pos \
 N_WLSEL\<707\>_XI2\<0\>\/XI2\<1\>\/XI2\<0\>\/XI2\<1\>\/XI2\<1\>\/XI2\<0\>\/XI2\<0\>\/XI2\<0\>\/RR3_neg \
 ) R_1X_LL w=1e-07 l=1e-07   res=0.149966
XXI2\<0\>\/XI2\<1\>\/XI2\<0\>\/XI2\<1\>\/XI2\<1\>\/XI2\<0\>\/XI2\<0\>\/XI2\<0\>\/RR4 \
 (  \
 N_SEL4\<1\>_XI2\<0\>\/XI2\<1\>\/XI2\<0\>\/XI2\<1\>\/XI2\<1\>\/XI2\<0\>\/XI2\<0\>\/XI2\<0\>\/RR4_pos \
 N_WLSEL\<708\>_XI2\<0\>\/XI2\<1\>\/XI2\<0\>\/XI2\<1\>\/XI2\<1\>\/XI2\<0\>\/XI2\<0\>\/XI2\<0\>\/RR4_neg \
 ) R_1X_LL w=1e-07 l=1e-07   res=0.149966
XXI2\<0\>\/XI2\<1\>\/XI2\<0\>\/XI2\<1\>\/XI2\<1\>\/XI2\<0\>\/XI2\<0\>\/XI2\<0\>\/RR7 \
 (  \
 N_SEL5\<0\>_XI2\<0\>\/XI2\<1\>\/XI2\<0\>\/XI2\<1\>\/XI2\<1\>\/XI2\<0\>\/XI2\<0\>\/XI2\<0\>\/RR7_pos \
 N_WLSEL\<709\>_XI2\<0\>\/XI2\<1\>\/XI2\<0\>\/XI2\<1\>\/XI2\<1\>\/XI2\<0\>\/XI2\<0\>\/XI2\<0\>\/RR7_neg \
 ) R_1X_LL w=1e-07 l=1e-07   res=0.149966
XXI2\<0\>\/XI2\<1\>\/XI2\<0\>\/XI2\<1\>\/XI2\<1\>\/XI2\<0\>\/XI2\<0\>\/XI2\<0\>\/RR6 \
 (  \
 N_SEL6\<1\>_XI2\<0\>\/XI2\<1\>\/XI2\<0\>\/XI2\<1\>\/XI2\<1\>\/XI2\<0\>\/XI2\<0\>\/XI2\<0\>\/RR6_pos \
 N_WLSEL\<710\>_XI2\<0\>\/XI2\<1\>\/XI2\<0\>\/XI2\<1\>\/XI2\<1\>\/XI2\<0\>\/XI2\<0\>\/XI2\<0\>\/RR6_neg \
 ) R_1X_LL w=1e-07 l=1e-07   res=0.149966
XXI2\<0\>\/XI2\<1\>\/XI2\<0\>\/XI2\<1\>\/XI2\<1\>\/XI2\<0\>\/XI2\<0\>\/XI2\<0\>\/RR5 \
 (  \
 N_SEL7\<0\>_XI2\<0\>\/XI2\<1\>\/XI2\<0\>\/XI2\<1\>\/XI2\<1\>\/XI2\<0\>\/XI2\<0\>\/XI2\<0\>\/RR5_pos \
 N_WLSEL\<711\>_XI2\<0\>\/XI2\<1\>\/XI2\<0\>\/XI2\<1\>\/XI2\<1\>\/XI2\<0\>\/XI2\<0\>\/XI2\<0\>\/RR5_neg \
 ) R_1X_LL w=1e-07 l=1e-07   res=0.149966
XXI2\<0\>\/XI2\<1\>\/XI2\<0\>\/XI2\<1\>\/XI2\<1\>\/XI2\<0\>\/XI2\<0\>\/XI2\<1\>\/RR0 \
 (  \
 N_SEL0\<1\>_XI2\<0\>\/XI2\<1\>\/XI2\<0\>\/XI2\<1\>\/XI2\<1\>\/XI2\<0\>\/XI2\<0\>\/XI2\<1\>\/RR0_pos \
 N_WLSEL\<712\>_XI2\<0\>\/XI2\<1\>\/XI2\<0\>\/XI2\<1\>\/XI2\<1\>\/XI2\<0\>\/XI2\<0\>\/XI2\<1\>\/RR0_neg \
 ) R_1X_LL w=1e-07 l=1e-07   res=0.149966
XXI2\<0\>\/XI2\<1\>\/XI2\<0\>\/XI2\<1\>\/XI2\<1\>\/XI2\<0\>\/XI2\<0\>\/XI2\<1\>\/RR1 \
 (  \
 N_SEL1\<0\>_XI2\<0\>\/XI2\<1\>\/XI2\<0\>\/XI2\<1\>\/XI2\<1\>\/XI2\<0\>\/XI2\<0\>\/XI2\<1\>\/RR1_pos \
 N_WLSEL\<713\>_XI2\<0\>\/XI2\<1\>\/XI2\<0\>\/XI2\<1\>\/XI2\<1\>\/XI2\<0\>\/XI2\<0\>\/XI2\<1\>\/RR1_neg \
 ) R_1X_LL w=1e-07 l=1e-07   res=0.149966
XXI2\<0\>\/XI2\<1\>\/XI2\<0\>\/XI2\<1\>\/XI2\<1\>\/XI2\<0\>\/XI2\<0\>\/XI2\<1\>\/RR2 \
 (  \
 N_SEL2\<0\>_XI2\<0\>\/XI2\<1\>\/XI2\<0\>\/XI2\<1\>\/XI2\<1\>\/XI2\<0\>\/XI2\<0\>\/XI2\<1\>\/RR2_pos \
 N_WLSEL\<714\>_XI2\<0\>\/XI2\<1\>\/XI2\<0\>\/XI2\<1\>\/XI2\<1\>\/XI2\<0\>\/XI2\<0\>\/XI2\<1\>\/RR2_neg \
 ) R_1X_LL w=1e-07 l=1e-07   res=0.149966
XXI2\<0\>\/XI2\<1\>\/XI2\<0\>\/XI2\<1\>\/XI2\<1\>\/XI2\<0\>\/XI2\<0\>\/XI2\<1\>\/RR3 \
 (  \
 N_SEL3\<1\>_XI2\<0\>\/XI2\<1\>\/XI2\<0\>\/XI2\<1\>\/XI2\<1\>\/XI2\<0\>\/XI2\<0\>\/XI2\<1\>\/RR3_pos \
 N_WLSEL\<715\>_XI2\<0\>\/XI2\<1\>\/XI2\<0\>\/XI2\<1\>\/XI2\<1\>\/XI2\<0\>\/XI2\<0\>\/XI2\<1\>\/RR3_neg \
 ) R_1X_LL w=1e-07 l=1e-07   res=0.149966
XXI2\<0\>\/XI2\<1\>\/XI2\<0\>\/XI2\<1\>\/XI2\<1\>\/XI2\<0\>\/XI2\<0\>\/XI2\<1\>\/RR4 \
 (  \
 N_SEL4\<1\>_XI2\<0\>\/XI2\<1\>\/XI2\<0\>\/XI2\<1\>\/XI2\<1\>\/XI2\<0\>\/XI2\<0\>\/XI2\<1\>\/RR4_pos \
 N_WLSEL\<716\>_XI2\<0\>\/XI2\<1\>\/XI2\<0\>\/XI2\<1\>\/XI2\<1\>\/XI2\<0\>\/XI2\<0\>\/XI2\<1\>\/RR4_neg \
 ) R_1X_LL w=1e-07 l=1e-07   res=0.149966
XXI2\<0\>\/XI2\<1\>\/XI2\<0\>\/XI2\<1\>\/XI2\<1\>\/XI2\<0\>\/XI2\<0\>\/XI2\<1\>\/RR7 \
 (  \
 N_SEL5\<0\>_XI2\<0\>\/XI2\<1\>\/XI2\<0\>\/XI2\<1\>\/XI2\<1\>\/XI2\<0\>\/XI2\<0\>\/XI2\<1\>\/RR7_pos \
 N_WLSEL\<717\>_XI2\<0\>\/XI2\<1\>\/XI2\<0\>\/XI2\<1\>\/XI2\<1\>\/XI2\<0\>\/XI2\<0\>\/XI2\<1\>\/RR7_neg \
 ) R_1X_LL w=1e-07 l=1e-07   res=0.149966
XXI2\<0\>\/XI2\<1\>\/XI2\<0\>\/XI2\<1\>\/XI2\<1\>\/XI2\<0\>\/XI2\<0\>\/XI2\<1\>\/RR6 \
 (  \
 N_SEL6\<1\>_XI2\<0\>\/XI2\<1\>\/XI2\<0\>\/XI2\<1\>\/XI2\<1\>\/XI2\<0\>\/XI2\<0\>\/XI2\<1\>\/RR6_pos \
 N_WLSEL\<718\>_XI2\<0\>\/XI2\<1\>\/XI2\<0\>\/XI2\<1\>\/XI2\<1\>\/XI2\<0\>\/XI2\<0\>\/XI2\<1\>\/RR6_neg \
 ) R_1X_LL w=1e-07 l=1e-07   res=0.149966
XXI2\<0\>\/XI2\<1\>\/XI2\<0\>\/XI2\<1\>\/XI2\<1\>\/XI2\<0\>\/XI2\<0\>\/XI2\<1\>\/RR5 \
 (  \
 N_SEL7\<0\>_XI2\<0\>\/XI2\<1\>\/XI2\<0\>\/XI2\<1\>\/XI2\<1\>\/XI2\<0\>\/XI2\<0\>\/XI2\<1\>\/RR5_pos \
 N_WLSEL\<719\>_XI2\<0\>\/XI2\<1\>\/XI2\<0\>\/XI2\<1\>\/XI2\<1\>\/XI2\<0\>\/XI2\<0\>\/XI2\<1\>\/RR5_neg \
 ) R_1X_LL w=1e-07 l=1e-07   res=0.149966
XXI2\<0\>\/XI2\<1\>\/XI2\<0\>\/XI2\<1\>\/XI2\<1\>\/XI2\<0\>\/XI2\<1\>\/XI2\<0\>\/RR0 \
 (  \
 N_SEL0\<0\>_XI2\<0\>\/XI2\<1\>\/XI2\<0\>\/XI2\<1\>\/XI2\<1\>\/XI2\<0\>\/XI2\<1\>\/XI2\<0\>\/RR0_pos \
 N_WLSEL\<720\>_XI2\<0\>\/XI2\<1\>\/XI2\<0\>\/XI2\<1\>\/XI2\<1\>\/XI2\<0\>\/XI2\<1\>\/XI2\<0\>\/RR0_neg \
 ) R_1X_LL w=1e-07 l=1e-07   res=0.149966
XXI2\<0\>\/XI2\<1\>\/XI2\<0\>\/XI2\<1\>\/XI2\<1\>\/XI2\<0\>\/XI2\<1\>\/XI2\<0\>\/RR1 \
 (  \
 N_SEL1\<1\>_XI2\<0\>\/XI2\<1\>\/XI2\<0\>\/XI2\<1\>\/XI2\<1\>\/XI2\<0\>\/XI2\<1\>\/XI2\<0\>\/RR1_pos \
 N_WLSEL\<721\>_XI2\<0\>\/XI2\<1\>\/XI2\<0\>\/XI2\<1\>\/XI2\<1\>\/XI2\<0\>\/XI2\<1\>\/XI2\<0\>\/RR1_neg \
 ) R_1X_LL w=1e-07 l=1e-07   res=0.149966
XXI2\<0\>\/XI2\<1\>\/XI2\<0\>\/XI2\<1\>\/XI2\<1\>\/XI2\<0\>\/XI2\<1\>\/XI2\<0\>\/RR2 \
 (  \
 N_SEL2\<0\>_XI2\<0\>\/XI2\<1\>\/XI2\<0\>\/XI2\<1\>\/XI2\<1\>\/XI2\<0\>\/XI2\<1\>\/XI2\<0\>\/RR2_pos \
 N_WLSEL\<722\>_XI2\<0\>\/XI2\<1\>\/XI2\<0\>\/XI2\<1\>\/XI2\<1\>\/XI2\<0\>\/XI2\<1\>\/XI2\<0\>\/RR2_neg \
 ) R_1X_LL w=1e-07 l=1e-07   res=0.149966
XXI2\<0\>\/XI2\<1\>\/XI2\<0\>\/XI2\<1\>\/XI2\<1\>\/XI2\<0\>\/XI2\<1\>\/XI2\<0\>\/RR3 \
 (  \
 N_SEL3\<1\>_XI2\<0\>\/XI2\<1\>\/XI2\<0\>\/XI2\<1\>\/XI2\<1\>\/XI2\<0\>\/XI2\<1\>\/XI2\<0\>\/RR3_pos \
 N_WLSEL\<723\>_XI2\<0\>\/XI2\<1\>\/XI2\<0\>\/XI2\<1\>\/XI2\<1\>\/XI2\<0\>\/XI2\<1\>\/XI2\<0\>\/RR3_neg \
 ) R_1X_LL w=1e-07 l=1e-07   res=0.149966
XXI2\<0\>\/XI2\<1\>\/XI2\<0\>\/XI2\<1\>\/XI2\<1\>\/XI2\<0\>\/XI2\<1\>\/XI2\<0\>\/RR4 \
 (  \
 N_SEL4\<1\>_XI2\<0\>\/XI2\<1\>\/XI2\<0\>\/XI2\<1\>\/XI2\<1\>\/XI2\<0\>\/XI2\<1\>\/XI2\<0\>\/RR4_pos \
 N_WLSEL\<724\>_XI2\<0\>\/XI2\<1\>\/XI2\<0\>\/XI2\<1\>\/XI2\<1\>\/XI2\<0\>\/XI2\<1\>\/XI2\<0\>\/RR4_neg \
 ) R_1X_LL w=1e-07 l=1e-07   res=0.149966
XXI2\<0\>\/XI2\<1\>\/XI2\<0\>\/XI2\<1\>\/XI2\<1\>\/XI2\<0\>\/XI2\<1\>\/XI2\<0\>\/RR7 \
 (  \
 N_SEL5\<0\>_XI2\<0\>\/XI2\<1\>\/XI2\<0\>\/XI2\<1\>\/XI2\<1\>\/XI2\<0\>\/XI2\<1\>\/XI2\<0\>\/RR7_pos \
 N_WLSEL\<725\>_XI2\<0\>\/XI2\<1\>\/XI2\<0\>\/XI2\<1\>\/XI2\<1\>\/XI2\<0\>\/XI2\<1\>\/XI2\<0\>\/RR7_neg \
 ) R_1X_LL w=1e-07 l=1e-07   res=0.149966
XXI2\<0\>\/XI2\<1\>\/XI2\<0\>\/XI2\<1\>\/XI2\<1\>\/XI2\<0\>\/XI2\<1\>\/XI2\<0\>\/RR6 \
 (  \
 N_SEL6\<1\>_XI2\<0\>\/XI2\<1\>\/XI2\<0\>\/XI2\<1\>\/XI2\<1\>\/XI2\<0\>\/XI2\<1\>\/XI2\<0\>\/RR6_pos \
 N_WLSEL\<726\>_XI2\<0\>\/XI2\<1\>\/XI2\<0\>\/XI2\<1\>\/XI2\<1\>\/XI2\<0\>\/XI2\<1\>\/XI2\<0\>\/RR6_neg \
 ) R_1X_LL w=1e-07 l=1e-07   res=0.149966
XXI2\<0\>\/XI2\<1\>\/XI2\<0\>\/XI2\<1\>\/XI2\<1\>\/XI2\<0\>\/XI2\<1\>\/XI2\<0\>\/RR5 \
 (  \
 N_SEL7\<0\>_XI2\<0\>\/XI2\<1\>\/XI2\<0\>\/XI2\<1\>\/XI2\<1\>\/XI2\<0\>\/XI2\<1\>\/XI2\<0\>\/RR5_pos \
 N_WLSEL\<727\>_XI2\<0\>\/XI2\<1\>\/XI2\<0\>\/XI2\<1\>\/XI2\<1\>\/XI2\<0\>\/XI2\<1\>\/XI2\<0\>\/RR5_neg \
 ) R_1X_LL w=1e-07 l=1e-07   res=0.149966
XXI2\<0\>\/XI2\<1\>\/XI2\<0\>\/XI2\<1\>\/XI2\<1\>\/XI2\<0\>\/XI2\<1\>\/XI2\<1\>\/RR0 \
 (  \
 N_SEL0\<1\>_XI2\<0\>\/XI2\<1\>\/XI2\<0\>\/XI2\<1\>\/XI2\<1\>\/XI2\<0\>\/XI2\<1\>\/XI2\<1\>\/RR0_pos \
 N_WLSEL\<728\>_XI2\<0\>\/XI2\<1\>\/XI2\<0\>\/XI2\<1\>\/XI2\<1\>\/XI2\<0\>\/XI2\<1\>\/XI2\<1\>\/RR0_neg \
 ) R_1X_LL w=1e-07 l=1e-07   res=0.149966
XXI2\<0\>\/XI2\<1\>\/XI2\<0\>\/XI2\<1\>\/XI2\<1\>\/XI2\<0\>\/XI2\<1\>\/XI2\<1\>\/RR1 \
 (  \
 N_SEL1\<1\>_XI2\<0\>\/XI2\<1\>\/XI2\<0\>\/XI2\<1\>\/XI2\<1\>\/XI2\<0\>\/XI2\<1\>\/XI2\<1\>\/RR1_pos \
 N_WLSEL\<729\>_XI2\<0\>\/XI2\<1\>\/XI2\<0\>\/XI2\<1\>\/XI2\<1\>\/XI2\<0\>\/XI2\<1\>\/XI2\<1\>\/RR1_neg \
 ) R_1X_LL w=1e-07 l=1e-07   res=0.149966
XXI2\<0\>\/XI2\<1\>\/XI2\<0\>\/XI2\<1\>\/XI2\<1\>\/XI2\<0\>\/XI2\<1\>\/XI2\<1\>\/RR2 \
 (  \
 N_SEL2\<0\>_XI2\<0\>\/XI2\<1\>\/XI2\<0\>\/XI2\<1\>\/XI2\<1\>\/XI2\<0\>\/XI2\<1\>\/XI2\<1\>\/RR2_pos \
 N_WLSEL\<730\>_XI2\<0\>\/XI2\<1\>\/XI2\<0\>\/XI2\<1\>\/XI2\<1\>\/XI2\<0\>\/XI2\<1\>\/XI2\<1\>\/RR2_neg \
 ) R_1X_LL w=1e-07 l=1e-07   res=0.149966
XXI2\<0\>\/XI2\<1\>\/XI2\<0\>\/XI2\<1\>\/XI2\<1\>\/XI2\<0\>\/XI2\<1\>\/XI2\<1\>\/RR3 \
 (  \
 N_SEL3\<1\>_XI2\<0\>\/XI2\<1\>\/XI2\<0\>\/XI2\<1\>\/XI2\<1\>\/XI2\<0\>\/XI2\<1\>\/XI2\<1\>\/RR3_pos \
 N_WLSEL\<731\>_XI2\<0\>\/XI2\<1\>\/XI2\<0\>\/XI2\<1\>\/XI2\<1\>\/XI2\<0\>\/XI2\<1\>\/XI2\<1\>\/RR3_neg \
 ) R_1X_LL w=1e-07 l=1e-07   res=0.149966
XXI2\<0\>\/XI2\<1\>\/XI2\<0\>\/XI2\<1\>\/XI2\<1\>\/XI2\<0\>\/XI2\<1\>\/XI2\<1\>\/RR4 \
 (  \
 N_SEL4\<1\>_XI2\<0\>\/XI2\<1\>\/XI2\<0\>\/XI2\<1\>\/XI2\<1\>\/XI2\<0\>\/XI2\<1\>\/XI2\<1\>\/RR4_pos \
 N_WLSEL\<732\>_XI2\<0\>\/XI2\<1\>\/XI2\<0\>\/XI2\<1\>\/XI2\<1\>\/XI2\<0\>\/XI2\<1\>\/XI2\<1\>\/RR4_neg \
 ) R_1X_LL w=1e-07 l=1e-07   res=0.149966
XXI2\<0\>\/XI2\<1\>\/XI2\<0\>\/XI2\<1\>\/XI2\<1\>\/XI2\<0\>\/XI2\<1\>\/XI2\<1\>\/RR7 \
 (  \
 N_SEL5\<0\>_XI2\<0\>\/XI2\<1\>\/XI2\<0\>\/XI2\<1\>\/XI2\<1\>\/XI2\<0\>\/XI2\<1\>\/XI2\<1\>\/RR7_pos \
 N_WLSEL\<733\>_XI2\<0\>\/XI2\<1\>\/XI2\<0\>\/XI2\<1\>\/XI2\<1\>\/XI2\<0\>\/XI2\<1\>\/XI2\<1\>\/RR7_neg \
 ) R_1X_LL w=1e-07 l=1e-07   res=0.149966
XXI2\<0\>\/XI2\<1\>\/XI2\<0\>\/XI2\<1\>\/XI2\<1\>\/XI2\<0\>\/XI2\<1\>\/XI2\<1\>\/RR6 \
 (  \
 N_SEL6\<1\>_XI2\<0\>\/XI2\<1\>\/XI2\<0\>\/XI2\<1\>\/XI2\<1\>\/XI2\<0\>\/XI2\<1\>\/XI2\<1\>\/RR6_pos \
 N_WLSEL\<734\>_XI2\<0\>\/XI2\<1\>\/XI2\<0\>\/XI2\<1\>\/XI2\<1\>\/XI2\<0\>\/XI2\<1\>\/XI2\<1\>\/RR6_neg \
 ) R_1X_LL w=1e-07 l=1e-07   res=0.149966
XXI2\<0\>\/XI2\<1\>\/XI2\<0\>\/XI2\<1\>\/XI2\<1\>\/XI2\<0\>\/XI2\<1\>\/XI2\<1\>\/RR5 \
 (  \
 N_SEL7\<0\>_XI2\<0\>\/XI2\<1\>\/XI2\<0\>\/XI2\<1\>\/XI2\<1\>\/XI2\<0\>\/XI2\<1\>\/XI2\<1\>\/RR5_pos \
 N_WLSEL\<735\>_XI2\<0\>\/XI2\<1\>\/XI2\<0\>\/XI2\<1\>\/XI2\<1\>\/XI2\<0\>\/XI2\<1\>\/XI2\<1\>\/RR5_neg \
 ) R_1X_LL w=1e-07 l=1e-07   res=0.149966
XXI2\<0\>\/XI2\<1\>\/XI2\<0\>\/XI2\<1\>\/XI2\<1\>\/XI2\<1\>\/XI2\<0\>\/XI2\<0\>\/RR0 \
 (  \
 N_SEL0\<0\>_XI2\<0\>\/XI2\<1\>\/XI2\<0\>\/XI2\<1\>\/XI2\<1\>\/XI2\<1\>\/XI2\<0\>\/XI2\<0\>\/RR0_pos \
 N_WLSEL\<736\>_XI2\<0\>\/XI2\<1\>\/XI2\<0\>\/XI2\<1\>\/XI2\<1\>\/XI2\<1\>\/XI2\<0\>\/XI2\<0\>\/RR0_neg \
 ) R_1X_LL w=1e-07 l=1e-07   res=0.149966
XXI2\<0\>\/XI2\<1\>\/XI2\<0\>\/XI2\<1\>\/XI2\<1\>\/XI2\<1\>\/XI2\<0\>\/XI2\<0\>\/RR1 \
 (  \
 N_SEL1\<0\>_XI2\<0\>\/XI2\<1\>\/XI2\<0\>\/XI2\<1\>\/XI2\<1\>\/XI2\<1\>\/XI2\<0\>\/XI2\<0\>\/RR1_pos \
 N_WLSEL\<737\>_XI2\<0\>\/XI2\<1\>\/XI2\<0\>\/XI2\<1\>\/XI2\<1\>\/XI2\<1\>\/XI2\<0\>\/XI2\<0\>\/RR1_neg \
 ) R_1X_LL w=1e-07 l=1e-07   res=0.149966
XXI2\<0\>\/XI2\<1\>\/XI2\<0\>\/XI2\<1\>\/XI2\<1\>\/XI2\<1\>\/XI2\<0\>\/XI2\<0\>\/RR2 \
 (  \
 N_SEL2\<1\>_XI2\<0\>\/XI2\<1\>\/XI2\<0\>\/XI2\<1\>\/XI2\<1\>\/XI2\<1\>\/XI2\<0\>\/XI2\<0\>\/RR2_pos \
 N_WLSEL\<738\>_XI2\<0\>\/XI2\<1\>\/XI2\<0\>\/XI2\<1\>\/XI2\<1\>\/XI2\<1\>\/XI2\<0\>\/XI2\<0\>\/RR2_neg \
 ) R_1X_LL w=1e-07 l=1e-07   res=0.149966
XXI2\<0\>\/XI2\<1\>\/XI2\<0\>\/XI2\<1\>\/XI2\<1\>\/XI2\<1\>\/XI2\<0\>\/XI2\<0\>\/RR3 \
 (  \
 N_SEL3\<1\>_XI2\<0\>\/XI2\<1\>\/XI2\<0\>\/XI2\<1\>\/XI2\<1\>\/XI2\<1\>\/XI2\<0\>\/XI2\<0\>\/RR3_pos \
 N_WLSEL\<739\>_XI2\<0\>\/XI2\<1\>\/XI2\<0\>\/XI2\<1\>\/XI2\<1\>\/XI2\<1\>\/XI2\<0\>\/XI2\<0\>\/RR3_neg \
 ) R_1X_LL w=1e-07 l=1e-07   res=0.149966
XXI2\<0\>\/XI2\<1\>\/XI2\<0\>\/XI2\<1\>\/XI2\<1\>\/XI2\<1\>\/XI2\<0\>\/XI2\<0\>\/RR4 \
 (  \
 N_SEL4\<1\>_XI2\<0\>\/XI2\<1\>\/XI2\<0\>\/XI2\<1\>\/XI2\<1\>\/XI2\<1\>\/XI2\<0\>\/XI2\<0\>\/RR4_pos \
 N_WLSEL\<740\>_XI2\<0\>\/XI2\<1\>\/XI2\<0\>\/XI2\<1\>\/XI2\<1\>\/XI2\<1\>\/XI2\<0\>\/XI2\<0\>\/RR4_neg \
 ) R_1X_LL w=1e-07 l=1e-07   res=0.149966
XXI2\<0\>\/XI2\<1\>\/XI2\<0\>\/XI2\<1\>\/XI2\<1\>\/XI2\<1\>\/XI2\<0\>\/XI2\<0\>\/RR7 \
 (  \
 N_SEL5\<0\>_XI2\<0\>\/XI2\<1\>\/XI2\<0\>\/XI2\<1\>\/XI2\<1\>\/XI2\<1\>\/XI2\<0\>\/XI2\<0\>\/RR7_pos \
 N_WLSEL\<741\>_XI2\<0\>\/XI2\<1\>\/XI2\<0\>\/XI2\<1\>\/XI2\<1\>\/XI2\<1\>\/XI2\<0\>\/XI2\<0\>\/RR7_neg \
 ) R_1X_LL w=1e-07 l=1e-07   res=0.149966
XXI2\<0\>\/XI2\<1\>\/XI2\<0\>\/XI2\<1\>\/XI2\<1\>\/XI2\<1\>\/XI2\<0\>\/XI2\<0\>\/RR6 \
 (  \
 N_SEL6\<1\>_XI2\<0\>\/XI2\<1\>\/XI2\<0\>\/XI2\<1\>\/XI2\<1\>\/XI2\<1\>\/XI2\<0\>\/XI2\<0\>\/RR6_pos \
 N_WLSEL\<742\>_XI2\<0\>\/XI2\<1\>\/XI2\<0\>\/XI2\<1\>\/XI2\<1\>\/XI2\<1\>\/XI2\<0\>\/XI2\<0\>\/RR6_neg \
 ) R_1X_LL w=1e-07 l=1e-07   res=0.149966
XXI2\<0\>\/XI2\<1\>\/XI2\<0\>\/XI2\<1\>\/XI2\<1\>\/XI2\<1\>\/XI2\<0\>\/XI2\<0\>\/RR5 \
 (  \
 N_SEL7\<0\>_XI2\<0\>\/XI2\<1\>\/XI2\<0\>\/XI2\<1\>\/XI2\<1\>\/XI2\<1\>\/XI2\<0\>\/XI2\<0\>\/RR5_pos \
 N_WLSEL\<743\>_XI2\<0\>\/XI2\<1\>\/XI2\<0\>\/XI2\<1\>\/XI2\<1\>\/XI2\<1\>\/XI2\<0\>\/XI2\<0\>\/RR5_neg \
 ) R_1X_LL w=1e-07 l=1e-07   res=0.149966
XXI2\<0\>\/XI2\<1\>\/XI2\<0\>\/XI2\<1\>\/XI2\<1\>\/XI2\<1\>\/XI2\<0\>\/XI2\<1\>\/RR0 \
 (  \
 N_SEL0\<1\>_XI2\<0\>\/XI2\<1\>\/XI2\<0\>\/XI2\<1\>\/XI2\<1\>\/XI2\<1\>\/XI2\<0\>\/XI2\<1\>\/RR0_pos \
 N_WLSEL\<744\>_XI2\<0\>\/XI2\<1\>\/XI2\<0\>\/XI2\<1\>\/XI2\<1\>\/XI2\<1\>\/XI2\<0\>\/XI2\<1\>\/RR0_neg \
 ) R_1X_LL w=1e-07 l=1e-07   res=0.149966
XXI2\<0\>\/XI2\<1\>\/XI2\<0\>\/XI2\<1\>\/XI2\<1\>\/XI2\<1\>\/XI2\<0\>\/XI2\<1\>\/RR1 \
 (  \
 N_SEL1\<0\>_XI2\<0\>\/XI2\<1\>\/XI2\<0\>\/XI2\<1\>\/XI2\<1\>\/XI2\<1\>\/XI2\<0\>\/XI2\<1\>\/RR1_pos \
 N_WLSEL\<745\>_XI2\<0\>\/XI2\<1\>\/XI2\<0\>\/XI2\<1\>\/XI2\<1\>\/XI2\<1\>\/XI2\<0\>\/XI2\<1\>\/RR1_neg \
 ) R_1X_LL w=1e-07 l=1e-07   res=0.149966
XXI2\<0\>\/XI2\<1\>\/XI2\<0\>\/XI2\<1\>\/XI2\<1\>\/XI2\<1\>\/XI2\<0\>\/XI2\<1\>\/RR2 \
 (  \
 N_SEL2\<1\>_XI2\<0\>\/XI2\<1\>\/XI2\<0\>\/XI2\<1\>\/XI2\<1\>\/XI2\<1\>\/XI2\<0\>\/XI2\<1\>\/RR2_pos \
 N_WLSEL\<746\>_XI2\<0\>\/XI2\<1\>\/XI2\<0\>\/XI2\<1\>\/XI2\<1\>\/XI2\<1\>\/XI2\<0\>\/XI2\<1\>\/RR2_neg \
 ) R_1X_LL w=1e-07 l=1e-07   res=0.149966
XXI2\<0\>\/XI2\<1\>\/XI2\<0\>\/XI2\<1\>\/XI2\<1\>\/XI2\<1\>\/XI2\<0\>\/XI2\<1\>\/RR3 \
 (  \
 N_SEL3\<1\>_XI2\<0\>\/XI2\<1\>\/XI2\<0\>\/XI2\<1\>\/XI2\<1\>\/XI2\<1\>\/XI2\<0\>\/XI2\<1\>\/RR3_pos \
 N_WLSEL\<747\>_XI2\<0\>\/XI2\<1\>\/XI2\<0\>\/XI2\<1\>\/XI2\<1\>\/XI2\<1\>\/XI2\<0\>\/XI2\<1\>\/RR3_neg \
 ) R_1X_LL w=1e-07 l=1e-07   res=0.149966
XXI2\<0\>\/XI2\<1\>\/XI2\<0\>\/XI2\<1\>\/XI2\<1\>\/XI2\<1\>\/XI2\<0\>\/XI2\<1\>\/RR4 \
 (  \
 N_SEL4\<1\>_XI2\<0\>\/XI2\<1\>\/XI2\<0\>\/XI2\<1\>\/XI2\<1\>\/XI2\<1\>\/XI2\<0\>\/XI2\<1\>\/RR4_pos \
 N_WLSEL\<748\>_XI2\<0\>\/XI2\<1\>\/XI2\<0\>\/XI2\<1\>\/XI2\<1\>\/XI2\<1\>\/XI2\<0\>\/XI2\<1\>\/RR4_neg \
 ) R_1X_LL w=1e-07 l=1e-07   res=0.149966
XXI2\<0\>\/XI2\<1\>\/XI2\<0\>\/XI2\<1\>\/XI2\<1\>\/XI2\<1\>\/XI2\<0\>\/XI2\<1\>\/RR7 \
 (  \
 N_SEL5\<0\>_XI2\<0\>\/XI2\<1\>\/XI2\<0\>\/XI2\<1\>\/XI2\<1\>\/XI2\<1\>\/XI2\<0\>\/XI2\<1\>\/RR7_pos \
 N_WLSEL\<749\>_XI2\<0\>\/XI2\<1\>\/XI2\<0\>\/XI2\<1\>\/XI2\<1\>\/XI2\<1\>\/XI2\<0\>\/XI2\<1\>\/RR7_neg \
 ) R_1X_LL w=1e-07 l=1e-07   res=0.149966
XXI2\<0\>\/XI2\<1\>\/XI2\<0\>\/XI2\<1\>\/XI2\<1\>\/XI2\<1\>\/XI2\<0\>\/XI2\<1\>\/RR6 \
 (  \
 N_SEL6\<1\>_XI2\<0\>\/XI2\<1\>\/XI2\<0\>\/XI2\<1\>\/XI2\<1\>\/XI2\<1\>\/XI2\<0\>\/XI2\<1\>\/RR6_pos \
 N_WLSEL\<750\>_XI2\<0\>\/XI2\<1\>\/XI2\<0\>\/XI2\<1\>\/XI2\<1\>\/XI2\<1\>\/XI2\<0\>\/XI2\<1\>\/RR6_neg \
 ) R_1X_LL w=1e-07 l=1e-07   res=0.149966
XXI2\<0\>\/XI2\<1\>\/XI2\<0\>\/XI2\<1\>\/XI2\<1\>\/XI2\<1\>\/XI2\<0\>\/XI2\<1\>\/RR5 \
 (  \
 N_SEL7\<0\>_XI2\<0\>\/XI2\<1\>\/XI2\<0\>\/XI2\<1\>\/XI2\<1\>\/XI2\<1\>\/XI2\<0\>\/XI2\<1\>\/RR5_pos \
 N_WLSEL\<751\>_XI2\<0\>\/XI2\<1\>\/XI2\<0\>\/XI2\<1\>\/XI2\<1\>\/XI2\<1\>\/XI2\<0\>\/XI2\<1\>\/RR5_neg \
 ) R_1X_LL w=1e-07 l=1e-07   res=0.149966
XXI2\<0\>\/XI2\<1\>\/XI2\<0\>\/XI2\<1\>\/XI2\<1\>\/XI2\<1\>\/XI2\<1\>\/XI2\<0\>\/RR0 \
 (  \
 N_SEL0\<0\>_XI2\<0\>\/XI2\<1\>\/XI2\<0\>\/XI2\<1\>\/XI2\<1\>\/XI2\<1\>\/XI2\<1\>\/XI2\<0\>\/RR0_pos \
 N_WLSEL\<752\>_XI2\<0\>\/XI2\<1\>\/XI2\<0\>\/XI2\<1\>\/XI2\<1\>\/XI2\<1\>\/XI2\<1\>\/XI2\<0\>\/RR0_neg \
 ) R_1X_LL w=1e-07 l=1e-07   res=0.149966
XXI2\<0\>\/XI2\<1\>\/XI2\<0\>\/XI2\<1\>\/XI2\<1\>\/XI2\<1\>\/XI2\<1\>\/XI2\<0\>\/RR1 \
 (  \
 N_SEL1\<1\>_XI2\<0\>\/XI2\<1\>\/XI2\<0\>\/XI2\<1\>\/XI2\<1\>\/XI2\<1\>\/XI2\<1\>\/XI2\<0\>\/RR1_pos \
 N_WLSEL\<753\>_XI2\<0\>\/XI2\<1\>\/XI2\<0\>\/XI2\<1\>\/XI2\<1\>\/XI2\<1\>\/XI2\<1\>\/XI2\<0\>\/RR1_neg \
 ) R_1X_LL w=1e-07 l=1e-07   res=0.149966
XXI2\<0\>\/XI2\<1\>\/XI2\<0\>\/XI2\<1\>\/XI2\<1\>\/XI2\<1\>\/XI2\<1\>\/XI2\<0\>\/RR2 \
 (  \
 N_SEL2\<1\>_XI2\<0\>\/XI2\<1\>\/XI2\<0\>\/XI2\<1\>\/XI2\<1\>\/XI2\<1\>\/XI2\<1\>\/XI2\<0\>\/RR2_pos \
 N_WLSEL\<754\>_XI2\<0\>\/XI2\<1\>\/XI2\<0\>\/XI2\<1\>\/XI2\<1\>\/XI2\<1\>\/XI2\<1\>\/XI2\<0\>\/RR2_neg \
 ) R_1X_LL w=1e-07 l=1e-07   res=0.149966
XXI2\<0\>\/XI2\<1\>\/XI2\<0\>\/XI2\<1\>\/XI2\<1\>\/XI2\<1\>\/XI2\<1\>\/XI2\<0\>\/RR3 \
 (  \
 N_SEL3\<1\>_XI2\<0\>\/XI2\<1\>\/XI2\<0\>\/XI2\<1\>\/XI2\<1\>\/XI2\<1\>\/XI2\<1\>\/XI2\<0\>\/RR3_pos \
 N_WLSEL\<755\>_XI2\<0\>\/XI2\<1\>\/XI2\<0\>\/XI2\<1\>\/XI2\<1\>\/XI2\<1\>\/XI2\<1\>\/XI2\<0\>\/RR3_neg \
 ) R_1X_LL w=1e-07 l=1e-07   res=0.149966
XXI2\<0\>\/XI2\<1\>\/XI2\<0\>\/XI2\<1\>\/XI2\<1\>\/XI2\<1\>\/XI2\<1\>\/XI2\<0\>\/RR4 \
 (  \
 N_SEL4\<1\>_XI2\<0\>\/XI2\<1\>\/XI2\<0\>\/XI2\<1\>\/XI2\<1\>\/XI2\<1\>\/XI2\<1\>\/XI2\<0\>\/RR4_pos \
 N_WLSEL\<756\>_XI2\<0\>\/XI2\<1\>\/XI2\<0\>\/XI2\<1\>\/XI2\<1\>\/XI2\<1\>\/XI2\<1\>\/XI2\<0\>\/RR4_neg \
 ) R_1X_LL w=1e-07 l=1e-07   res=0.149966
XXI2\<0\>\/XI2\<1\>\/XI2\<0\>\/XI2\<1\>\/XI2\<1\>\/XI2\<1\>\/XI2\<1\>\/XI2\<0\>\/RR7 \
 (  \
 N_SEL5\<0\>_XI2\<0\>\/XI2\<1\>\/XI2\<0\>\/XI2\<1\>\/XI2\<1\>\/XI2\<1\>\/XI2\<1\>\/XI2\<0\>\/RR7_pos \
 N_WLSEL\<757\>_XI2\<0\>\/XI2\<1\>\/XI2\<0\>\/XI2\<1\>\/XI2\<1\>\/XI2\<1\>\/XI2\<1\>\/XI2\<0\>\/RR7_neg \
 ) R_1X_LL w=1e-07 l=1e-07   res=0.149966
XXI2\<0\>\/XI2\<1\>\/XI2\<0\>\/XI2\<1\>\/XI2\<1\>\/XI2\<1\>\/XI2\<1\>\/XI2\<0\>\/RR6 \
 (  \
 N_SEL6\<1\>_XI2\<0\>\/XI2\<1\>\/XI2\<0\>\/XI2\<1\>\/XI2\<1\>\/XI2\<1\>\/XI2\<1\>\/XI2\<0\>\/RR6_pos \
 N_WLSEL\<758\>_XI2\<0\>\/XI2\<1\>\/XI2\<0\>\/XI2\<1\>\/XI2\<1\>\/XI2\<1\>\/XI2\<1\>\/XI2\<0\>\/RR6_neg \
 ) R_1X_LL w=1e-07 l=1e-07   res=0.149966
XXI2\<0\>\/XI2\<1\>\/XI2\<0\>\/XI2\<1\>\/XI2\<1\>\/XI2\<1\>\/XI2\<1\>\/XI2\<0\>\/RR5 \
 (  \
 N_SEL7\<0\>_XI2\<0\>\/XI2\<1\>\/XI2\<0\>\/XI2\<1\>\/XI2\<1\>\/XI2\<1\>\/XI2\<1\>\/XI2\<0\>\/RR5_pos \
 N_WLSEL\<759\>_XI2\<0\>\/XI2\<1\>\/XI2\<0\>\/XI2\<1\>\/XI2\<1\>\/XI2\<1\>\/XI2\<1\>\/XI2\<0\>\/RR5_neg \
 ) R_1X_LL w=1e-07 l=1e-07   res=0.149966
XXI2\<0\>\/XI2\<1\>\/XI2\<0\>\/XI2\<1\>\/XI2\<1\>\/XI2\<1\>\/XI2\<1\>\/XI2\<1\>\/RR0 \
 (  \
 N_SEL0\<1\>_XI2\<0\>\/XI2\<1\>\/XI2\<0\>\/XI2\<1\>\/XI2\<1\>\/XI2\<1\>\/XI2\<1\>\/XI2\<1\>\/RR0_pos \
 N_WLSEL\<760\>_XI2\<0\>\/XI2\<1\>\/XI2\<0\>\/XI2\<1\>\/XI2\<1\>\/XI2\<1\>\/XI2\<1\>\/XI2\<1\>\/RR0_neg \
 ) R_1X_LL w=1e-07 l=1e-07   res=0.149966
XXI2\<0\>\/XI2\<1\>\/XI2\<0\>\/XI2\<1\>\/XI2\<1\>\/XI2\<1\>\/XI2\<1\>\/XI2\<1\>\/RR1 \
 (  \
 N_SEL1\<1\>_XI2\<0\>\/XI2\<1\>\/XI2\<0\>\/XI2\<1\>\/XI2\<1\>\/XI2\<1\>\/XI2\<1\>\/XI2\<1\>\/RR1_pos \
 N_WLSEL\<761\>_XI2\<0\>\/XI2\<1\>\/XI2\<0\>\/XI2\<1\>\/XI2\<1\>\/XI2\<1\>\/XI2\<1\>\/XI2\<1\>\/RR1_neg \
 ) R_1X_LL w=1e-07 l=1e-07   res=0.149966
XXI2\<0\>\/XI2\<1\>\/XI2\<0\>\/XI2\<1\>\/XI2\<1\>\/XI2\<1\>\/XI2\<1\>\/XI2\<1\>\/RR2 \
 (  \
 N_SEL2\<1\>_XI2\<0\>\/XI2\<1\>\/XI2\<0\>\/XI2\<1\>\/XI2\<1\>\/XI2\<1\>\/XI2\<1\>\/XI2\<1\>\/RR2_pos \
 N_WLSEL\<762\>_XI2\<0\>\/XI2\<1\>\/XI2\<0\>\/XI2\<1\>\/XI2\<1\>\/XI2\<1\>\/XI2\<1\>\/XI2\<1\>\/RR2_neg \
 ) R_1X_LL w=1e-07 l=1e-07   res=0.149966
XXI2\<0\>\/XI2\<1\>\/XI2\<0\>\/XI2\<1\>\/XI2\<1\>\/XI2\<1\>\/XI2\<1\>\/XI2\<1\>\/RR3 \
 (  \
 N_SEL3\<1\>_XI2\<0\>\/XI2\<1\>\/XI2\<0\>\/XI2\<1\>\/XI2\<1\>\/XI2\<1\>\/XI2\<1\>\/XI2\<1\>\/RR3_pos \
 N_WLSEL\<763\>_XI2\<0\>\/XI2\<1\>\/XI2\<0\>\/XI2\<1\>\/XI2\<1\>\/XI2\<1\>\/XI2\<1\>\/XI2\<1\>\/RR3_neg \
 ) R_1X_LL w=1e-07 l=1e-07   res=0.149966
XXI2\<0\>\/XI2\<1\>\/XI2\<0\>\/XI2\<1\>\/XI2\<1\>\/XI2\<1\>\/XI2\<1\>\/XI2\<1\>\/RR4 \
 (  \
 N_SEL4\<1\>_XI2\<0\>\/XI2\<1\>\/XI2\<0\>\/XI2\<1\>\/XI2\<1\>\/XI2\<1\>\/XI2\<1\>\/XI2\<1\>\/RR4_pos \
 N_WLSEL\<764\>_XI2\<0\>\/XI2\<1\>\/XI2\<0\>\/XI2\<1\>\/XI2\<1\>\/XI2\<1\>\/XI2\<1\>\/XI2\<1\>\/RR4_neg \
 ) R_1X_LL w=1e-07 l=1e-07   res=0.149966
XXI2\<0\>\/XI2\<1\>\/XI2\<0\>\/XI2\<1\>\/XI2\<1\>\/XI2\<1\>\/XI2\<1\>\/XI2\<1\>\/RR7 \
 (  \
 N_SEL5\<0\>_XI2\<0\>\/XI2\<1\>\/XI2\<0\>\/XI2\<1\>\/XI2\<1\>\/XI2\<1\>\/XI2\<1\>\/XI2\<1\>\/RR7_pos \
 N_WLSEL\<765\>_XI2\<0\>\/XI2\<1\>\/XI2\<0\>\/XI2\<1\>\/XI2\<1\>\/XI2\<1\>\/XI2\<1\>\/XI2\<1\>\/RR7_neg \
 ) R_1X_LL w=1e-07 l=1e-07   res=0.149966
XXI2\<0\>\/XI2\<1\>\/XI2\<0\>\/XI2\<1\>\/XI2\<1\>\/XI2\<1\>\/XI2\<1\>\/XI2\<1\>\/RR6 \
 (  \
 N_SEL6\<1\>_XI2\<0\>\/XI2\<1\>\/XI2\<0\>\/XI2\<1\>\/XI2\<1\>\/XI2\<1\>\/XI2\<1\>\/XI2\<1\>\/RR6_pos \
 N_WLSEL\<766\>_XI2\<0\>\/XI2\<1\>\/XI2\<0\>\/XI2\<1\>\/XI2\<1\>\/XI2\<1\>\/XI2\<1\>\/XI2\<1\>\/RR6_neg \
 ) R_1X_LL w=1e-07 l=1e-07   res=0.149966
XXI2\<0\>\/XI2\<1\>\/XI2\<0\>\/XI2\<1\>\/XI2\<1\>\/XI2\<1\>\/XI2\<1\>\/XI2\<1\>\/RR5 \
 (  \
 N_SEL7\<0\>_XI2\<0\>\/XI2\<1\>\/XI2\<0\>\/XI2\<1\>\/XI2\<1\>\/XI2\<1\>\/XI2\<1\>\/XI2\<1\>\/RR5_pos \
 N_WLSEL\<767\>_XI2\<0\>\/XI2\<1\>\/XI2\<0\>\/XI2\<1\>\/XI2\<1\>\/XI2\<1\>\/XI2\<1\>\/XI2\<1\>\/RR5_neg \
 ) R_1X_LL w=1e-07 l=1e-07   res=0.149966
XXI2\<0\>\/XI2\<1\>\/XI2\<1\>\/XI2\<0\>\/XI2\<0\>\/XI2\<0\>\/XI2\<0\>\/XI2\<0\>\/RR0 \
 (  \
 N_SEL0\<0\>_XI2\<0\>\/XI2\<1\>\/XI2\<1\>\/XI2\<0\>\/XI2\<0\>\/XI2\<0\>\/XI2\<0\>\/XI2\<0\>\/RR0_pos \
 N_WLSEL\<768\>_XI2\<0\>\/XI2\<1\>\/XI2\<1\>\/XI2\<0\>\/XI2\<0\>\/XI2\<0\>\/XI2\<0\>\/XI2\<0\>\/RR0_neg \
 ) R_1X_LL w=1e-07 l=1e-07   res=0.149966
XXI2\<0\>\/XI2\<1\>\/XI2\<1\>\/XI2\<0\>\/XI2\<0\>\/XI2\<0\>\/XI2\<0\>\/XI2\<0\>\/RR1 \
 (  \
 N_SEL1\<0\>_XI2\<0\>\/XI2\<1\>\/XI2\<1\>\/XI2\<0\>\/XI2\<0\>\/XI2\<0\>\/XI2\<0\>\/XI2\<0\>\/RR1_pos \
 N_WLSEL\<769\>_XI2\<0\>\/XI2\<1\>\/XI2\<1\>\/XI2\<0\>\/XI2\<0\>\/XI2\<0\>\/XI2\<0\>\/XI2\<0\>\/RR1_neg \
 ) R_1X_LL w=1e-07 l=1e-07   res=0.149966
XXI2\<0\>\/XI2\<1\>\/XI2\<1\>\/XI2\<0\>\/XI2\<0\>\/XI2\<0\>\/XI2\<0\>\/XI2\<0\>\/RR2 \
 (  \
 N_SEL2\<0\>_XI2\<0\>\/XI2\<1\>\/XI2\<1\>\/XI2\<0\>\/XI2\<0\>\/XI2\<0\>\/XI2\<0\>\/XI2\<0\>\/RR2_pos \
 N_WLSEL\<770\>_XI2\<0\>\/XI2\<1\>\/XI2\<1\>\/XI2\<0\>\/XI2\<0\>\/XI2\<0\>\/XI2\<0\>\/XI2\<0\>\/RR2_neg \
 ) R_1X_LL w=1e-07 l=1e-07   res=0.149966
XXI2\<0\>\/XI2\<1\>\/XI2\<1\>\/XI2\<0\>\/XI2\<0\>\/XI2\<0\>\/XI2\<0\>\/XI2\<0\>\/RR3 \
 (  \
 N_SEL3\<0\>_XI2\<0\>\/XI2\<1\>\/XI2\<1\>\/XI2\<0\>\/XI2\<0\>\/XI2\<0\>\/XI2\<0\>\/XI2\<0\>\/RR3_pos \
 N_WLSEL\<771\>_XI2\<0\>\/XI2\<1\>\/XI2\<1\>\/XI2\<0\>\/XI2\<0\>\/XI2\<0\>\/XI2\<0\>\/XI2\<0\>\/RR3_neg \
 ) R_1X_LL w=1e-07 l=1e-07   res=0.149966
XXI2\<0\>\/XI2\<1\>\/XI2\<1\>\/XI2\<0\>\/XI2\<0\>\/XI2\<0\>\/XI2\<0\>\/XI2\<0\>\/RR4 \
 (  \
 N_SEL4\<0\>_XI2\<0\>\/XI2\<1\>\/XI2\<1\>\/XI2\<0\>\/XI2\<0\>\/XI2\<0\>\/XI2\<0\>\/XI2\<0\>\/RR4_pos \
 N_WLSEL\<772\>_XI2\<0\>\/XI2\<1\>\/XI2\<1\>\/XI2\<0\>\/XI2\<0\>\/XI2\<0\>\/XI2\<0\>\/XI2\<0\>\/RR4_neg \
 ) R_1X_LL w=1e-07 l=1e-07   res=0.149966
XXI2\<0\>\/XI2\<1\>\/XI2\<1\>\/XI2\<0\>\/XI2\<0\>\/XI2\<0\>\/XI2\<0\>\/XI2\<0\>\/RR7 \
 (  \
 N_SEL5\<1\>_XI2\<0\>\/XI2\<1\>\/XI2\<1\>\/XI2\<0\>\/XI2\<0\>\/XI2\<0\>\/XI2\<0\>\/XI2\<0\>\/RR7_pos \
 N_WLSEL\<773\>_XI2\<0\>\/XI2\<1\>\/XI2\<1\>\/XI2\<0\>\/XI2\<0\>\/XI2\<0\>\/XI2\<0\>\/XI2\<0\>\/RR7_neg \
 ) R_1X_LL w=1e-07 l=1e-07   res=0.149966
XXI2\<0\>\/XI2\<1\>\/XI2\<1\>\/XI2\<0\>\/XI2\<0\>\/XI2\<0\>\/XI2\<0\>\/XI2\<0\>\/RR6 \
 (  \
 N_SEL6\<1\>_XI2\<0\>\/XI2\<1\>\/XI2\<1\>\/XI2\<0\>\/XI2\<0\>\/XI2\<0\>\/XI2\<0\>\/XI2\<0\>\/RR6_pos \
 N_WLSEL\<774\>_XI2\<0\>\/XI2\<1\>\/XI2\<1\>\/XI2\<0\>\/XI2\<0\>\/XI2\<0\>\/XI2\<0\>\/XI2\<0\>\/RR6_neg \
 ) R_1X_LL w=1e-07 l=1e-07   res=0.149966
XXI2\<0\>\/XI2\<1\>\/XI2\<1\>\/XI2\<0\>\/XI2\<0\>\/XI2\<0\>\/XI2\<0\>\/XI2\<0\>\/RR5 \
 (  \
 N_SEL7\<0\>_XI2\<0\>\/XI2\<1\>\/XI2\<1\>\/XI2\<0\>\/XI2\<0\>\/XI2\<0\>\/XI2\<0\>\/XI2\<0\>\/RR5_pos \
 N_WLSEL\<775\>_XI2\<0\>\/XI2\<1\>\/XI2\<1\>\/XI2\<0\>\/XI2\<0\>\/XI2\<0\>\/XI2\<0\>\/XI2\<0\>\/RR5_neg \
 ) R_1X_LL w=1e-07 l=1e-07   res=0.149966
XXI2\<0\>\/XI2\<1\>\/XI2\<1\>\/XI2\<0\>\/XI2\<0\>\/XI2\<0\>\/XI2\<0\>\/XI2\<1\>\/RR0 \
 (  \
 N_SEL0\<1\>_XI2\<0\>\/XI2\<1\>\/XI2\<1\>\/XI2\<0\>\/XI2\<0\>\/XI2\<0\>\/XI2\<0\>\/XI2\<1\>\/RR0_pos \
 N_WLSEL\<776\>_XI2\<0\>\/XI2\<1\>\/XI2\<1\>\/XI2\<0\>\/XI2\<0\>\/XI2\<0\>\/XI2\<0\>\/XI2\<1\>\/RR0_neg \
 ) R_1X_LL w=1e-07 l=1e-07   res=0.149966
XXI2\<0\>\/XI2\<1\>\/XI2\<1\>\/XI2\<0\>\/XI2\<0\>\/XI2\<0\>\/XI2\<0\>\/XI2\<1\>\/RR1 \
 (  \
 N_SEL1\<0\>_XI2\<0\>\/XI2\<1\>\/XI2\<1\>\/XI2\<0\>\/XI2\<0\>\/XI2\<0\>\/XI2\<0\>\/XI2\<1\>\/RR1_pos \
 N_WLSEL\<777\>_XI2\<0\>\/XI2\<1\>\/XI2\<1\>\/XI2\<0\>\/XI2\<0\>\/XI2\<0\>\/XI2\<0\>\/XI2\<1\>\/RR1_neg \
 ) R_1X_LL w=1e-07 l=1e-07   res=0.149966
XXI2\<0\>\/XI2\<1\>\/XI2\<1\>\/XI2\<0\>\/XI2\<0\>\/XI2\<0\>\/XI2\<0\>\/XI2\<1\>\/RR2 \
 (  \
 N_SEL2\<0\>_XI2\<0\>\/XI2\<1\>\/XI2\<1\>\/XI2\<0\>\/XI2\<0\>\/XI2\<0\>\/XI2\<0\>\/XI2\<1\>\/RR2_pos \
 N_WLSEL\<778\>_XI2\<0\>\/XI2\<1\>\/XI2\<1\>\/XI2\<0\>\/XI2\<0\>\/XI2\<0\>\/XI2\<0\>\/XI2\<1\>\/RR2_neg \
 ) R_1X_LL w=1e-07 l=1e-07   res=0.149966
XXI2\<0\>\/XI2\<1\>\/XI2\<1\>\/XI2\<0\>\/XI2\<0\>\/XI2\<0\>\/XI2\<0\>\/XI2\<1\>\/RR3 \
 (  \
 N_SEL3\<0\>_XI2\<0\>\/XI2\<1\>\/XI2\<1\>\/XI2\<0\>\/XI2\<0\>\/XI2\<0\>\/XI2\<0\>\/XI2\<1\>\/RR3_pos \
 N_WLSEL\<779\>_XI2\<0\>\/XI2\<1\>\/XI2\<1\>\/XI2\<0\>\/XI2\<0\>\/XI2\<0\>\/XI2\<0\>\/XI2\<1\>\/RR3_neg \
 ) R_1X_LL w=1e-07 l=1e-07   res=0.149966
XXI2\<0\>\/XI2\<1\>\/XI2\<1\>\/XI2\<0\>\/XI2\<0\>\/XI2\<0\>\/XI2\<0\>\/XI2\<1\>\/RR4 \
 (  \
 N_SEL4\<0\>_XI2\<0\>\/XI2\<1\>\/XI2\<1\>\/XI2\<0\>\/XI2\<0\>\/XI2\<0\>\/XI2\<0\>\/XI2\<1\>\/RR4_pos \
 N_WLSEL\<780\>_XI2\<0\>\/XI2\<1\>\/XI2\<1\>\/XI2\<0\>\/XI2\<0\>\/XI2\<0\>\/XI2\<0\>\/XI2\<1\>\/RR4_neg \
 ) R_1X_LL w=1e-07 l=1e-07   res=0.149966
XXI2\<0\>\/XI2\<1\>\/XI2\<1\>\/XI2\<0\>\/XI2\<0\>\/XI2\<0\>\/XI2\<0\>\/XI2\<1\>\/RR7 \
 (  \
 N_SEL5\<1\>_XI2\<0\>\/XI2\<1\>\/XI2\<1\>\/XI2\<0\>\/XI2\<0\>\/XI2\<0\>\/XI2\<0\>\/XI2\<1\>\/RR7_pos \
 N_WLSEL\<781\>_XI2\<0\>\/XI2\<1\>\/XI2\<1\>\/XI2\<0\>\/XI2\<0\>\/XI2\<0\>\/XI2\<0\>\/XI2\<1\>\/RR7_neg \
 ) R_1X_LL w=1e-07 l=1e-07   res=0.149966
XXI2\<0\>\/XI2\<0\>\/XI2\<0\>\/XI2\<1\>\/XI2\<0\>\/XI2\<1\>\/XI2\<1\>\/XI2\<1\>\/RR6 \
 (  \
 N_SEL6\<0\>_XI2\<0\>\/XI2\<0\>\/XI2\<0\>\/XI2\<1\>\/XI2\<0\>\/XI2\<1\>\/XI2\<1\>\/XI2\<1\>\/RR6_pos \
 N_WLSEL\<190\>_XI2\<0\>\/XI2\<0\>\/XI2\<0\>\/XI2\<1\>\/XI2\<0\>\/XI2\<1\>\/XI2\<1\>\/XI2\<1\>\/RR6_neg \
 ) R_1X_LL w=1e-07 l=1e-07   res=0.149966
XXI2\<0\>\/XI2\<0\>\/XI2\<0\>\/XI2\<1\>\/XI2\<0\>\/XI2\<1\>\/XI2\<1\>\/XI2\<1\>\/RR5 \
 (  \
 N_SEL7\<0\>_XI2\<0\>\/XI2\<0\>\/XI2\<0\>\/XI2\<1\>\/XI2\<0\>\/XI2\<1\>\/XI2\<1\>\/XI2\<1\>\/RR5_pos \
 N_WLSEL\<191\>_XI2\<0\>\/XI2\<0\>\/XI2\<0\>\/XI2\<1\>\/XI2\<0\>\/XI2\<1\>\/XI2\<1\>\/XI2\<1\>\/RR5_neg \
 ) R_1X_LL w=1e-07 l=1e-07   res=0.149966
XXI2\<0\>\/XI2\<0\>\/XI2\<0\>\/XI2\<1\>\/XI2\<1\>\/XI2\<0\>\/XI2\<0\>\/XI2\<0\>\/RR0 \
 (  \
 N_SEL0\<0\>_XI2\<0\>\/XI2\<0\>\/XI2\<0\>\/XI2\<1\>\/XI2\<1\>\/XI2\<0\>\/XI2\<0\>\/XI2\<0\>\/RR0_pos \
 N_WLSEL\<192\>_XI2\<0\>\/XI2\<0\>\/XI2\<0\>\/XI2\<1\>\/XI2\<1\>\/XI2\<0\>\/XI2\<0\>\/XI2\<0\>\/RR0_neg \
 ) R_1X_LL w=1e-07 l=1e-07   res=0.149966
XXI2\<0\>\/XI2\<0\>\/XI2\<0\>\/XI2\<1\>\/XI2\<1\>\/XI2\<0\>\/XI2\<0\>\/XI2\<0\>\/RR1 \
 (  \
 N_SEL1\<0\>_XI2\<0\>\/XI2\<0\>\/XI2\<0\>\/XI2\<1\>\/XI2\<1\>\/XI2\<0\>\/XI2\<0\>\/XI2\<0\>\/RR1_pos \
 N_WLSEL\<193\>_XI2\<0\>\/XI2\<0\>\/XI2\<0\>\/XI2\<1\>\/XI2\<1\>\/XI2\<0\>\/XI2\<0\>\/XI2\<0\>\/RR1_neg \
 ) R_1X_LL w=1e-07 l=1e-07   res=0.149966
XXI2\<0\>\/XI2\<0\>\/XI2\<0\>\/XI2\<1\>\/XI2\<1\>\/XI2\<0\>\/XI2\<0\>\/XI2\<0\>\/RR2 \
 (  \
 N_SEL2\<0\>_XI2\<0\>\/XI2\<0\>\/XI2\<0\>\/XI2\<1\>\/XI2\<1\>\/XI2\<0\>\/XI2\<0\>\/XI2\<0\>\/RR2_pos \
 N_WLSEL\<194\>_XI2\<0\>\/XI2\<0\>\/XI2\<0\>\/XI2\<1\>\/XI2\<1\>\/XI2\<0\>\/XI2\<0\>\/XI2\<0\>\/RR2_neg \
 ) R_1X_LL w=1e-07 l=1e-07   res=0.149966
XXI2\<0\>\/XI2\<0\>\/XI2\<0\>\/XI2\<1\>\/XI2\<1\>\/XI2\<0\>\/XI2\<0\>\/XI2\<0\>\/RR3 \
 (  \
 N_SEL3\<1\>_XI2\<0\>\/XI2\<0\>\/XI2\<0\>\/XI2\<1\>\/XI2\<1\>\/XI2\<0\>\/XI2\<0\>\/XI2\<0\>\/RR3_pos \
 N_WLSEL\<195\>_XI2\<0\>\/XI2\<0\>\/XI2\<0\>\/XI2\<1\>\/XI2\<1\>\/XI2\<0\>\/XI2\<0\>\/XI2\<0\>\/RR3_neg \
 ) R_1X_LL w=1e-07 l=1e-07   res=0.149966
XXI2\<0\>\/XI2\<0\>\/XI2\<0\>\/XI2\<1\>\/XI2\<1\>\/XI2\<0\>\/XI2\<0\>\/XI2\<0\>\/RR4 \
 (  \
 N_SEL4\<1\>_XI2\<0\>\/XI2\<0\>\/XI2\<0\>\/XI2\<1\>\/XI2\<1\>\/XI2\<0\>\/XI2\<0\>\/XI2\<0\>\/RR4_pos \
 N_WLSEL\<196\>_XI2\<0\>\/XI2\<0\>\/XI2\<0\>\/XI2\<1\>\/XI2\<1\>\/XI2\<0\>\/XI2\<0\>\/XI2\<0\>\/RR4_neg \
 ) R_1X_LL w=1e-07 l=1e-07   res=0.149966
XXI2\<0\>\/XI2\<0\>\/XI2\<0\>\/XI2\<1\>\/XI2\<1\>\/XI2\<0\>\/XI2\<0\>\/XI2\<0\>\/RR7 \
 (  \
 N_SEL5\<0\>_XI2\<0\>\/XI2\<0\>\/XI2\<0\>\/XI2\<1\>\/XI2\<1\>\/XI2\<0\>\/XI2\<0\>\/XI2\<0\>\/RR7_pos \
 N_WLSEL\<197\>_XI2\<0\>\/XI2\<0\>\/XI2\<0\>\/XI2\<1\>\/XI2\<1\>\/XI2\<0\>\/XI2\<0\>\/XI2\<0\>\/RR7_neg \
 ) R_1X_LL w=1e-07 l=1e-07   res=0.149966
XXI2\<0\>\/XI2\<0\>\/XI2\<0\>\/XI2\<1\>\/XI2\<1\>\/XI2\<0\>\/XI2\<0\>\/XI2\<0\>\/RR6 \
 (  \
 N_SEL6\<0\>_XI2\<0\>\/XI2\<0\>\/XI2\<0\>\/XI2\<1\>\/XI2\<1\>\/XI2\<0\>\/XI2\<0\>\/XI2\<0\>\/RR6_pos \
 N_WLSEL\<198\>_XI2\<0\>\/XI2\<0\>\/XI2\<0\>\/XI2\<1\>\/XI2\<1\>\/XI2\<0\>\/XI2\<0\>\/XI2\<0\>\/RR6_neg \
 ) R_1X_LL w=1e-07 l=1e-07   res=0.149966
XXI2\<0\>\/XI2\<0\>\/XI2\<0\>\/XI2\<1\>\/XI2\<1\>\/XI2\<0\>\/XI2\<0\>\/XI2\<0\>\/RR5 \
 (  \
 N_SEL7\<0\>_XI2\<0\>\/XI2\<0\>\/XI2\<0\>\/XI2\<1\>\/XI2\<1\>\/XI2\<0\>\/XI2\<0\>\/XI2\<0\>\/RR5_pos \
 N_WLSEL\<199\>_XI2\<0\>\/XI2\<0\>\/XI2\<0\>\/XI2\<1\>\/XI2\<1\>\/XI2\<0\>\/XI2\<0\>\/XI2\<0\>\/RR5_neg \
 ) R_1X_LL w=1e-07 l=1e-07   res=0.149966
XXI2\<0\>\/XI2\<0\>\/XI2\<0\>\/XI2\<1\>\/XI2\<1\>\/XI2\<0\>\/XI2\<0\>\/XI2\<1\>\/RR0 \
 (  \
 N_SEL0\<1\>_XI2\<0\>\/XI2\<0\>\/XI2\<0\>\/XI2\<1\>\/XI2\<1\>\/XI2\<0\>\/XI2\<0\>\/XI2\<1\>\/RR0_pos \
 N_WLSEL\<200\>_XI2\<0\>\/XI2\<0\>\/XI2\<0\>\/XI2\<1\>\/XI2\<1\>\/XI2\<0\>\/XI2\<0\>\/XI2\<1\>\/RR0_neg \
 ) R_1X_LL w=1e-07 l=1e-07   res=0.149966
XXI2\<0\>\/XI2\<0\>\/XI2\<0\>\/XI2\<1\>\/XI2\<1\>\/XI2\<0\>\/XI2\<0\>\/XI2\<1\>\/RR1 \
 (  \
 N_SEL1\<0\>_XI2\<0\>\/XI2\<0\>\/XI2\<0\>\/XI2\<1\>\/XI2\<1\>\/XI2\<0\>\/XI2\<0\>\/XI2\<1\>\/RR1_pos \
 N_WLSEL\<201\>_XI2\<0\>\/XI2\<0\>\/XI2\<0\>\/XI2\<1\>\/XI2\<1\>\/XI2\<0\>\/XI2\<0\>\/XI2\<1\>\/RR1_neg \
 ) R_1X_LL w=1e-07 l=1e-07   res=0.149966
XXI2\<0\>\/XI2\<0\>\/XI2\<0\>\/XI2\<1\>\/XI2\<1\>\/XI2\<0\>\/XI2\<0\>\/XI2\<1\>\/RR2 \
 (  \
 N_SEL2\<0\>_XI2\<0\>\/XI2\<0\>\/XI2\<0\>\/XI2\<1\>\/XI2\<1\>\/XI2\<0\>\/XI2\<0\>\/XI2\<1\>\/RR2_pos \
 N_WLSEL\<202\>_XI2\<0\>\/XI2\<0\>\/XI2\<0\>\/XI2\<1\>\/XI2\<1\>\/XI2\<0\>\/XI2\<0\>\/XI2\<1\>\/RR2_neg \
 ) R_1X_LL w=1e-07 l=1e-07   res=0.149966
XXI2\<0\>\/XI2\<0\>\/XI2\<0\>\/XI2\<1\>\/XI2\<1\>\/XI2\<0\>\/XI2\<0\>\/XI2\<1\>\/RR3 \
 (  \
 N_SEL3\<1\>_XI2\<0\>\/XI2\<0\>\/XI2\<0\>\/XI2\<1\>\/XI2\<1\>\/XI2\<0\>\/XI2\<0\>\/XI2\<1\>\/RR3_pos \
 N_WLSEL\<203\>_XI2\<0\>\/XI2\<0\>\/XI2\<0\>\/XI2\<1\>\/XI2\<1\>\/XI2\<0\>\/XI2\<0\>\/XI2\<1\>\/RR3_neg \
 ) R_1X_LL w=1e-07 l=1e-07   res=0.149966
XXI2\<0\>\/XI2\<0\>\/XI2\<0\>\/XI2\<1\>\/XI2\<1\>\/XI2\<0\>\/XI2\<0\>\/XI2\<1\>\/RR4 \
 (  \
 N_SEL4\<1\>_XI2\<0\>\/XI2\<0\>\/XI2\<0\>\/XI2\<1\>\/XI2\<1\>\/XI2\<0\>\/XI2\<0\>\/XI2\<1\>\/RR4_pos \
 N_WLSEL\<204\>_XI2\<0\>\/XI2\<0\>\/XI2\<0\>\/XI2\<1\>\/XI2\<1\>\/XI2\<0\>\/XI2\<0\>\/XI2\<1\>\/RR4_neg \
 ) R_1X_LL w=1e-07 l=1e-07   res=0.149966
XXI2\<0\>\/XI2\<0\>\/XI2\<0\>\/XI2\<1\>\/XI2\<1\>\/XI2\<0\>\/XI2\<0\>\/XI2\<1\>\/RR7 \
 (  \
 N_SEL5\<0\>_XI2\<0\>\/XI2\<0\>\/XI2\<0\>\/XI2\<1\>\/XI2\<1\>\/XI2\<0\>\/XI2\<0\>\/XI2\<1\>\/RR7_pos \
 N_WLSEL\<205\>_XI2\<0\>\/XI2\<0\>\/XI2\<0\>\/XI2\<1\>\/XI2\<1\>\/XI2\<0\>\/XI2\<0\>\/XI2\<1\>\/RR7_neg \
 ) R_1X_LL w=1e-07 l=1e-07   res=0.149966
XXI2\<0\>\/XI2\<0\>\/XI2\<0\>\/XI2\<1\>\/XI2\<1\>\/XI2\<0\>\/XI2\<0\>\/XI2\<1\>\/RR6 \
 (  \
 N_SEL6\<0\>_XI2\<0\>\/XI2\<0\>\/XI2\<0\>\/XI2\<1\>\/XI2\<1\>\/XI2\<0\>\/XI2\<0\>\/XI2\<1\>\/RR6_pos \
 N_WLSEL\<206\>_XI2\<0\>\/XI2\<0\>\/XI2\<0\>\/XI2\<1\>\/XI2\<1\>\/XI2\<0\>\/XI2\<0\>\/XI2\<1\>\/RR6_neg \
 ) R_1X_LL w=1e-07 l=1e-07   res=0.149966
XXI2\<0\>\/XI2\<0\>\/XI2\<0\>\/XI2\<1\>\/XI2\<1\>\/XI2\<0\>\/XI2\<0\>\/XI2\<1\>\/RR5 \
 (  \
 N_SEL7\<0\>_XI2\<0\>\/XI2\<0\>\/XI2\<0\>\/XI2\<1\>\/XI2\<1\>\/XI2\<0\>\/XI2\<0\>\/XI2\<1\>\/RR5_pos \
 N_WLSEL\<207\>_XI2\<0\>\/XI2\<0\>\/XI2\<0\>\/XI2\<1\>\/XI2\<1\>\/XI2\<0\>\/XI2\<0\>\/XI2\<1\>\/RR5_neg \
 ) R_1X_LL w=1e-07 l=1e-07   res=0.149966
XXI2\<0\>\/XI2\<0\>\/XI2\<0\>\/XI2\<1\>\/XI2\<1\>\/XI2\<0\>\/XI2\<1\>\/XI2\<0\>\/RR0 \
 (  \
 N_SEL0\<0\>_XI2\<0\>\/XI2\<0\>\/XI2\<0\>\/XI2\<1\>\/XI2\<1\>\/XI2\<0\>\/XI2\<1\>\/XI2\<0\>\/RR0_pos \
 N_WLSEL\<208\>_XI2\<0\>\/XI2\<0\>\/XI2\<0\>\/XI2\<1\>\/XI2\<1\>\/XI2\<0\>\/XI2\<1\>\/XI2\<0\>\/RR0_neg \
 ) R_1X_LL w=1e-07 l=1e-07   res=0.149966
XXI2\<0\>\/XI2\<0\>\/XI2\<0\>\/XI2\<1\>\/XI2\<1\>\/XI2\<0\>\/XI2\<1\>\/XI2\<0\>\/RR1 \
 (  \
 N_SEL1\<1\>_XI2\<0\>\/XI2\<0\>\/XI2\<0\>\/XI2\<1\>\/XI2\<1\>\/XI2\<0\>\/XI2\<1\>\/XI2\<0\>\/RR1_pos \
 N_WLSEL\<209\>_XI2\<0\>\/XI2\<0\>\/XI2\<0\>\/XI2\<1\>\/XI2\<1\>\/XI2\<0\>\/XI2\<1\>\/XI2\<0\>\/RR1_neg \
 ) R_1X_LL w=1e-07 l=1e-07   res=0.149966
XXI2\<0\>\/XI2\<0\>\/XI2\<0\>\/XI2\<1\>\/XI2\<1\>\/XI2\<0\>\/XI2\<1\>\/XI2\<0\>\/RR2 \
 (  \
 N_SEL2\<0\>_XI2\<0\>\/XI2\<0\>\/XI2\<0\>\/XI2\<1\>\/XI2\<1\>\/XI2\<0\>\/XI2\<1\>\/XI2\<0\>\/RR2_pos \
 N_WLSEL\<210\>_XI2\<0\>\/XI2\<0\>\/XI2\<0\>\/XI2\<1\>\/XI2\<1\>\/XI2\<0\>\/XI2\<1\>\/XI2\<0\>\/RR2_neg \
 ) R_1X_LL w=1e-07 l=1e-07   res=0.149966
XXI2\<0\>\/XI2\<0\>\/XI2\<0\>\/XI2\<1\>\/XI2\<1\>\/XI2\<0\>\/XI2\<1\>\/XI2\<0\>\/RR3 \
 (  \
 N_SEL3\<1\>_XI2\<0\>\/XI2\<0\>\/XI2\<0\>\/XI2\<1\>\/XI2\<1\>\/XI2\<0\>\/XI2\<1\>\/XI2\<0\>\/RR3_pos \
 N_WLSEL\<211\>_XI2\<0\>\/XI2\<0\>\/XI2\<0\>\/XI2\<1\>\/XI2\<1\>\/XI2\<0\>\/XI2\<1\>\/XI2\<0\>\/RR3_neg \
 ) R_1X_LL w=1e-07 l=1e-07   res=0.149966
XXI2\<0\>\/XI2\<0\>\/XI2\<0\>\/XI2\<1\>\/XI2\<1\>\/XI2\<0\>\/XI2\<1\>\/XI2\<0\>\/RR4 \
 (  \
 N_SEL4\<1\>_XI2\<0\>\/XI2\<0\>\/XI2\<0\>\/XI2\<1\>\/XI2\<1\>\/XI2\<0\>\/XI2\<1\>\/XI2\<0\>\/RR4_pos \
 N_WLSEL\<212\>_XI2\<0\>\/XI2\<0\>\/XI2\<0\>\/XI2\<1\>\/XI2\<1\>\/XI2\<0\>\/XI2\<1\>\/XI2\<0\>\/RR4_neg \
 ) R_1X_LL w=1e-07 l=1e-07   res=0.149966
XXI2\<0\>\/XI2\<0\>\/XI2\<0\>\/XI2\<1\>\/XI2\<1\>\/XI2\<0\>\/XI2\<1\>\/XI2\<0\>\/RR7 \
 (  \
 N_SEL5\<0\>_XI2\<0\>\/XI2\<0\>\/XI2\<0\>\/XI2\<1\>\/XI2\<1\>\/XI2\<0\>\/XI2\<1\>\/XI2\<0\>\/RR7_pos \
 N_WLSEL\<213\>_XI2\<0\>\/XI2\<0\>\/XI2\<0\>\/XI2\<1\>\/XI2\<1\>\/XI2\<0\>\/XI2\<1\>\/XI2\<0\>\/RR7_neg \
 ) R_1X_LL w=1e-07 l=1e-07   res=0.149966
XXI2\<0\>\/XI2\<0\>\/XI2\<0\>\/XI2\<1\>\/XI2\<1\>\/XI2\<0\>\/XI2\<1\>\/XI2\<0\>\/RR6 \
 (  \
 N_SEL6\<0\>_XI2\<0\>\/XI2\<0\>\/XI2\<0\>\/XI2\<1\>\/XI2\<1\>\/XI2\<0\>\/XI2\<1\>\/XI2\<0\>\/RR6_pos \
 N_WLSEL\<214\>_XI2\<0\>\/XI2\<0\>\/XI2\<0\>\/XI2\<1\>\/XI2\<1\>\/XI2\<0\>\/XI2\<1\>\/XI2\<0\>\/RR6_neg \
 ) R_1X_LL w=1e-07 l=1e-07   res=0.149966
XXI2\<0\>\/XI2\<0\>\/XI2\<0\>\/XI2\<1\>\/XI2\<1\>\/XI2\<0\>\/XI2\<1\>\/XI2\<0\>\/RR5 \
 (  \
 N_SEL7\<0\>_XI2\<0\>\/XI2\<0\>\/XI2\<0\>\/XI2\<1\>\/XI2\<1\>\/XI2\<0\>\/XI2\<1\>\/XI2\<0\>\/RR5_pos \
 N_WLSEL\<215\>_XI2\<0\>\/XI2\<0\>\/XI2\<0\>\/XI2\<1\>\/XI2\<1\>\/XI2\<0\>\/XI2\<1\>\/XI2\<0\>\/RR5_neg \
 ) R_1X_LL w=1e-07 l=1e-07   res=0.149966
XXI2\<0\>\/XI2\<0\>\/XI2\<0\>\/XI2\<1\>\/XI2\<1\>\/XI2\<0\>\/XI2\<1\>\/XI2\<1\>\/RR0 \
 (  \
 N_SEL0\<1\>_XI2\<0\>\/XI2\<0\>\/XI2\<0\>\/XI2\<1\>\/XI2\<1\>\/XI2\<0\>\/XI2\<1\>\/XI2\<1\>\/RR0_pos \
 N_WLSEL\<216\>_XI2\<0\>\/XI2\<0\>\/XI2\<0\>\/XI2\<1\>\/XI2\<1\>\/XI2\<0\>\/XI2\<1\>\/XI2\<1\>\/RR0_neg \
 ) R_1X_LL w=1e-07 l=1e-07   res=0.149966
XXI2\<0\>\/XI2\<0\>\/XI2\<0\>\/XI2\<1\>\/XI2\<1\>\/XI2\<0\>\/XI2\<1\>\/XI2\<1\>\/RR1 \
 (  \
 N_SEL1\<1\>_XI2\<0\>\/XI2\<0\>\/XI2\<0\>\/XI2\<1\>\/XI2\<1\>\/XI2\<0\>\/XI2\<1\>\/XI2\<1\>\/RR1_pos \
 N_WLSEL\<217\>_XI2\<0\>\/XI2\<0\>\/XI2\<0\>\/XI2\<1\>\/XI2\<1\>\/XI2\<0\>\/XI2\<1\>\/XI2\<1\>\/RR1_neg \
 ) R_1X_LL w=1e-07 l=1e-07   res=0.149966
XXI2\<0\>\/XI2\<0\>\/XI2\<0\>\/XI2\<1\>\/XI2\<1\>\/XI2\<0\>\/XI2\<1\>\/XI2\<1\>\/RR2 \
 (  \
 N_SEL2\<0\>_XI2\<0\>\/XI2\<0\>\/XI2\<0\>\/XI2\<1\>\/XI2\<1\>\/XI2\<0\>\/XI2\<1\>\/XI2\<1\>\/RR2_pos \
 N_WLSEL\<218\>_XI2\<0\>\/XI2\<0\>\/XI2\<0\>\/XI2\<1\>\/XI2\<1\>\/XI2\<0\>\/XI2\<1\>\/XI2\<1\>\/RR2_neg \
 ) R_1X_LL w=1e-07 l=1e-07   res=0.149966
XXI2\<0\>\/XI2\<0\>\/XI2\<0\>\/XI2\<1\>\/XI2\<1\>\/XI2\<0\>\/XI2\<1\>\/XI2\<1\>\/RR3 \
 (  \
 N_SEL3\<1\>_XI2\<0\>\/XI2\<0\>\/XI2\<0\>\/XI2\<1\>\/XI2\<1\>\/XI2\<0\>\/XI2\<1\>\/XI2\<1\>\/RR3_pos \
 N_WLSEL\<219\>_XI2\<0\>\/XI2\<0\>\/XI2\<0\>\/XI2\<1\>\/XI2\<1\>\/XI2\<0\>\/XI2\<1\>\/XI2\<1\>\/RR3_neg \
 ) R_1X_LL w=1e-07 l=1e-07   res=0.149966
XXI2\<0\>\/XI2\<0\>\/XI2\<0\>\/XI2\<1\>\/XI2\<1\>\/XI2\<0\>\/XI2\<1\>\/XI2\<1\>\/RR4 \
 (  \
 N_SEL4\<1\>_XI2\<0\>\/XI2\<0\>\/XI2\<0\>\/XI2\<1\>\/XI2\<1\>\/XI2\<0\>\/XI2\<1\>\/XI2\<1\>\/RR4_pos \
 N_WLSEL\<220\>_XI2\<0\>\/XI2\<0\>\/XI2\<0\>\/XI2\<1\>\/XI2\<1\>\/XI2\<0\>\/XI2\<1\>\/XI2\<1\>\/RR4_neg \
 ) R_1X_LL w=1e-07 l=1e-07   res=0.149966
XXI2\<0\>\/XI2\<0\>\/XI2\<0\>\/XI2\<1\>\/XI2\<1\>\/XI2\<0\>\/XI2\<1\>\/XI2\<1\>\/RR7 \
 (  \
 N_SEL5\<0\>_XI2\<0\>\/XI2\<0\>\/XI2\<0\>\/XI2\<1\>\/XI2\<1\>\/XI2\<0\>\/XI2\<1\>\/XI2\<1\>\/RR7_pos \
 N_WLSEL\<221\>_XI2\<0\>\/XI2\<0\>\/XI2\<0\>\/XI2\<1\>\/XI2\<1\>\/XI2\<0\>\/XI2\<1\>\/XI2\<1\>\/RR7_neg \
 ) R_1X_LL w=1e-07 l=1e-07   res=0.149966
XXI2\<0\>\/XI2\<0\>\/XI2\<0\>\/XI2\<1\>\/XI2\<1\>\/XI2\<0\>\/XI2\<1\>\/XI2\<1\>\/RR6 \
 (  \
 N_SEL6\<0\>_XI2\<0\>\/XI2\<0\>\/XI2\<0\>\/XI2\<1\>\/XI2\<1\>\/XI2\<0\>\/XI2\<1\>\/XI2\<1\>\/RR6_pos \
 N_WLSEL\<222\>_XI2\<0\>\/XI2\<0\>\/XI2\<0\>\/XI2\<1\>\/XI2\<1\>\/XI2\<0\>\/XI2\<1\>\/XI2\<1\>\/RR6_neg \
 ) R_1X_LL w=1e-07 l=1e-07   res=0.149966
XXI2\<0\>\/XI2\<0\>\/XI2\<0\>\/XI2\<1\>\/XI2\<1\>\/XI2\<0\>\/XI2\<1\>\/XI2\<1\>\/RR5 \
 (  \
 N_SEL7\<0\>_XI2\<0\>\/XI2\<0\>\/XI2\<0\>\/XI2\<1\>\/XI2\<1\>\/XI2\<0\>\/XI2\<1\>\/XI2\<1\>\/RR5_pos \
 N_WLSEL\<223\>_XI2\<0\>\/XI2\<0\>\/XI2\<0\>\/XI2\<1\>\/XI2\<1\>\/XI2\<0\>\/XI2\<1\>\/XI2\<1\>\/RR5_neg \
 ) R_1X_LL w=1e-07 l=1e-07   res=0.149966
XXI2\<0\>\/XI2\<0\>\/XI2\<0\>\/XI2\<1\>\/XI2\<1\>\/XI2\<1\>\/XI2\<0\>\/XI2\<0\>\/RR0 \
 (  \
 N_SEL0\<0\>_XI2\<0\>\/XI2\<0\>\/XI2\<0\>\/XI2\<1\>\/XI2\<1\>\/XI2\<1\>\/XI2\<0\>\/XI2\<0\>\/RR0_pos \
 N_WLSEL\<224\>_XI2\<0\>\/XI2\<0\>\/XI2\<0\>\/XI2\<1\>\/XI2\<1\>\/XI2\<1\>\/XI2\<0\>\/XI2\<0\>\/RR0_neg \
 ) R_1X_LL w=1e-07 l=1e-07   res=0.149966
XXI2\<0\>\/XI2\<0\>\/XI2\<0\>\/XI2\<1\>\/XI2\<1\>\/XI2\<1\>\/XI2\<0\>\/XI2\<0\>\/RR1 \
 (  \
 N_SEL1\<0\>_XI2\<0\>\/XI2\<0\>\/XI2\<0\>\/XI2\<1\>\/XI2\<1\>\/XI2\<1\>\/XI2\<0\>\/XI2\<0\>\/RR1_pos \
 N_WLSEL\<225\>_XI2\<0\>\/XI2\<0\>\/XI2\<0\>\/XI2\<1\>\/XI2\<1\>\/XI2\<1\>\/XI2\<0\>\/XI2\<0\>\/RR1_neg \
 ) R_1X_LL w=1e-07 l=1e-07   res=0.149966
XXI2\<0\>\/XI2\<0\>\/XI2\<0\>\/XI2\<1\>\/XI2\<1\>\/XI2\<1\>\/XI2\<0\>\/XI2\<0\>\/RR2 \
 (  \
 N_SEL2\<1\>_XI2\<0\>\/XI2\<0\>\/XI2\<0\>\/XI2\<1\>\/XI2\<1\>\/XI2\<1\>\/XI2\<0\>\/XI2\<0\>\/RR2_pos \
 N_WLSEL\<226\>_XI2\<0\>\/XI2\<0\>\/XI2\<0\>\/XI2\<1\>\/XI2\<1\>\/XI2\<1\>\/XI2\<0\>\/XI2\<0\>\/RR2_neg \
 ) R_1X_LL w=1e-07 l=1e-07   res=0.149966
XXI2\<0\>\/XI2\<0\>\/XI2\<0\>\/XI2\<1\>\/XI2\<1\>\/XI2\<1\>\/XI2\<0\>\/XI2\<0\>\/RR3 \
 (  \
 N_SEL3\<1\>_XI2\<0\>\/XI2\<0\>\/XI2\<0\>\/XI2\<1\>\/XI2\<1\>\/XI2\<1\>\/XI2\<0\>\/XI2\<0\>\/RR3_pos \
 N_WLSEL\<227\>_XI2\<0\>\/XI2\<0\>\/XI2\<0\>\/XI2\<1\>\/XI2\<1\>\/XI2\<1\>\/XI2\<0\>\/XI2\<0\>\/RR3_neg \
 ) R_1X_LL w=1e-07 l=1e-07   res=0.149966
XXI2\<0\>\/XI2\<0\>\/XI2\<0\>\/XI2\<1\>\/XI2\<1\>\/XI2\<1\>\/XI2\<0\>\/XI2\<0\>\/RR4 \
 (  \
 N_SEL4\<1\>_XI2\<0\>\/XI2\<0\>\/XI2\<0\>\/XI2\<1\>\/XI2\<1\>\/XI2\<1\>\/XI2\<0\>\/XI2\<0\>\/RR4_pos \
 N_WLSEL\<228\>_XI2\<0\>\/XI2\<0\>\/XI2\<0\>\/XI2\<1\>\/XI2\<1\>\/XI2\<1\>\/XI2\<0\>\/XI2\<0\>\/RR4_neg \
 ) R_1X_LL w=1e-07 l=1e-07   res=0.149966
XXI2\<0\>\/XI2\<0\>\/XI2\<0\>\/XI2\<1\>\/XI2\<1\>\/XI2\<1\>\/XI2\<0\>\/XI2\<0\>\/RR7 \
 (  \
 N_SEL5\<0\>_XI2\<0\>\/XI2\<0\>\/XI2\<0\>\/XI2\<1\>\/XI2\<1\>\/XI2\<1\>\/XI2\<0\>\/XI2\<0\>\/RR7_pos \
 N_WLSEL\<229\>_XI2\<0\>\/XI2\<0\>\/XI2\<0\>\/XI2\<1\>\/XI2\<1\>\/XI2\<1\>\/XI2\<0\>\/XI2\<0\>\/RR7_neg \
 ) R_1X_LL w=1e-07 l=1e-07   res=0.149966
XXI2\<0\>\/XI2\<0\>\/XI2\<0\>\/XI2\<1\>\/XI2\<1\>\/XI2\<1\>\/XI2\<0\>\/XI2\<0\>\/RR6 \
 (  \
 N_SEL6\<0\>_XI2\<0\>\/XI2\<0\>\/XI2\<0\>\/XI2\<1\>\/XI2\<1\>\/XI2\<1\>\/XI2\<0\>\/XI2\<0\>\/RR6_pos \
 N_WLSEL\<230\>_XI2\<0\>\/XI2\<0\>\/XI2\<0\>\/XI2\<1\>\/XI2\<1\>\/XI2\<1\>\/XI2\<0\>\/XI2\<0\>\/RR6_neg \
 ) R_1X_LL w=1e-07 l=1e-07   res=0.149966
XXI2\<0\>\/XI2\<0\>\/XI2\<0\>\/XI2\<1\>\/XI2\<1\>\/XI2\<1\>\/XI2\<0\>\/XI2\<0\>\/RR5 \
 (  \
 N_SEL7\<0\>_XI2\<0\>\/XI2\<0\>\/XI2\<0\>\/XI2\<1\>\/XI2\<1\>\/XI2\<1\>\/XI2\<0\>\/XI2\<0\>\/RR5_pos \
 N_WLSEL\<231\>_XI2\<0\>\/XI2\<0\>\/XI2\<0\>\/XI2\<1\>\/XI2\<1\>\/XI2\<1\>\/XI2\<0\>\/XI2\<0\>\/RR5_neg \
 ) R_1X_LL w=1e-07 l=1e-07   res=0.149966
XXI2\<0\>\/XI2\<0\>\/XI2\<0\>\/XI2\<1\>\/XI2\<1\>\/XI2\<1\>\/XI2\<0\>\/XI2\<1\>\/RR0 \
 (  \
 N_SEL0\<1\>_XI2\<0\>\/XI2\<0\>\/XI2\<0\>\/XI2\<1\>\/XI2\<1\>\/XI2\<1\>\/XI2\<0\>\/XI2\<1\>\/RR0_pos \
 N_WLSEL\<232\>_XI2\<0\>\/XI2\<0\>\/XI2\<0\>\/XI2\<1\>\/XI2\<1\>\/XI2\<1\>\/XI2\<0\>\/XI2\<1\>\/RR0_neg \
 ) R_1X_LL w=1e-07 l=1e-07   res=0.149966
XXI2\<0\>\/XI2\<0\>\/XI2\<0\>\/XI2\<1\>\/XI2\<1\>\/XI2\<1\>\/XI2\<0\>\/XI2\<1\>\/RR1 \
 (  \
 N_SEL1\<0\>_XI2\<0\>\/XI2\<0\>\/XI2\<0\>\/XI2\<1\>\/XI2\<1\>\/XI2\<1\>\/XI2\<0\>\/XI2\<1\>\/RR1_pos \
 N_WLSEL\<233\>_XI2\<0\>\/XI2\<0\>\/XI2\<0\>\/XI2\<1\>\/XI2\<1\>\/XI2\<1\>\/XI2\<0\>\/XI2\<1\>\/RR1_neg \
 ) R_1X_LL w=1e-07 l=1e-07   res=0.149966
XXI2\<0\>\/XI2\<0\>\/XI2\<0\>\/XI2\<1\>\/XI2\<1\>\/XI2\<1\>\/XI2\<0\>\/XI2\<1\>\/RR2 \
 (  \
 N_SEL2\<1\>_XI2\<0\>\/XI2\<0\>\/XI2\<0\>\/XI2\<1\>\/XI2\<1\>\/XI2\<1\>\/XI2\<0\>\/XI2\<1\>\/RR2_pos \
 N_WLSEL\<234\>_XI2\<0\>\/XI2\<0\>\/XI2\<0\>\/XI2\<1\>\/XI2\<1\>\/XI2\<1\>\/XI2\<0\>\/XI2\<1\>\/RR2_neg \
 ) R_1X_LL w=1e-07 l=1e-07   res=0.149966
XXI2\<0\>\/XI2\<0\>\/XI2\<0\>\/XI2\<1\>\/XI2\<1\>\/XI2\<1\>\/XI2\<0\>\/XI2\<1\>\/RR3 \
 (  \
 N_SEL3\<1\>_XI2\<0\>\/XI2\<0\>\/XI2\<0\>\/XI2\<1\>\/XI2\<1\>\/XI2\<1\>\/XI2\<0\>\/XI2\<1\>\/RR3_pos \
 N_WLSEL\<235\>_XI2\<0\>\/XI2\<0\>\/XI2\<0\>\/XI2\<1\>\/XI2\<1\>\/XI2\<1\>\/XI2\<0\>\/XI2\<1\>\/RR3_neg \
 ) R_1X_LL w=1e-07 l=1e-07   res=0.149966
XXI2\<0\>\/XI2\<0\>\/XI2\<0\>\/XI2\<1\>\/XI2\<1\>\/XI2\<1\>\/XI2\<0\>\/XI2\<1\>\/RR4 \
 (  \
 N_SEL4\<1\>_XI2\<0\>\/XI2\<0\>\/XI2\<0\>\/XI2\<1\>\/XI2\<1\>\/XI2\<1\>\/XI2\<0\>\/XI2\<1\>\/RR4_pos \
 N_WLSEL\<236\>_XI2\<0\>\/XI2\<0\>\/XI2\<0\>\/XI2\<1\>\/XI2\<1\>\/XI2\<1\>\/XI2\<0\>\/XI2\<1\>\/RR4_neg \
 ) R_1X_LL w=1e-07 l=1e-07   res=0.149966
XXI2\<0\>\/XI2\<0\>\/XI2\<0\>\/XI2\<1\>\/XI2\<1\>\/XI2\<1\>\/XI2\<0\>\/XI2\<1\>\/RR7 \
 (  \
 N_SEL5\<0\>_XI2\<0\>\/XI2\<0\>\/XI2\<0\>\/XI2\<1\>\/XI2\<1\>\/XI2\<1\>\/XI2\<0\>\/XI2\<1\>\/RR7_pos \
 N_WLSEL\<237\>_XI2\<0\>\/XI2\<0\>\/XI2\<0\>\/XI2\<1\>\/XI2\<1\>\/XI2\<1\>\/XI2\<0\>\/XI2\<1\>\/RR7_neg \
 ) R_1X_LL w=1e-07 l=1e-07   res=0.149966
XXI2\<0\>\/XI2\<0\>\/XI2\<0\>\/XI2\<1\>\/XI2\<1\>\/XI2\<1\>\/XI2\<0\>\/XI2\<1\>\/RR6 \
 (  \
 N_SEL6\<0\>_XI2\<0\>\/XI2\<0\>\/XI2\<0\>\/XI2\<1\>\/XI2\<1\>\/XI2\<1\>\/XI2\<0\>\/XI2\<1\>\/RR6_pos \
 N_WLSEL\<238\>_XI2\<0\>\/XI2\<0\>\/XI2\<0\>\/XI2\<1\>\/XI2\<1\>\/XI2\<1\>\/XI2\<0\>\/XI2\<1\>\/RR6_neg \
 ) R_1X_LL w=1e-07 l=1e-07   res=0.149966
XXI2\<0\>\/XI2\<0\>\/XI2\<0\>\/XI2\<1\>\/XI2\<1\>\/XI2\<1\>\/XI2\<0\>\/XI2\<1\>\/RR5 \
 (  \
 N_SEL7\<0\>_XI2\<0\>\/XI2\<0\>\/XI2\<0\>\/XI2\<1\>\/XI2\<1\>\/XI2\<1\>\/XI2\<0\>\/XI2\<1\>\/RR5_pos \
 N_WLSEL\<239\>_XI2\<0\>\/XI2\<0\>\/XI2\<0\>\/XI2\<1\>\/XI2\<1\>\/XI2\<1\>\/XI2\<0\>\/XI2\<1\>\/RR5_neg \
 ) R_1X_LL w=1e-07 l=1e-07   res=0.149966
XXI2\<0\>\/XI2\<0\>\/XI2\<0\>\/XI2\<1\>\/XI2\<1\>\/XI2\<1\>\/XI2\<1\>\/XI2\<0\>\/RR0 \
 (  \
 N_SEL0\<0\>_XI2\<0\>\/XI2\<0\>\/XI2\<0\>\/XI2\<1\>\/XI2\<1\>\/XI2\<1\>\/XI2\<1\>\/XI2\<0\>\/RR0_pos \
 N_WLSEL\<240\>_XI2\<0\>\/XI2\<0\>\/XI2\<0\>\/XI2\<1\>\/XI2\<1\>\/XI2\<1\>\/XI2\<1\>\/XI2\<0\>\/RR0_neg \
 ) R_1X_LL w=1e-07 l=1e-07   res=0.149966
XXI2\<0\>\/XI2\<0\>\/XI2\<0\>\/XI2\<1\>\/XI2\<1\>\/XI2\<1\>\/XI2\<1\>\/XI2\<0\>\/RR1 \
 (  \
 N_SEL1\<1\>_XI2\<0\>\/XI2\<0\>\/XI2\<0\>\/XI2\<1\>\/XI2\<1\>\/XI2\<1\>\/XI2\<1\>\/XI2\<0\>\/RR1_pos \
 N_WLSEL\<241\>_XI2\<0\>\/XI2\<0\>\/XI2\<0\>\/XI2\<1\>\/XI2\<1\>\/XI2\<1\>\/XI2\<1\>\/XI2\<0\>\/RR1_neg \
 ) R_1X_LL w=1e-07 l=1e-07   res=0.149966
XXI2\<0\>\/XI2\<0\>\/XI2\<0\>\/XI2\<1\>\/XI2\<1\>\/XI2\<1\>\/XI2\<1\>\/XI2\<0\>\/RR2 \
 (  \
 N_SEL2\<1\>_XI2\<0\>\/XI2\<0\>\/XI2\<0\>\/XI2\<1\>\/XI2\<1\>\/XI2\<1\>\/XI2\<1\>\/XI2\<0\>\/RR2_pos \
 N_WLSEL\<242\>_XI2\<0\>\/XI2\<0\>\/XI2\<0\>\/XI2\<1\>\/XI2\<1\>\/XI2\<1\>\/XI2\<1\>\/XI2\<0\>\/RR2_neg \
 ) R_1X_LL w=1e-07 l=1e-07   res=0.149966
XXI2\<0\>\/XI2\<0\>\/XI2\<0\>\/XI2\<1\>\/XI2\<1\>\/XI2\<1\>\/XI2\<1\>\/XI2\<0\>\/RR3 \
 (  \
 N_SEL3\<1\>_XI2\<0\>\/XI2\<0\>\/XI2\<0\>\/XI2\<1\>\/XI2\<1\>\/XI2\<1\>\/XI2\<1\>\/XI2\<0\>\/RR3_pos \
 N_WLSEL\<243\>_XI2\<0\>\/XI2\<0\>\/XI2\<0\>\/XI2\<1\>\/XI2\<1\>\/XI2\<1\>\/XI2\<1\>\/XI2\<0\>\/RR3_neg \
 ) R_1X_LL w=1e-07 l=1e-07   res=0.149966
XXI2\<0\>\/XI2\<0\>\/XI2\<0\>\/XI2\<1\>\/XI2\<1\>\/XI2\<1\>\/XI2\<1\>\/XI2\<0\>\/RR4 \
 (  \
 N_SEL4\<1\>_XI2\<0\>\/XI2\<0\>\/XI2\<0\>\/XI2\<1\>\/XI2\<1\>\/XI2\<1\>\/XI2\<1\>\/XI2\<0\>\/RR4_pos \
 N_WLSEL\<244\>_XI2\<0\>\/XI2\<0\>\/XI2\<0\>\/XI2\<1\>\/XI2\<1\>\/XI2\<1\>\/XI2\<1\>\/XI2\<0\>\/RR4_neg \
 ) R_1X_LL w=1e-07 l=1e-07   res=0.149966
XXI2\<0\>\/XI2\<0\>\/XI2\<0\>\/XI2\<1\>\/XI2\<1\>\/XI2\<1\>\/XI2\<1\>\/XI2\<0\>\/RR7 \
 (  \
 N_SEL5\<0\>_XI2\<0\>\/XI2\<0\>\/XI2\<0\>\/XI2\<1\>\/XI2\<1\>\/XI2\<1\>\/XI2\<1\>\/XI2\<0\>\/RR7_pos \
 N_WLSEL\<245\>_XI2\<0\>\/XI2\<0\>\/XI2\<0\>\/XI2\<1\>\/XI2\<1\>\/XI2\<1\>\/XI2\<1\>\/XI2\<0\>\/RR7_neg \
 ) R_1X_LL w=1e-07 l=1e-07   res=0.149966
XXI2\<0\>\/XI2\<0\>\/XI2\<0\>\/XI2\<1\>\/XI2\<1\>\/XI2\<1\>\/XI2\<1\>\/XI2\<0\>\/RR6 \
 (  \
 N_SEL6\<0\>_XI2\<0\>\/XI2\<0\>\/XI2\<0\>\/XI2\<1\>\/XI2\<1\>\/XI2\<1\>\/XI2\<1\>\/XI2\<0\>\/RR6_pos \
 N_WLSEL\<246\>_XI2\<0\>\/XI2\<0\>\/XI2\<0\>\/XI2\<1\>\/XI2\<1\>\/XI2\<1\>\/XI2\<1\>\/XI2\<0\>\/RR6_neg \
 ) R_1X_LL w=1e-07 l=1e-07   res=0.149966
XXI2\<0\>\/XI2\<0\>\/XI2\<0\>\/XI2\<1\>\/XI2\<1\>\/XI2\<1\>\/XI2\<1\>\/XI2\<0\>\/RR5 \
 (  \
 N_SEL7\<0\>_XI2\<0\>\/XI2\<0\>\/XI2\<0\>\/XI2\<1\>\/XI2\<1\>\/XI2\<1\>\/XI2\<1\>\/XI2\<0\>\/RR5_pos \
 N_WLSEL\<247\>_XI2\<0\>\/XI2\<0\>\/XI2\<0\>\/XI2\<1\>\/XI2\<1\>\/XI2\<1\>\/XI2\<1\>\/XI2\<0\>\/RR5_neg \
 ) R_1X_LL w=1e-07 l=1e-07   res=0.149966
XXI2\<0\>\/XI2\<0\>\/XI2\<0\>\/XI2\<1\>\/XI2\<1\>\/XI2\<1\>\/XI2\<1\>\/XI2\<1\>\/RR0 \
 (  \
 N_SEL0\<1\>_XI2\<0\>\/XI2\<0\>\/XI2\<0\>\/XI2\<1\>\/XI2\<1\>\/XI2\<1\>\/XI2\<1\>\/XI2\<1\>\/RR0_pos \
 N_WLSEL\<248\>_XI2\<0\>\/XI2\<0\>\/XI2\<0\>\/XI2\<1\>\/XI2\<1\>\/XI2\<1\>\/XI2\<1\>\/XI2\<1\>\/RR0_neg \
 ) R_1X_LL w=1e-07 l=1e-07   res=0.149966
XXI2\<0\>\/XI2\<0\>\/XI2\<0\>\/XI2\<1\>\/XI2\<1\>\/XI2\<1\>\/XI2\<1\>\/XI2\<1\>\/RR1 \
 (  \
 N_SEL1\<1\>_XI2\<0\>\/XI2\<0\>\/XI2\<0\>\/XI2\<1\>\/XI2\<1\>\/XI2\<1\>\/XI2\<1\>\/XI2\<1\>\/RR1_pos \
 N_WLSEL\<249\>_XI2\<0\>\/XI2\<0\>\/XI2\<0\>\/XI2\<1\>\/XI2\<1\>\/XI2\<1\>\/XI2\<1\>\/XI2\<1\>\/RR1_neg \
 ) R_1X_LL w=1e-07 l=1e-07   res=0.149966
XXI2\<0\>\/XI2\<0\>\/XI2\<0\>\/XI2\<1\>\/XI2\<1\>\/XI2\<1\>\/XI2\<1\>\/XI2\<1\>\/RR2 \
 (  \
 N_SEL2\<1\>_XI2\<0\>\/XI2\<0\>\/XI2\<0\>\/XI2\<1\>\/XI2\<1\>\/XI2\<1\>\/XI2\<1\>\/XI2\<1\>\/RR2_pos \
 N_WLSEL\<250\>_XI2\<0\>\/XI2\<0\>\/XI2\<0\>\/XI2\<1\>\/XI2\<1\>\/XI2\<1\>\/XI2\<1\>\/XI2\<1\>\/RR2_neg \
 ) R_1X_LL w=1e-07 l=1e-07   res=0.149966
XXI2\<0\>\/XI2\<0\>\/XI2\<0\>\/XI2\<1\>\/XI2\<1\>\/XI2\<1\>\/XI2\<1\>\/XI2\<1\>\/RR3 \
 (  \
 N_SEL3\<1\>_XI2\<0\>\/XI2\<0\>\/XI2\<0\>\/XI2\<1\>\/XI2\<1\>\/XI2\<1\>\/XI2\<1\>\/XI2\<1\>\/RR3_pos \
 N_WLSEL\<251\>_XI2\<0\>\/XI2\<0\>\/XI2\<0\>\/XI2\<1\>\/XI2\<1\>\/XI2\<1\>\/XI2\<1\>\/XI2\<1\>\/RR3_neg \
 ) R_1X_LL w=1e-07 l=1e-07   res=0.149966
XXI2\<0\>\/XI2\<0\>\/XI2\<0\>\/XI2\<1\>\/XI2\<1\>\/XI2\<1\>\/XI2\<1\>\/XI2\<1\>\/RR4 \
 (  \
 N_SEL4\<1\>_XI2\<0\>\/XI2\<0\>\/XI2\<0\>\/XI2\<1\>\/XI2\<1\>\/XI2\<1\>\/XI2\<1\>\/XI2\<1\>\/RR4_pos \
 N_WLSEL\<252\>_XI2\<0\>\/XI2\<0\>\/XI2\<0\>\/XI2\<1\>\/XI2\<1\>\/XI2\<1\>\/XI2\<1\>\/XI2\<1\>\/RR4_neg \
 ) R_1X_LL w=1e-07 l=1e-07   res=0.149966
XXI2\<0\>\/XI2\<0\>\/XI2\<0\>\/XI2\<1\>\/XI2\<1\>\/XI2\<1\>\/XI2\<1\>\/XI2\<1\>\/RR7 \
 (  \
 N_SEL5\<0\>_XI2\<0\>\/XI2\<0\>\/XI2\<0\>\/XI2\<1\>\/XI2\<1\>\/XI2\<1\>\/XI2\<1\>\/XI2\<1\>\/RR7_pos \
 N_WLSEL\<253\>_XI2\<0\>\/XI2\<0\>\/XI2\<0\>\/XI2\<1\>\/XI2\<1\>\/XI2\<1\>\/XI2\<1\>\/XI2\<1\>\/RR7_neg \
 ) R_1X_LL w=1e-07 l=1e-07   res=0.149966
XXI2\<0\>\/XI2\<0\>\/XI2\<0\>\/XI2\<1\>\/XI2\<1\>\/XI2\<1\>\/XI2\<1\>\/XI2\<1\>\/RR6 \
 (  \
 N_SEL6\<0\>_XI2\<0\>\/XI2\<0\>\/XI2\<0\>\/XI2\<1\>\/XI2\<1\>\/XI2\<1\>\/XI2\<1\>\/XI2\<1\>\/RR6_pos \
 N_WLSEL\<254\>_XI2\<0\>\/XI2\<0\>\/XI2\<0\>\/XI2\<1\>\/XI2\<1\>\/XI2\<1\>\/XI2\<1\>\/XI2\<1\>\/RR6_neg \
 ) R_1X_LL w=1e-07 l=1e-07   res=0.149966
XXI2\<0\>\/XI2\<0\>\/XI2\<0\>\/XI2\<1\>\/XI2\<1\>\/XI2\<1\>\/XI2\<1\>\/XI2\<1\>\/RR5 \
 (  \
 N_SEL7\<0\>_XI2\<0\>\/XI2\<0\>\/XI2\<0\>\/XI2\<1\>\/XI2\<1\>\/XI2\<1\>\/XI2\<1\>\/XI2\<1\>\/RR5_pos \
 N_WLSEL\<255\>_XI2\<0\>\/XI2\<0\>\/XI2\<0\>\/XI2\<1\>\/XI2\<1\>\/XI2\<1\>\/XI2\<1\>\/XI2\<1\>\/RR5_neg \
 ) R_1X_LL w=1e-07 l=1e-07   res=0.149966
XXI2\<0\>\/XI2\<0\>\/XI2\<1\>\/XI2\<0\>\/XI2\<0\>\/XI2\<0\>\/XI2\<0\>\/XI2\<0\>\/RR0 \
 (  \
 N_SEL0\<0\>_XI2\<0\>\/XI2\<0\>\/XI2\<1\>\/XI2\<0\>\/XI2\<0\>\/XI2\<0\>\/XI2\<0\>\/XI2\<0\>\/RR0_pos \
 N_WLSEL\<256\>_XI2\<0\>\/XI2\<0\>\/XI2\<1\>\/XI2\<0\>\/XI2\<0\>\/XI2\<0\>\/XI2\<0\>\/XI2\<0\>\/RR0_neg \
 ) R_1X_LL w=1e-07 l=1e-07   res=0.149966
XXI2\<0\>\/XI2\<0\>\/XI2\<1\>\/XI2\<0\>\/XI2\<0\>\/XI2\<0\>\/XI2\<0\>\/XI2\<0\>\/RR1 \
 (  \
 N_SEL1\<0\>_XI2\<0\>\/XI2\<0\>\/XI2\<1\>\/XI2\<0\>\/XI2\<0\>\/XI2\<0\>\/XI2\<0\>\/XI2\<0\>\/RR1_pos \
 N_WLSEL\<257\>_XI2\<0\>\/XI2\<0\>\/XI2\<1\>\/XI2\<0\>\/XI2\<0\>\/XI2\<0\>\/XI2\<0\>\/XI2\<0\>\/RR1_neg \
 ) R_1X_LL w=1e-07 l=1e-07   res=0.149966
XXI2\<0\>\/XI2\<0\>\/XI2\<1\>\/XI2\<0\>\/XI2\<0\>\/XI2\<0\>\/XI2\<0\>\/XI2\<0\>\/RR2 \
 (  \
 N_SEL2\<0\>_XI2\<0\>\/XI2\<0\>\/XI2\<1\>\/XI2\<0\>\/XI2\<0\>\/XI2\<0\>\/XI2\<0\>\/XI2\<0\>\/RR2_pos \
 N_WLSEL\<258\>_XI2\<0\>\/XI2\<0\>\/XI2\<1\>\/XI2\<0\>\/XI2\<0\>\/XI2\<0\>\/XI2\<0\>\/XI2\<0\>\/RR2_neg \
 ) R_1X_LL w=1e-07 l=1e-07   res=0.149966
XXI2\<0\>\/XI2\<0\>\/XI2\<1\>\/XI2\<0\>\/XI2\<0\>\/XI2\<0\>\/XI2\<0\>\/XI2\<0\>\/RR3 \
 (  \
 N_SEL3\<0\>_XI2\<0\>\/XI2\<0\>\/XI2\<1\>\/XI2\<0\>\/XI2\<0\>\/XI2\<0\>\/XI2\<0\>\/XI2\<0\>\/RR3_pos \
 N_WLSEL\<259\>_XI2\<0\>\/XI2\<0\>\/XI2\<1\>\/XI2\<0\>\/XI2\<0\>\/XI2\<0\>\/XI2\<0\>\/XI2\<0\>\/RR3_neg \
 ) R_1X_LL w=1e-07 l=1e-07   res=0.149966
XXI2\<0\>\/XI2\<0\>\/XI2\<1\>\/XI2\<0\>\/XI2\<0\>\/XI2\<0\>\/XI2\<0\>\/XI2\<0\>\/RR4 \
 (  \
 N_SEL4\<0\>_XI2\<0\>\/XI2\<0\>\/XI2\<1\>\/XI2\<0\>\/XI2\<0\>\/XI2\<0\>\/XI2\<0\>\/XI2\<0\>\/RR4_pos \
 N_WLSEL\<260\>_XI2\<0\>\/XI2\<0\>\/XI2\<1\>\/XI2\<0\>\/XI2\<0\>\/XI2\<0\>\/XI2\<0\>\/XI2\<0\>\/RR4_neg \
 ) R_1X_LL w=1e-07 l=1e-07   res=0.149966
XXI2\<0\>\/XI2\<0\>\/XI2\<1\>\/XI2\<0\>\/XI2\<0\>\/XI2\<0\>\/XI2\<0\>\/XI2\<0\>\/RR7 \
 (  \
 N_SEL5\<1\>_XI2\<0\>\/XI2\<0\>\/XI2\<1\>\/XI2\<0\>\/XI2\<0\>\/XI2\<0\>\/XI2\<0\>\/XI2\<0\>\/RR7_pos \
 N_WLSEL\<261\>_XI2\<0\>\/XI2\<0\>\/XI2\<1\>\/XI2\<0\>\/XI2\<0\>\/XI2\<0\>\/XI2\<0\>\/XI2\<0\>\/RR7_neg \
 ) R_1X_LL w=1e-07 l=1e-07   res=0.149966
XXI2\<0\>\/XI2\<0\>\/XI2\<1\>\/XI2\<0\>\/XI2\<0\>\/XI2\<0\>\/XI2\<0\>\/XI2\<0\>\/RR6 \
 (  \
 N_SEL6\<0\>_XI2\<0\>\/XI2\<0\>\/XI2\<1\>\/XI2\<0\>\/XI2\<0\>\/XI2\<0\>\/XI2\<0\>\/XI2\<0\>\/RR6_pos \
 N_WLSEL\<262\>_XI2\<0\>\/XI2\<0\>\/XI2\<1\>\/XI2\<0\>\/XI2\<0\>\/XI2\<0\>\/XI2\<0\>\/XI2\<0\>\/RR6_neg \
 ) R_1X_LL w=1e-07 l=1e-07   res=0.149966
XXI2\<0\>\/XI2\<0\>\/XI2\<1\>\/XI2\<0\>\/XI2\<0\>\/XI2\<0\>\/XI2\<0\>\/XI2\<0\>\/RR5 \
 (  \
 N_SEL7\<0\>_XI2\<0\>\/XI2\<0\>\/XI2\<1\>\/XI2\<0\>\/XI2\<0\>\/XI2\<0\>\/XI2\<0\>\/XI2\<0\>\/RR5_pos \
 N_WLSEL\<263\>_XI2\<0\>\/XI2\<0\>\/XI2\<1\>\/XI2\<0\>\/XI2\<0\>\/XI2\<0\>\/XI2\<0\>\/XI2\<0\>\/RR5_neg \
 ) R_1X_LL w=1e-07 l=1e-07   res=0.149966
XXI2\<0\>\/XI2\<0\>\/XI2\<1\>\/XI2\<0\>\/XI2\<0\>\/XI2\<0\>\/XI2\<0\>\/XI2\<1\>\/RR0 \
 (  \
 N_SEL0\<1\>_XI2\<0\>\/XI2\<0\>\/XI2\<1\>\/XI2\<0\>\/XI2\<0\>\/XI2\<0\>\/XI2\<0\>\/XI2\<1\>\/RR0_pos \
 N_WLSEL\<264\>_XI2\<0\>\/XI2\<0\>\/XI2\<1\>\/XI2\<0\>\/XI2\<0\>\/XI2\<0\>\/XI2\<0\>\/XI2\<1\>\/RR0_neg \
 ) R_1X_LL w=1e-07 l=1e-07   res=0.149966
XXI2\<0\>\/XI2\<0\>\/XI2\<1\>\/XI2\<0\>\/XI2\<0\>\/XI2\<0\>\/XI2\<0\>\/XI2\<1\>\/RR1 \
 (  \
 N_SEL1\<0\>_XI2\<0\>\/XI2\<0\>\/XI2\<1\>\/XI2\<0\>\/XI2\<0\>\/XI2\<0\>\/XI2\<0\>\/XI2\<1\>\/RR1_pos \
 N_WLSEL\<265\>_XI2\<0\>\/XI2\<0\>\/XI2\<1\>\/XI2\<0\>\/XI2\<0\>\/XI2\<0\>\/XI2\<0\>\/XI2\<1\>\/RR1_neg \
 ) R_1X_LL w=1e-07 l=1e-07   res=0.149966
XXI2\<0\>\/XI2\<0\>\/XI2\<1\>\/XI2\<0\>\/XI2\<0\>\/XI2\<0\>\/XI2\<0\>\/XI2\<1\>\/RR2 \
 (  \
 N_SEL2\<0\>_XI2\<0\>\/XI2\<0\>\/XI2\<1\>\/XI2\<0\>\/XI2\<0\>\/XI2\<0\>\/XI2\<0\>\/XI2\<1\>\/RR2_pos \
 N_WLSEL\<266\>_XI2\<0\>\/XI2\<0\>\/XI2\<1\>\/XI2\<0\>\/XI2\<0\>\/XI2\<0\>\/XI2\<0\>\/XI2\<1\>\/RR2_neg \
 ) R_1X_LL w=1e-07 l=1e-07   res=0.149966
XXI2\<0\>\/XI2\<0\>\/XI2\<1\>\/XI2\<0\>\/XI2\<0\>\/XI2\<0\>\/XI2\<0\>\/XI2\<1\>\/RR3 \
 (  \
 N_SEL3\<0\>_XI2\<0\>\/XI2\<0\>\/XI2\<1\>\/XI2\<0\>\/XI2\<0\>\/XI2\<0\>\/XI2\<0\>\/XI2\<1\>\/RR3_pos \
 N_WLSEL\<267\>_XI2\<0\>\/XI2\<0\>\/XI2\<1\>\/XI2\<0\>\/XI2\<0\>\/XI2\<0\>\/XI2\<0\>\/XI2\<1\>\/RR3_neg \
 ) R_1X_LL w=1e-07 l=1e-07   res=0.149966
XXI2\<0\>\/XI2\<0\>\/XI2\<1\>\/XI2\<0\>\/XI2\<0\>\/XI2\<0\>\/XI2\<0\>\/XI2\<1\>\/RR4 \
 (  \
 N_SEL4\<0\>_XI2\<0\>\/XI2\<0\>\/XI2\<1\>\/XI2\<0\>\/XI2\<0\>\/XI2\<0\>\/XI2\<0\>\/XI2\<1\>\/RR4_pos \
 N_WLSEL\<268\>_XI2\<0\>\/XI2\<0\>\/XI2\<1\>\/XI2\<0\>\/XI2\<0\>\/XI2\<0\>\/XI2\<0\>\/XI2\<1\>\/RR4_neg \
 ) R_1X_LL w=1e-07 l=1e-07   res=0.149966
XXI2\<0\>\/XI2\<0\>\/XI2\<1\>\/XI2\<0\>\/XI2\<0\>\/XI2\<0\>\/XI2\<0\>\/XI2\<1\>\/RR7 \
 (  \
 N_SEL5\<1\>_XI2\<0\>\/XI2\<0\>\/XI2\<1\>\/XI2\<0\>\/XI2\<0\>\/XI2\<0\>\/XI2\<0\>\/XI2\<1\>\/RR7_pos \
 N_WLSEL\<269\>_XI2\<0\>\/XI2\<0\>\/XI2\<1\>\/XI2\<0\>\/XI2\<0\>\/XI2\<0\>\/XI2\<0\>\/XI2\<1\>\/RR7_neg \
 ) R_1X_LL w=1e-07 l=1e-07   res=0.149966
XXI2\<1\>\/XI2\<1\>\/XI2\<0\>\/XI2\<0\>\/XI2\<1\>\/XI2\<1\>\/XI2\<0\>\/XI2\<1\>\/RR6 \
 (  \
 N_SEL6\<1\>_XI2\<1\>\/XI2\<1\>\/XI2\<0\>\/XI2\<0\>\/XI2\<1\>\/XI2\<1\>\/XI2\<0\>\/XI2\<1\>\/RR6_pos \
 N_WLSEL\<1646\>_XI2\<1\>\/XI2\<1\>\/XI2\<0\>\/XI2\<0\>\/XI2\<1\>\/XI2\<1\>\/XI2\<0\>\/XI2\<1\>\/RR6_neg \
 ) R_1X_LL w=1e-07 l=1e-07   res=0.149966
XXI2\<1\>\/XI2\<1\>\/XI2\<0\>\/XI2\<0\>\/XI2\<1\>\/XI2\<1\>\/XI2\<0\>\/XI2\<1\>\/RR5 \
 (  \
 N_SEL7\<1\>_XI2\<1\>\/XI2\<1\>\/XI2\<0\>\/XI2\<0\>\/XI2\<1\>\/XI2\<1\>\/XI2\<0\>\/XI2\<1\>\/RR5_pos \
 N_WLSEL\<1647\>_XI2\<1\>\/XI2\<1\>\/XI2\<0\>\/XI2\<0\>\/XI2\<1\>\/XI2\<1\>\/XI2\<0\>\/XI2\<1\>\/RR5_neg \
 ) R_1X_LL w=1e-07 l=1e-07   res=0.149966
XXI2\<1\>\/XI2\<1\>\/XI2\<0\>\/XI2\<0\>\/XI2\<1\>\/XI2\<1\>\/XI2\<1\>\/XI2\<0\>\/RR0 \
 (  \
 N_SEL0\<0\>_XI2\<1\>\/XI2\<1\>\/XI2\<0\>\/XI2\<0\>\/XI2\<1\>\/XI2\<1\>\/XI2\<1\>\/XI2\<0\>\/RR0_pos \
 N_WLSEL\<1648\>_XI2\<1\>\/XI2\<1\>\/XI2\<0\>\/XI2\<0\>\/XI2\<1\>\/XI2\<1\>\/XI2\<1\>\/XI2\<0\>\/RR0_neg \
 ) R_1X_LL w=1e-07 l=1e-07   res=0.149966
XXI2\<1\>\/XI2\<1\>\/XI2\<0\>\/XI2\<0\>\/XI2\<1\>\/XI2\<1\>\/XI2\<1\>\/XI2\<0\>\/RR1 \
 (  \
 N_SEL1\<1\>_XI2\<1\>\/XI2\<1\>\/XI2\<0\>\/XI2\<0\>\/XI2\<1\>\/XI2\<1\>\/XI2\<1\>\/XI2\<0\>\/RR1_pos \
 N_WLSEL\<1649\>_XI2\<1\>\/XI2\<1\>\/XI2\<0\>\/XI2\<0\>\/XI2\<1\>\/XI2\<1\>\/XI2\<1\>\/XI2\<0\>\/RR1_neg \
 ) R_1X_LL w=1e-07 l=1e-07   res=0.149966
XXI2\<1\>\/XI2\<1\>\/XI2\<0\>\/XI2\<0\>\/XI2\<1\>\/XI2\<1\>\/XI2\<1\>\/XI2\<0\>\/RR2 \
 (  \
 N_SEL2\<1\>_XI2\<1\>\/XI2\<1\>\/XI2\<0\>\/XI2\<0\>\/XI2\<1\>\/XI2\<1\>\/XI2\<1\>\/XI2\<0\>\/RR2_pos \
 N_WLSEL\<1650\>_XI2\<1\>\/XI2\<1\>\/XI2\<0\>\/XI2\<0\>\/XI2\<1\>\/XI2\<1\>\/XI2\<1\>\/XI2\<0\>\/RR2_neg \
 ) R_1X_LL w=1e-07 l=1e-07   res=0.149966
XXI2\<1\>\/XI2\<1\>\/XI2\<0\>\/XI2\<0\>\/XI2\<1\>\/XI2\<1\>\/XI2\<1\>\/XI2\<0\>\/RR3 \
 (  \
 N_SEL3\<1\>_XI2\<1\>\/XI2\<1\>\/XI2\<0\>\/XI2\<0\>\/XI2\<1\>\/XI2\<1\>\/XI2\<1\>\/XI2\<0\>\/RR3_pos \
 N_WLSEL\<1651\>_XI2\<1\>\/XI2\<1\>\/XI2\<0\>\/XI2\<0\>\/XI2\<1\>\/XI2\<1\>\/XI2\<1\>\/XI2\<0\>\/RR3_neg \
 ) R_1X_LL w=1e-07 l=1e-07   res=0.149966
XXI2\<1\>\/XI2\<1\>\/XI2\<0\>\/XI2\<0\>\/XI2\<1\>\/XI2\<1\>\/XI2\<1\>\/XI2\<0\>\/RR4 \
 (  \
 N_SEL4\<0\>_XI2\<1\>\/XI2\<1\>\/XI2\<0\>\/XI2\<0\>\/XI2\<1\>\/XI2\<1\>\/XI2\<1\>\/XI2\<0\>\/RR4_pos \
 N_WLSEL\<1652\>_XI2\<1\>\/XI2\<1\>\/XI2\<0\>\/XI2\<0\>\/XI2\<1\>\/XI2\<1\>\/XI2\<1\>\/XI2\<0\>\/RR4_neg \
 ) R_1X_LL w=1e-07 l=1e-07   res=0.149966
XXI2\<1\>\/XI2\<1\>\/XI2\<0\>\/XI2\<0\>\/XI2\<1\>\/XI2\<1\>\/XI2\<1\>\/XI2\<0\>\/RR7 \
 (  \
 N_SEL5\<0\>_XI2\<1\>\/XI2\<1\>\/XI2\<0\>\/XI2\<0\>\/XI2\<1\>\/XI2\<1\>\/XI2\<1\>\/XI2\<0\>\/RR7_pos \
 N_WLSEL\<1653\>_XI2\<1\>\/XI2\<1\>\/XI2\<0\>\/XI2\<0\>\/XI2\<1\>\/XI2\<1\>\/XI2\<1\>\/XI2\<0\>\/RR7_neg \
 ) R_1X_LL w=1e-07 l=1e-07   res=0.149966
XXI2\<1\>\/XI2\<1\>\/XI2\<0\>\/XI2\<0\>\/XI2\<1\>\/XI2\<1\>\/XI2\<1\>\/XI2\<0\>\/RR6 \
 (  \
 N_SEL6\<1\>_XI2\<1\>\/XI2\<1\>\/XI2\<0\>\/XI2\<0\>\/XI2\<1\>\/XI2\<1\>\/XI2\<1\>\/XI2\<0\>\/RR6_pos \
 N_WLSEL\<1654\>_XI2\<1\>\/XI2\<1\>\/XI2\<0\>\/XI2\<0\>\/XI2\<1\>\/XI2\<1\>\/XI2\<1\>\/XI2\<0\>\/RR6_neg \
 ) R_1X_LL w=1e-07 l=1e-07   res=0.149966
XXI2\<1\>\/XI2\<1\>\/XI2\<0\>\/XI2\<0\>\/XI2\<1\>\/XI2\<1\>\/XI2\<1\>\/XI2\<0\>\/RR5 \
 (  \
 N_SEL7\<1\>_XI2\<1\>\/XI2\<1\>\/XI2\<0\>\/XI2\<0\>\/XI2\<1\>\/XI2\<1\>\/XI2\<1\>\/XI2\<0\>\/RR5_pos \
 N_WLSEL\<1655\>_XI2\<1\>\/XI2\<1\>\/XI2\<0\>\/XI2\<0\>\/XI2\<1\>\/XI2\<1\>\/XI2\<1\>\/XI2\<0\>\/RR5_neg \
 ) R_1X_LL w=1e-07 l=1e-07   res=0.149966
XXI2\<1\>\/XI2\<1\>\/XI2\<0\>\/XI2\<0\>\/XI2\<1\>\/XI2\<1\>\/XI2\<1\>\/XI2\<1\>\/RR0 \
 (  \
 N_SEL0\<1\>_XI2\<1\>\/XI2\<1\>\/XI2\<0\>\/XI2\<0\>\/XI2\<1\>\/XI2\<1\>\/XI2\<1\>\/XI2\<1\>\/RR0_pos \
 N_WLSEL\<1656\>_XI2\<1\>\/XI2\<1\>\/XI2\<0\>\/XI2\<0\>\/XI2\<1\>\/XI2\<1\>\/XI2\<1\>\/XI2\<1\>\/RR0_neg \
 ) R_1X_LL w=1e-07 l=1e-07   res=0.149966
XXI2\<1\>\/XI2\<1\>\/XI2\<0\>\/XI2\<0\>\/XI2\<1\>\/XI2\<1\>\/XI2\<1\>\/XI2\<1\>\/RR1 \
 (  \
 N_SEL1\<1\>_XI2\<1\>\/XI2\<1\>\/XI2\<0\>\/XI2\<0\>\/XI2\<1\>\/XI2\<1\>\/XI2\<1\>\/XI2\<1\>\/RR1_pos \
 N_WLSEL\<1657\>_XI2\<1\>\/XI2\<1\>\/XI2\<0\>\/XI2\<0\>\/XI2\<1\>\/XI2\<1\>\/XI2\<1\>\/XI2\<1\>\/RR1_neg \
 ) R_1X_LL w=1e-07 l=1e-07   res=0.149966
XXI2\<1\>\/XI2\<1\>\/XI2\<0\>\/XI2\<0\>\/XI2\<1\>\/XI2\<1\>\/XI2\<1\>\/XI2\<1\>\/RR2 \
 (  \
 N_SEL2\<1\>_XI2\<1\>\/XI2\<1\>\/XI2\<0\>\/XI2\<0\>\/XI2\<1\>\/XI2\<1\>\/XI2\<1\>\/XI2\<1\>\/RR2_pos \
 N_WLSEL\<1658\>_XI2\<1\>\/XI2\<1\>\/XI2\<0\>\/XI2\<0\>\/XI2\<1\>\/XI2\<1\>\/XI2\<1\>\/XI2\<1\>\/RR2_neg \
 ) R_1X_LL w=1e-07 l=1e-07   res=0.149966
XXI2\<1\>\/XI2\<1\>\/XI2\<0\>\/XI2\<0\>\/XI2\<1\>\/XI2\<1\>\/XI2\<1\>\/XI2\<1\>\/RR3 \
 (  \
 N_SEL3\<1\>_XI2\<1\>\/XI2\<1\>\/XI2\<0\>\/XI2\<0\>\/XI2\<1\>\/XI2\<1\>\/XI2\<1\>\/XI2\<1\>\/RR3_pos \
 N_WLSEL\<1659\>_XI2\<1\>\/XI2\<1\>\/XI2\<0\>\/XI2\<0\>\/XI2\<1\>\/XI2\<1\>\/XI2\<1\>\/XI2\<1\>\/RR3_neg \
 ) R_1X_LL w=1e-07 l=1e-07   res=0.149966
XXI2\<1\>\/XI2\<1\>\/XI2\<0\>\/XI2\<0\>\/XI2\<1\>\/XI2\<1\>\/XI2\<1\>\/XI2\<1\>\/RR4 \
 (  \
 N_SEL4\<0\>_XI2\<1\>\/XI2\<1\>\/XI2\<0\>\/XI2\<0\>\/XI2\<1\>\/XI2\<1\>\/XI2\<1\>\/XI2\<1\>\/RR4_pos \
 N_WLSEL\<1660\>_XI2\<1\>\/XI2\<1\>\/XI2\<0\>\/XI2\<0\>\/XI2\<1\>\/XI2\<1\>\/XI2\<1\>\/XI2\<1\>\/RR4_neg \
 ) R_1X_LL w=1e-07 l=1e-07   res=0.149966
XXI2\<1\>\/XI2\<1\>\/XI2\<0\>\/XI2\<0\>\/XI2\<1\>\/XI2\<1\>\/XI2\<1\>\/XI2\<1\>\/RR7 \
 (  \
 N_SEL5\<0\>_XI2\<1\>\/XI2\<1\>\/XI2\<0\>\/XI2\<0\>\/XI2\<1\>\/XI2\<1\>\/XI2\<1\>\/XI2\<1\>\/RR7_pos \
 N_WLSEL\<1661\>_XI2\<1\>\/XI2\<1\>\/XI2\<0\>\/XI2\<0\>\/XI2\<1\>\/XI2\<1\>\/XI2\<1\>\/XI2\<1\>\/RR7_neg \
 ) R_1X_LL w=1e-07 l=1e-07   res=0.149966
XXI2\<1\>\/XI2\<1\>\/XI2\<0\>\/XI2\<0\>\/XI2\<1\>\/XI2\<1\>\/XI2\<1\>\/XI2\<1\>\/RR6 \
 (  \
 N_SEL6\<1\>_XI2\<1\>\/XI2\<1\>\/XI2\<0\>\/XI2\<0\>\/XI2\<1\>\/XI2\<1\>\/XI2\<1\>\/XI2\<1\>\/RR6_pos \
 N_WLSEL\<1662\>_XI2\<1\>\/XI2\<1\>\/XI2\<0\>\/XI2\<0\>\/XI2\<1\>\/XI2\<1\>\/XI2\<1\>\/XI2\<1\>\/RR6_neg \
 ) R_1X_LL w=1e-07 l=1e-07   res=0.149966
XXI2\<1\>\/XI2\<1\>\/XI2\<0\>\/XI2\<0\>\/XI2\<1\>\/XI2\<1\>\/XI2\<1\>\/XI2\<1\>\/RR5 \
 (  \
 N_SEL7\<1\>_XI2\<1\>\/XI2\<1\>\/XI2\<0\>\/XI2\<0\>\/XI2\<1\>\/XI2\<1\>\/XI2\<1\>\/XI2\<1\>\/RR5_pos \
 N_WLSEL\<1663\>_XI2\<1\>\/XI2\<1\>\/XI2\<0\>\/XI2\<0\>\/XI2\<1\>\/XI2\<1\>\/XI2\<1\>\/XI2\<1\>\/RR5_neg \
 ) R_1X_LL w=1e-07 l=1e-07   res=0.149966
XXI2\<1\>\/XI2\<1\>\/XI2\<0\>\/XI2\<1\>\/XI2\<0\>\/XI2\<0\>\/XI2\<0\>\/XI2\<0\>\/RR0 \
 (  \
 N_SEL0\<0\>_XI2\<1\>\/XI2\<1\>\/XI2\<0\>\/XI2\<1\>\/XI2\<0\>\/XI2\<0\>\/XI2\<0\>\/XI2\<0\>\/RR0_pos \
 N_WLSEL\<1664\>_XI2\<1\>\/XI2\<1\>\/XI2\<0\>\/XI2\<1\>\/XI2\<0\>\/XI2\<0\>\/XI2\<0\>\/XI2\<0\>\/RR0_neg \
 ) R_1X_LL w=1e-07 l=1e-07   res=0.149966
XXI2\<1\>\/XI2\<1\>\/XI2\<0\>\/XI2\<1\>\/XI2\<0\>\/XI2\<0\>\/XI2\<0\>\/XI2\<0\>\/RR1 \
 (  \
 N_SEL1\<0\>_XI2\<1\>\/XI2\<1\>\/XI2\<0\>\/XI2\<1\>\/XI2\<0\>\/XI2\<0\>\/XI2\<0\>\/XI2\<0\>\/RR1_pos \
 N_WLSEL\<1665\>_XI2\<1\>\/XI2\<1\>\/XI2\<0\>\/XI2\<1\>\/XI2\<0\>\/XI2\<0\>\/XI2\<0\>\/XI2\<0\>\/RR1_neg \
 ) R_1X_LL w=1e-07 l=1e-07   res=0.149966
XXI2\<1\>\/XI2\<1\>\/XI2\<0\>\/XI2\<1\>\/XI2\<0\>\/XI2\<0\>\/XI2\<0\>\/XI2\<0\>\/RR2 \
 (  \
 N_SEL2\<0\>_XI2\<1\>\/XI2\<1\>\/XI2\<0\>\/XI2\<1\>\/XI2\<0\>\/XI2\<0\>\/XI2\<0\>\/XI2\<0\>\/RR2_pos \
 N_WLSEL\<1666\>_XI2\<1\>\/XI2\<1\>\/XI2\<0\>\/XI2\<1\>\/XI2\<0\>\/XI2\<0\>\/XI2\<0\>\/XI2\<0\>\/RR2_neg \
 ) R_1X_LL w=1e-07 l=1e-07   res=0.149966
XXI2\<1\>\/XI2\<1\>\/XI2\<0\>\/XI2\<1\>\/XI2\<0\>\/XI2\<0\>\/XI2\<0\>\/XI2\<0\>\/RR3 \
 (  \
 N_SEL3\<0\>_XI2\<1\>\/XI2\<1\>\/XI2\<0\>\/XI2\<1\>\/XI2\<0\>\/XI2\<0\>\/XI2\<0\>\/XI2\<0\>\/RR3_pos \
 N_WLSEL\<1667\>_XI2\<1\>\/XI2\<1\>\/XI2\<0\>\/XI2\<1\>\/XI2\<0\>\/XI2\<0\>\/XI2\<0\>\/XI2\<0\>\/RR3_neg \
 ) R_1X_LL w=1e-07 l=1e-07   res=0.149966
XXI2\<1\>\/XI2\<1\>\/XI2\<0\>\/XI2\<1\>\/XI2\<0\>\/XI2\<0\>\/XI2\<0\>\/XI2\<0\>\/RR4 \
 (  \
 N_SEL4\<1\>_XI2\<1\>\/XI2\<1\>\/XI2\<0\>\/XI2\<1\>\/XI2\<0\>\/XI2\<0\>\/XI2\<0\>\/XI2\<0\>\/RR4_pos \
 N_WLSEL\<1668\>_XI2\<1\>\/XI2\<1\>\/XI2\<0\>\/XI2\<1\>\/XI2\<0\>\/XI2\<0\>\/XI2\<0\>\/XI2\<0\>\/RR4_neg \
 ) R_1X_LL w=1e-07 l=1e-07   res=0.149966
XXI2\<1\>\/XI2\<1\>\/XI2\<0\>\/XI2\<1\>\/XI2\<0\>\/XI2\<0\>\/XI2\<0\>\/XI2\<0\>\/RR7 \
 (  \
 N_SEL5\<0\>_XI2\<1\>\/XI2\<1\>\/XI2\<0\>\/XI2\<1\>\/XI2\<0\>\/XI2\<0\>\/XI2\<0\>\/XI2\<0\>\/RR7_pos \
 N_WLSEL\<1669\>_XI2\<1\>\/XI2\<1\>\/XI2\<0\>\/XI2\<1\>\/XI2\<0\>\/XI2\<0\>\/XI2\<0\>\/XI2\<0\>\/RR7_neg \
 ) R_1X_LL w=1e-07 l=1e-07   res=0.149966
XXI2\<1\>\/XI2\<1\>\/XI2\<0\>\/XI2\<1\>\/XI2\<0\>\/XI2\<0\>\/XI2\<0\>\/XI2\<0\>\/RR6 \
 (  \
 N_SEL6\<1\>_XI2\<1\>\/XI2\<1\>\/XI2\<0\>\/XI2\<1\>\/XI2\<0\>\/XI2\<0\>\/XI2\<0\>\/XI2\<0\>\/RR6_pos \
 N_WLSEL\<1670\>_XI2\<1\>\/XI2\<1\>\/XI2\<0\>\/XI2\<1\>\/XI2\<0\>\/XI2\<0\>\/XI2\<0\>\/XI2\<0\>\/RR6_neg \
 ) R_1X_LL w=1e-07 l=1e-07   res=0.149966
XXI2\<1\>\/XI2\<1\>\/XI2\<0\>\/XI2\<1\>\/XI2\<0\>\/XI2\<0\>\/XI2\<0\>\/XI2\<0\>\/RR5 \
 (  \
 N_SEL7\<1\>_XI2\<1\>\/XI2\<1\>\/XI2\<0\>\/XI2\<1\>\/XI2\<0\>\/XI2\<0\>\/XI2\<0\>\/XI2\<0\>\/RR5_pos \
 N_WLSEL\<1671\>_XI2\<1\>\/XI2\<1\>\/XI2\<0\>\/XI2\<1\>\/XI2\<0\>\/XI2\<0\>\/XI2\<0\>\/XI2\<0\>\/RR5_neg \
 ) R_1X_LL w=1e-07 l=1e-07   res=0.149966
XXI2\<1\>\/XI2\<1\>\/XI2\<0\>\/XI2\<1\>\/XI2\<0\>\/XI2\<0\>\/XI2\<0\>\/XI2\<1\>\/RR0 \
 (  \
 N_SEL0\<1\>_XI2\<1\>\/XI2\<1\>\/XI2\<0\>\/XI2\<1\>\/XI2\<0\>\/XI2\<0\>\/XI2\<0\>\/XI2\<1\>\/RR0_pos \
 N_WLSEL\<1672\>_XI2\<1\>\/XI2\<1\>\/XI2\<0\>\/XI2\<1\>\/XI2\<0\>\/XI2\<0\>\/XI2\<0\>\/XI2\<1\>\/RR0_neg \
 ) R_1X_LL w=1e-07 l=1e-07   res=0.149966
XXI2\<1\>\/XI2\<1\>\/XI2\<0\>\/XI2\<1\>\/XI2\<0\>\/XI2\<0\>\/XI2\<0\>\/XI2\<1\>\/RR1 \
 (  \
 N_SEL1\<0\>_XI2\<1\>\/XI2\<1\>\/XI2\<0\>\/XI2\<1\>\/XI2\<0\>\/XI2\<0\>\/XI2\<0\>\/XI2\<1\>\/RR1_pos \
 N_WLSEL\<1673\>_XI2\<1\>\/XI2\<1\>\/XI2\<0\>\/XI2\<1\>\/XI2\<0\>\/XI2\<0\>\/XI2\<0\>\/XI2\<1\>\/RR1_neg \
 ) R_1X_LL w=1e-07 l=1e-07   res=0.149966
XXI2\<1\>\/XI2\<1\>\/XI2\<0\>\/XI2\<1\>\/XI2\<0\>\/XI2\<0\>\/XI2\<0\>\/XI2\<1\>\/RR2 \
 (  \
 N_SEL2\<0\>_XI2\<1\>\/XI2\<1\>\/XI2\<0\>\/XI2\<1\>\/XI2\<0\>\/XI2\<0\>\/XI2\<0\>\/XI2\<1\>\/RR2_pos \
 N_WLSEL\<1674\>_XI2\<1\>\/XI2\<1\>\/XI2\<0\>\/XI2\<1\>\/XI2\<0\>\/XI2\<0\>\/XI2\<0\>\/XI2\<1\>\/RR2_neg \
 ) R_1X_LL w=1e-07 l=1e-07   res=0.149966
XXI2\<1\>\/XI2\<1\>\/XI2\<0\>\/XI2\<1\>\/XI2\<0\>\/XI2\<0\>\/XI2\<0\>\/XI2\<1\>\/RR3 \
 (  \
 N_SEL3\<0\>_XI2\<1\>\/XI2\<1\>\/XI2\<0\>\/XI2\<1\>\/XI2\<0\>\/XI2\<0\>\/XI2\<0\>\/XI2\<1\>\/RR3_pos \
 N_WLSEL\<1675\>_XI2\<1\>\/XI2\<1\>\/XI2\<0\>\/XI2\<1\>\/XI2\<0\>\/XI2\<0\>\/XI2\<0\>\/XI2\<1\>\/RR3_neg \
 ) R_1X_LL w=1e-07 l=1e-07   res=0.149966
XXI2\<1\>\/XI2\<1\>\/XI2\<0\>\/XI2\<1\>\/XI2\<0\>\/XI2\<0\>\/XI2\<0\>\/XI2\<1\>\/RR4 \
 (  \
 N_SEL4\<1\>_XI2\<1\>\/XI2\<1\>\/XI2\<0\>\/XI2\<1\>\/XI2\<0\>\/XI2\<0\>\/XI2\<0\>\/XI2\<1\>\/RR4_pos \
 N_WLSEL\<1676\>_XI2\<1\>\/XI2\<1\>\/XI2\<0\>\/XI2\<1\>\/XI2\<0\>\/XI2\<0\>\/XI2\<0\>\/XI2\<1\>\/RR4_neg \
 ) R_1X_LL w=1e-07 l=1e-07   res=0.149966
XXI2\<1\>\/XI2\<1\>\/XI2\<0\>\/XI2\<1\>\/XI2\<0\>\/XI2\<0\>\/XI2\<0\>\/XI2\<1\>\/RR7 \
 (  \
 N_SEL5\<0\>_XI2\<1\>\/XI2\<1\>\/XI2\<0\>\/XI2\<1\>\/XI2\<0\>\/XI2\<0\>\/XI2\<0\>\/XI2\<1\>\/RR7_pos \
 N_WLSEL\<1677\>_XI2\<1\>\/XI2\<1\>\/XI2\<0\>\/XI2\<1\>\/XI2\<0\>\/XI2\<0\>\/XI2\<0\>\/XI2\<1\>\/RR7_neg \
 ) R_1X_LL w=1e-07 l=1e-07   res=0.149966
XXI2\<1\>\/XI2\<1\>\/XI2\<0\>\/XI2\<1\>\/XI2\<0\>\/XI2\<0\>\/XI2\<0\>\/XI2\<1\>\/RR6 \
 (  \
 N_SEL6\<1\>_XI2\<1\>\/XI2\<1\>\/XI2\<0\>\/XI2\<1\>\/XI2\<0\>\/XI2\<0\>\/XI2\<0\>\/XI2\<1\>\/RR6_pos \
 N_WLSEL\<1678\>_XI2\<1\>\/XI2\<1\>\/XI2\<0\>\/XI2\<1\>\/XI2\<0\>\/XI2\<0\>\/XI2\<0\>\/XI2\<1\>\/RR6_neg \
 ) R_1X_LL w=1e-07 l=1e-07   res=0.149966
XXI2\<1\>\/XI2\<1\>\/XI2\<0\>\/XI2\<1\>\/XI2\<0\>\/XI2\<0\>\/XI2\<0\>\/XI2\<1\>\/RR5 \
 (  \
 N_SEL7\<1\>_XI2\<1\>\/XI2\<1\>\/XI2\<0\>\/XI2\<1\>\/XI2\<0\>\/XI2\<0\>\/XI2\<0\>\/XI2\<1\>\/RR5_pos \
 N_WLSEL\<1679\>_XI2\<1\>\/XI2\<1\>\/XI2\<0\>\/XI2\<1\>\/XI2\<0\>\/XI2\<0\>\/XI2\<0\>\/XI2\<1\>\/RR5_neg \
 ) R_1X_LL w=1e-07 l=1e-07   res=0.149966
XXI2\<1\>\/XI2\<1\>\/XI2\<0\>\/XI2\<1\>\/XI2\<0\>\/XI2\<0\>\/XI2\<1\>\/XI2\<0\>\/RR0 \
 (  \
 N_SEL0\<0\>_XI2\<1\>\/XI2\<1\>\/XI2\<0\>\/XI2\<1\>\/XI2\<0\>\/XI2\<0\>\/XI2\<1\>\/XI2\<0\>\/RR0_pos \
 N_WLSEL\<1680\>_XI2\<1\>\/XI2\<1\>\/XI2\<0\>\/XI2\<1\>\/XI2\<0\>\/XI2\<0\>\/XI2\<1\>\/XI2\<0\>\/RR0_neg \
 ) R_1X_LL w=1e-07 l=1e-07   res=0.149966
XXI2\<1\>\/XI2\<1\>\/XI2\<0\>\/XI2\<1\>\/XI2\<0\>\/XI2\<0\>\/XI2\<1\>\/XI2\<0\>\/RR1 \
 (  \
 N_SEL1\<1\>_XI2\<1\>\/XI2\<1\>\/XI2\<0\>\/XI2\<1\>\/XI2\<0\>\/XI2\<0\>\/XI2\<1\>\/XI2\<0\>\/RR1_pos \
 N_WLSEL\<1681\>_XI2\<1\>\/XI2\<1\>\/XI2\<0\>\/XI2\<1\>\/XI2\<0\>\/XI2\<0\>\/XI2\<1\>\/XI2\<0\>\/RR1_neg \
 ) R_1X_LL w=1e-07 l=1e-07   res=0.149966
XXI2\<1\>\/XI2\<1\>\/XI2\<0\>\/XI2\<1\>\/XI2\<0\>\/XI2\<0\>\/XI2\<1\>\/XI2\<0\>\/RR2 \
 (  \
 N_SEL2\<0\>_XI2\<1\>\/XI2\<1\>\/XI2\<0\>\/XI2\<1\>\/XI2\<0\>\/XI2\<0\>\/XI2\<1\>\/XI2\<0\>\/RR2_pos \
 N_WLSEL\<1682\>_XI2\<1\>\/XI2\<1\>\/XI2\<0\>\/XI2\<1\>\/XI2\<0\>\/XI2\<0\>\/XI2\<1\>\/XI2\<0\>\/RR2_neg \
 ) R_1X_LL w=1e-07 l=1e-07   res=0.149966
XXI2\<1\>\/XI2\<1\>\/XI2\<0\>\/XI2\<1\>\/XI2\<0\>\/XI2\<0\>\/XI2\<1\>\/XI2\<0\>\/RR3 \
 (  \
 N_SEL3\<0\>_XI2\<1\>\/XI2\<1\>\/XI2\<0\>\/XI2\<1\>\/XI2\<0\>\/XI2\<0\>\/XI2\<1\>\/XI2\<0\>\/RR3_pos \
 N_WLSEL\<1683\>_XI2\<1\>\/XI2\<1\>\/XI2\<0\>\/XI2\<1\>\/XI2\<0\>\/XI2\<0\>\/XI2\<1\>\/XI2\<0\>\/RR3_neg \
 ) R_1X_LL w=1e-07 l=1e-07   res=0.149966
XXI2\<1\>\/XI2\<1\>\/XI2\<0\>\/XI2\<1\>\/XI2\<0\>\/XI2\<0\>\/XI2\<1\>\/XI2\<0\>\/RR4 \
 (  \
 N_SEL4\<1\>_XI2\<1\>\/XI2\<1\>\/XI2\<0\>\/XI2\<1\>\/XI2\<0\>\/XI2\<0\>\/XI2\<1\>\/XI2\<0\>\/RR4_pos \
 N_WLSEL\<1684\>_XI2\<1\>\/XI2\<1\>\/XI2\<0\>\/XI2\<1\>\/XI2\<0\>\/XI2\<0\>\/XI2\<1\>\/XI2\<0\>\/RR4_neg \
 ) R_1X_LL w=1e-07 l=1e-07   res=0.149966
XXI2\<1\>\/XI2\<1\>\/XI2\<0\>\/XI2\<1\>\/XI2\<0\>\/XI2\<0\>\/XI2\<1\>\/XI2\<0\>\/RR7 \
 (  \
 N_SEL5\<0\>_XI2\<1\>\/XI2\<1\>\/XI2\<0\>\/XI2\<1\>\/XI2\<0\>\/XI2\<0\>\/XI2\<1\>\/XI2\<0\>\/RR7_pos \
 N_WLSEL\<1685\>_XI2\<1\>\/XI2\<1\>\/XI2\<0\>\/XI2\<1\>\/XI2\<0\>\/XI2\<0\>\/XI2\<1\>\/XI2\<0\>\/RR7_neg \
 ) R_1X_LL w=1e-07 l=1e-07   res=0.149966
XXI2\<1\>\/XI2\<1\>\/XI2\<0\>\/XI2\<1\>\/XI2\<0\>\/XI2\<0\>\/XI2\<1\>\/XI2\<0\>\/RR6 \
 (  \
 N_SEL6\<1\>_XI2\<1\>\/XI2\<1\>\/XI2\<0\>\/XI2\<1\>\/XI2\<0\>\/XI2\<0\>\/XI2\<1\>\/XI2\<0\>\/RR6_pos \
 N_WLSEL\<1686\>_XI2\<1\>\/XI2\<1\>\/XI2\<0\>\/XI2\<1\>\/XI2\<0\>\/XI2\<0\>\/XI2\<1\>\/XI2\<0\>\/RR6_neg \
 ) R_1X_LL w=1e-07 l=1e-07   res=0.149966
XXI2\<1\>\/XI2\<1\>\/XI2\<0\>\/XI2\<1\>\/XI2\<0\>\/XI2\<0\>\/XI2\<1\>\/XI2\<0\>\/RR5 \
 (  \
 N_SEL7\<1\>_XI2\<1\>\/XI2\<1\>\/XI2\<0\>\/XI2\<1\>\/XI2\<0\>\/XI2\<0\>\/XI2\<1\>\/XI2\<0\>\/RR5_pos \
 N_WLSEL\<1687\>_XI2\<1\>\/XI2\<1\>\/XI2\<0\>\/XI2\<1\>\/XI2\<0\>\/XI2\<0\>\/XI2\<1\>\/XI2\<0\>\/RR5_neg \
 ) R_1X_LL w=1e-07 l=1e-07   res=0.149966
XXI2\<1\>\/XI2\<1\>\/XI2\<0\>\/XI2\<1\>\/XI2\<0\>\/XI2\<0\>\/XI2\<1\>\/XI2\<1\>\/RR0 \
 (  \
 N_SEL0\<1\>_XI2\<1\>\/XI2\<1\>\/XI2\<0\>\/XI2\<1\>\/XI2\<0\>\/XI2\<0\>\/XI2\<1\>\/XI2\<1\>\/RR0_pos \
 N_WLSEL\<1688\>_XI2\<1\>\/XI2\<1\>\/XI2\<0\>\/XI2\<1\>\/XI2\<0\>\/XI2\<0\>\/XI2\<1\>\/XI2\<1\>\/RR0_neg \
 ) R_1X_LL w=1e-07 l=1e-07   res=0.149966
XXI2\<1\>\/XI2\<1\>\/XI2\<0\>\/XI2\<1\>\/XI2\<0\>\/XI2\<0\>\/XI2\<1\>\/XI2\<1\>\/RR1 \
 (  \
 N_SEL1\<1\>_XI2\<1\>\/XI2\<1\>\/XI2\<0\>\/XI2\<1\>\/XI2\<0\>\/XI2\<0\>\/XI2\<1\>\/XI2\<1\>\/RR1_pos \
 N_WLSEL\<1689\>_XI2\<1\>\/XI2\<1\>\/XI2\<0\>\/XI2\<1\>\/XI2\<0\>\/XI2\<0\>\/XI2\<1\>\/XI2\<1\>\/RR1_neg \
 ) R_1X_LL w=1e-07 l=1e-07   res=0.149966
XXI2\<1\>\/XI2\<1\>\/XI2\<0\>\/XI2\<1\>\/XI2\<0\>\/XI2\<0\>\/XI2\<1\>\/XI2\<1\>\/RR2 \
 (  \
 N_SEL2\<0\>_XI2\<1\>\/XI2\<1\>\/XI2\<0\>\/XI2\<1\>\/XI2\<0\>\/XI2\<0\>\/XI2\<1\>\/XI2\<1\>\/RR2_pos \
 N_WLSEL\<1690\>_XI2\<1\>\/XI2\<1\>\/XI2\<0\>\/XI2\<1\>\/XI2\<0\>\/XI2\<0\>\/XI2\<1\>\/XI2\<1\>\/RR2_neg \
 ) R_1X_LL w=1e-07 l=1e-07   res=0.149966
XXI2\<1\>\/XI2\<1\>\/XI2\<0\>\/XI2\<1\>\/XI2\<0\>\/XI2\<0\>\/XI2\<1\>\/XI2\<1\>\/RR3 \
 (  \
 N_SEL3\<0\>_XI2\<1\>\/XI2\<1\>\/XI2\<0\>\/XI2\<1\>\/XI2\<0\>\/XI2\<0\>\/XI2\<1\>\/XI2\<1\>\/RR3_pos \
 N_WLSEL\<1691\>_XI2\<1\>\/XI2\<1\>\/XI2\<0\>\/XI2\<1\>\/XI2\<0\>\/XI2\<0\>\/XI2\<1\>\/XI2\<1\>\/RR3_neg \
 ) R_1X_LL w=1e-07 l=1e-07   res=0.149966
XXI2\<1\>\/XI2\<1\>\/XI2\<0\>\/XI2\<1\>\/XI2\<0\>\/XI2\<0\>\/XI2\<1\>\/XI2\<1\>\/RR4 \
 (  \
 N_SEL4\<1\>_XI2\<1\>\/XI2\<1\>\/XI2\<0\>\/XI2\<1\>\/XI2\<0\>\/XI2\<0\>\/XI2\<1\>\/XI2\<1\>\/RR4_pos \
 N_WLSEL\<1692\>_XI2\<1\>\/XI2\<1\>\/XI2\<0\>\/XI2\<1\>\/XI2\<0\>\/XI2\<0\>\/XI2\<1\>\/XI2\<1\>\/RR4_neg \
 ) R_1X_LL w=1e-07 l=1e-07   res=0.149966
XXI2\<1\>\/XI2\<1\>\/XI2\<0\>\/XI2\<1\>\/XI2\<0\>\/XI2\<0\>\/XI2\<1\>\/XI2\<1\>\/RR7 \
 (  \
 N_SEL5\<0\>_XI2\<1\>\/XI2\<1\>\/XI2\<0\>\/XI2\<1\>\/XI2\<0\>\/XI2\<0\>\/XI2\<1\>\/XI2\<1\>\/RR7_pos \
 N_WLSEL\<1693\>_XI2\<1\>\/XI2\<1\>\/XI2\<0\>\/XI2\<1\>\/XI2\<0\>\/XI2\<0\>\/XI2\<1\>\/XI2\<1\>\/RR7_neg \
 ) R_1X_LL w=1e-07 l=1e-07   res=0.149966
XXI2\<1\>\/XI2\<1\>\/XI2\<0\>\/XI2\<1\>\/XI2\<0\>\/XI2\<0\>\/XI2\<1\>\/XI2\<1\>\/RR6 \
 (  \
 N_SEL6\<1\>_XI2\<1\>\/XI2\<1\>\/XI2\<0\>\/XI2\<1\>\/XI2\<0\>\/XI2\<0\>\/XI2\<1\>\/XI2\<1\>\/RR6_pos \
 N_WLSEL\<1694\>_XI2\<1\>\/XI2\<1\>\/XI2\<0\>\/XI2\<1\>\/XI2\<0\>\/XI2\<0\>\/XI2\<1\>\/XI2\<1\>\/RR6_neg \
 ) R_1X_LL w=1e-07 l=1e-07   res=0.149966
XXI2\<1\>\/XI2\<1\>\/XI2\<0\>\/XI2\<1\>\/XI2\<0\>\/XI2\<0\>\/XI2\<1\>\/XI2\<1\>\/RR5 \
 (  \
 N_SEL7\<1\>_XI2\<1\>\/XI2\<1\>\/XI2\<0\>\/XI2\<1\>\/XI2\<0\>\/XI2\<0\>\/XI2\<1\>\/XI2\<1\>\/RR5_pos \
 N_WLSEL\<1695\>_XI2\<1\>\/XI2\<1\>\/XI2\<0\>\/XI2\<1\>\/XI2\<0\>\/XI2\<0\>\/XI2\<1\>\/XI2\<1\>\/RR5_neg \
 ) R_1X_LL w=1e-07 l=1e-07   res=0.149966
XXI2\<1\>\/XI2\<1\>\/XI2\<0\>\/XI2\<1\>\/XI2\<0\>\/XI2\<1\>\/XI2\<0\>\/XI2\<0\>\/RR0 \
 (  \
 N_SEL0\<0\>_XI2\<1\>\/XI2\<1\>\/XI2\<0\>\/XI2\<1\>\/XI2\<0\>\/XI2\<1\>\/XI2\<0\>\/XI2\<0\>\/RR0_pos \
 N_WLSEL\<1696\>_XI2\<1\>\/XI2\<1\>\/XI2\<0\>\/XI2\<1\>\/XI2\<0\>\/XI2\<1\>\/XI2\<0\>\/XI2\<0\>\/RR0_neg \
 ) R_1X_LL w=1e-07 l=1e-07   res=0.149966
XXI2\<1\>\/XI2\<1\>\/XI2\<0\>\/XI2\<1\>\/XI2\<0\>\/XI2\<1\>\/XI2\<0\>\/XI2\<0\>\/RR1 \
 (  \
 N_SEL1\<0\>_XI2\<1\>\/XI2\<1\>\/XI2\<0\>\/XI2\<1\>\/XI2\<0\>\/XI2\<1\>\/XI2\<0\>\/XI2\<0\>\/RR1_pos \
 N_WLSEL\<1697\>_XI2\<1\>\/XI2\<1\>\/XI2\<0\>\/XI2\<1\>\/XI2\<0\>\/XI2\<1\>\/XI2\<0\>\/XI2\<0\>\/RR1_neg \
 ) R_1X_LL w=1e-07 l=1e-07   res=0.149966
XXI2\<1\>\/XI2\<1\>\/XI2\<0\>\/XI2\<1\>\/XI2\<0\>\/XI2\<1\>\/XI2\<0\>\/XI2\<0\>\/RR2 \
 (  \
 N_SEL2\<1\>_XI2\<1\>\/XI2\<1\>\/XI2\<0\>\/XI2\<1\>\/XI2\<0\>\/XI2\<1\>\/XI2\<0\>\/XI2\<0\>\/RR2_pos \
 N_WLSEL\<1698\>_XI2\<1\>\/XI2\<1\>\/XI2\<0\>\/XI2\<1\>\/XI2\<0\>\/XI2\<1\>\/XI2\<0\>\/XI2\<0\>\/RR2_neg \
 ) R_1X_LL w=1e-07 l=1e-07   res=0.149966
XXI2\<1\>\/XI2\<1\>\/XI2\<0\>\/XI2\<1\>\/XI2\<0\>\/XI2\<1\>\/XI2\<0\>\/XI2\<0\>\/RR3 \
 (  \
 N_SEL3\<0\>_XI2\<1\>\/XI2\<1\>\/XI2\<0\>\/XI2\<1\>\/XI2\<0\>\/XI2\<1\>\/XI2\<0\>\/XI2\<0\>\/RR3_pos \
 N_WLSEL\<1699\>_XI2\<1\>\/XI2\<1\>\/XI2\<0\>\/XI2\<1\>\/XI2\<0\>\/XI2\<1\>\/XI2\<0\>\/XI2\<0\>\/RR3_neg \
 ) R_1X_LL w=1e-07 l=1e-07   res=0.149966
XXI2\<1\>\/XI2\<1\>\/XI2\<0\>\/XI2\<1\>\/XI2\<0\>\/XI2\<1\>\/XI2\<0\>\/XI2\<0\>\/RR4 \
 (  \
 N_SEL4\<1\>_XI2\<1\>\/XI2\<1\>\/XI2\<0\>\/XI2\<1\>\/XI2\<0\>\/XI2\<1\>\/XI2\<0\>\/XI2\<0\>\/RR4_pos \
 N_WLSEL\<1700\>_XI2\<1\>\/XI2\<1\>\/XI2\<0\>\/XI2\<1\>\/XI2\<0\>\/XI2\<1\>\/XI2\<0\>\/XI2\<0\>\/RR4_neg \
 ) R_1X_LL w=1e-07 l=1e-07   res=0.149966
XXI2\<1\>\/XI2\<1\>\/XI2\<0\>\/XI2\<1\>\/XI2\<0\>\/XI2\<1\>\/XI2\<0\>\/XI2\<0\>\/RR7 \
 (  \
 N_SEL5\<0\>_XI2\<1\>\/XI2\<1\>\/XI2\<0\>\/XI2\<1\>\/XI2\<0\>\/XI2\<1\>\/XI2\<0\>\/XI2\<0\>\/RR7_pos \
 N_WLSEL\<1701\>_XI2\<1\>\/XI2\<1\>\/XI2\<0\>\/XI2\<1\>\/XI2\<0\>\/XI2\<1\>\/XI2\<0\>\/XI2\<0\>\/RR7_neg \
 ) R_1X_LL w=1e-07 l=1e-07   res=0.149966
XXI2\<1\>\/XI2\<1\>\/XI2\<0\>\/XI2\<1\>\/XI2\<0\>\/XI2\<1\>\/XI2\<0\>\/XI2\<0\>\/RR6 \
 (  \
 N_SEL6\<1\>_XI2\<1\>\/XI2\<1\>\/XI2\<0\>\/XI2\<1\>\/XI2\<0\>\/XI2\<1\>\/XI2\<0\>\/XI2\<0\>\/RR6_pos \
 N_WLSEL\<1702\>_XI2\<1\>\/XI2\<1\>\/XI2\<0\>\/XI2\<1\>\/XI2\<0\>\/XI2\<1\>\/XI2\<0\>\/XI2\<0\>\/RR6_neg \
 ) R_1X_LL w=1e-07 l=1e-07   res=0.149966
XXI2\<1\>\/XI2\<1\>\/XI2\<0\>\/XI2\<1\>\/XI2\<0\>\/XI2\<1\>\/XI2\<0\>\/XI2\<0\>\/RR5 \
 (  \
 N_SEL7\<1\>_XI2\<1\>\/XI2\<1\>\/XI2\<0\>\/XI2\<1\>\/XI2\<0\>\/XI2\<1\>\/XI2\<0\>\/XI2\<0\>\/RR5_pos \
 N_WLSEL\<1703\>_XI2\<1\>\/XI2\<1\>\/XI2\<0\>\/XI2\<1\>\/XI2\<0\>\/XI2\<1\>\/XI2\<0\>\/XI2\<0\>\/RR5_neg \
 ) R_1X_LL w=1e-07 l=1e-07   res=0.149966
XXI2\<1\>\/XI2\<1\>\/XI2\<0\>\/XI2\<1\>\/XI2\<0\>\/XI2\<1\>\/XI2\<0\>\/XI2\<1\>\/RR0 \
 (  \
 N_SEL0\<1\>_XI2\<1\>\/XI2\<1\>\/XI2\<0\>\/XI2\<1\>\/XI2\<0\>\/XI2\<1\>\/XI2\<0\>\/XI2\<1\>\/RR0_pos \
 N_WLSEL\<1704\>_XI2\<1\>\/XI2\<1\>\/XI2\<0\>\/XI2\<1\>\/XI2\<0\>\/XI2\<1\>\/XI2\<0\>\/XI2\<1\>\/RR0_neg \
 ) R_1X_LL w=1e-07 l=1e-07   res=0.149966
XXI2\<1\>\/XI2\<1\>\/XI2\<0\>\/XI2\<1\>\/XI2\<0\>\/XI2\<1\>\/XI2\<0\>\/XI2\<1\>\/RR1 \
 (  \
 N_SEL1\<0\>_XI2\<1\>\/XI2\<1\>\/XI2\<0\>\/XI2\<1\>\/XI2\<0\>\/XI2\<1\>\/XI2\<0\>\/XI2\<1\>\/RR1_pos \
 N_WLSEL\<1705\>_XI2\<1\>\/XI2\<1\>\/XI2\<0\>\/XI2\<1\>\/XI2\<0\>\/XI2\<1\>\/XI2\<0\>\/XI2\<1\>\/RR1_neg \
 ) R_1X_LL w=1e-07 l=1e-07   res=0.149966
XXI2\<1\>\/XI2\<1\>\/XI2\<0\>\/XI2\<1\>\/XI2\<0\>\/XI2\<1\>\/XI2\<0\>\/XI2\<1\>\/RR2 \
 (  \
 N_SEL2\<1\>_XI2\<1\>\/XI2\<1\>\/XI2\<0\>\/XI2\<1\>\/XI2\<0\>\/XI2\<1\>\/XI2\<0\>\/XI2\<1\>\/RR2_pos \
 N_WLSEL\<1706\>_XI2\<1\>\/XI2\<1\>\/XI2\<0\>\/XI2\<1\>\/XI2\<0\>\/XI2\<1\>\/XI2\<0\>\/XI2\<1\>\/RR2_neg \
 ) R_1X_LL w=1e-07 l=1e-07   res=0.149966
XXI2\<1\>\/XI2\<1\>\/XI2\<0\>\/XI2\<1\>\/XI2\<0\>\/XI2\<1\>\/XI2\<0\>\/XI2\<1\>\/RR3 \
 (  \
 N_SEL3\<0\>_XI2\<1\>\/XI2\<1\>\/XI2\<0\>\/XI2\<1\>\/XI2\<0\>\/XI2\<1\>\/XI2\<0\>\/XI2\<1\>\/RR3_pos \
 N_WLSEL\<1707\>_XI2\<1\>\/XI2\<1\>\/XI2\<0\>\/XI2\<1\>\/XI2\<0\>\/XI2\<1\>\/XI2\<0\>\/XI2\<1\>\/RR3_neg \
 ) R_1X_LL w=1e-07 l=1e-07   res=0.149966
XXI2\<1\>\/XI2\<1\>\/XI2\<0\>\/XI2\<1\>\/XI2\<0\>\/XI2\<1\>\/XI2\<0\>\/XI2\<1\>\/RR4 \
 (  \
 N_SEL4\<1\>_XI2\<1\>\/XI2\<1\>\/XI2\<0\>\/XI2\<1\>\/XI2\<0\>\/XI2\<1\>\/XI2\<0\>\/XI2\<1\>\/RR4_pos \
 N_WLSEL\<1708\>_XI2\<1\>\/XI2\<1\>\/XI2\<0\>\/XI2\<1\>\/XI2\<0\>\/XI2\<1\>\/XI2\<0\>\/XI2\<1\>\/RR4_neg \
 ) R_1X_LL w=1e-07 l=1e-07   res=0.149966
XXI2\<1\>\/XI2\<1\>\/XI2\<0\>\/XI2\<1\>\/XI2\<0\>\/XI2\<1\>\/XI2\<0\>\/XI2\<1\>\/RR7 \
 (  \
 N_SEL5\<0\>_XI2\<1\>\/XI2\<1\>\/XI2\<0\>\/XI2\<1\>\/XI2\<0\>\/XI2\<1\>\/XI2\<0\>\/XI2\<1\>\/RR7_pos \
 N_WLSEL\<1709\>_XI2\<1\>\/XI2\<1\>\/XI2\<0\>\/XI2\<1\>\/XI2\<0\>\/XI2\<1\>\/XI2\<0\>\/XI2\<1\>\/RR7_neg \
 ) R_1X_LL w=1e-07 l=1e-07   res=0.149966
XXI2\<1\>\/XI2\<1\>\/XI2\<0\>\/XI2\<1\>\/XI2\<0\>\/XI2\<1\>\/XI2\<0\>\/XI2\<1\>\/RR6 \
 (  \
 N_SEL6\<1\>_XI2\<1\>\/XI2\<1\>\/XI2\<0\>\/XI2\<1\>\/XI2\<0\>\/XI2\<1\>\/XI2\<0\>\/XI2\<1\>\/RR6_pos \
 N_WLSEL\<1710\>_XI2\<1\>\/XI2\<1\>\/XI2\<0\>\/XI2\<1\>\/XI2\<0\>\/XI2\<1\>\/XI2\<0\>\/XI2\<1\>\/RR6_neg \
 ) R_1X_LL w=1e-07 l=1e-07   res=0.149966
XXI2\<1\>\/XI2\<1\>\/XI2\<0\>\/XI2\<1\>\/XI2\<0\>\/XI2\<1\>\/XI2\<0\>\/XI2\<1\>\/RR5 \
 (  \
 N_SEL7\<1\>_XI2\<1\>\/XI2\<1\>\/XI2\<0\>\/XI2\<1\>\/XI2\<0\>\/XI2\<1\>\/XI2\<0\>\/XI2\<1\>\/RR5_pos \
 N_WLSEL\<1711\>_XI2\<1\>\/XI2\<1\>\/XI2\<0\>\/XI2\<1\>\/XI2\<0\>\/XI2\<1\>\/XI2\<0\>\/XI2\<1\>\/RR5_neg \
 ) R_1X_LL w=1e-07 l=1e-07   res=0.149966
XXI2\<1\>\/XI2\<1\>\/XI2\<0\>\/XI2\<1\>\/XI2\<0\>\/XI2\<1\>\/XI2\<1\>\/XI2\<0\>\/RR0 \
 (  \
 N_SEL0\<0\>_XI2\<1\>\/XI2\<1\>\/XI2\<0\>\/XI2\<1\>\/XI2\<0\>\/XI2\<1\>\/XI2\<1\>\/XI2\<0\>\/RR0_pos \
 N_WLSEL\<1712\>_XI2\<1\>\/XI2\<1\>\/XI2\<0\>\/XI2\<1\>\/XI2\<0\>\/XI2\<1\>\/XI2\<1\>\/XI2\<0\>\/RR0_neg \
 ) R_1X_LL w=1e-07 l=1e-07   res=0.149966
XXI2\<1\>\/XI2\<1\>\/XI2\<0\>\/XI2\<1\>\/XI2\<0\>\/XI2\<1\>\/XI2\<1\>\/XI2\<0\>\/RR1 \
 (  \
 N_SEL1\<1\>_XI2\<1\>\/XI2\<1\>\/XI2\<0\>\/XI2\<1\>\/XI2\<0\>\/XI2\<1\>\/XI2\<1\>\/XI2\<0\>\/RR1_pos \
 N_WLSEL\<1713\>_XI2\<1\>\/XI2\<1\>\/XI2\<0\>\/XI2\<1\>\/XI2\<0\>\/XI2\<1\>\/XI2\<1\>\/XI2\<0\>\/RR1_neg \
 ) R_1X_LL w=1e-07 l=1e-07   res=0.149966
XXI2\<1\>\/XI2\<1\>\/XI2\<0\>\/XI2\<1\>\/XI2\<0\>\/XI2\<1\>\/XI2\<1\>\/XI2\<0\>\/RR2 \
 (  \
 N_SEL2\<1\>_XI2\<1\>\/XI2\<1\>\/XI2\<0\>\/XI2\<1\>\/XI2\<0\>\/XI2\<1\>\/XI2\<1\>\/XI2\<0\>\/RR2_pos \
 N_WLSEL\<1714\>_XI2\<1\>\/XI2\<1\>\/XI2\<0\>\/XI2\<1\>\/XI2\<0\>\/XI2\<1\>\/XI2\<1\>\/XI2\<0\>\/RR2_neg \
 ) R_1X_LL w=1e-07 l=1e-07   res=0.149966
XXI2\<1\>\/XI2\<1\>\/XI2\<0\>\/XI2\<1\>\/XI2\<0\>\/XI2\<1\>\/XI2\<1\>\/XI2\<0\>\/RR3 \
 (  \
 N_SEL3\<0\>_XI2\<1\>\/XI2\<1\>\/XI2\<0\>\/XI2\<1\>\/XI2\<0\>\/XI2\<1\>\/XI2\<1\>\/XI2\<0\>\/RR3_pos \
 N_WLSEL\<1715\>_XI2\<1\>\/XI2\<1\>\/XI2\<0\>\/XI2\<1\>\/XI2\<0\>\/XI2\<1\>\/XI2\<1\>\/XI2\<0\>\/RR3_neg \
 ) R_1X_LL w=1e-07 l=1e-07   res=0.149966
XXI2\<1\>\/XI2\<1\>\/XI2\<0\>\/XI2\<1\>\/XI2\<0\>\/XI2\<1\>\/XI2\<1\>\/XI2\<0\>\/RR4 \
 (  \
 N_SEL4\<1\>_XI2\<1\>\/XI2\<1\>\/XI2\<0\>\/XI2\<1\>\/XI2\<0\>\/XI2\<1\>\/XI2\<1\>\/XI2\<0\>\/RR4_pos \
 N_WLSEL\<1716\>_XI2\<1\>\/XI2\<1\>\/XI2\<0\>\/XI2\<1\>\/XI2\<0\>\/XI2\<1\>\/XI2\<1\>\/XI2\<0\>\/RR4_neg \
 ) R_1X_LL w=1e-07 l=1e-07   res=0.149966
XXI2\<1\>\/XI2\<1\>\/XI2\<0\>\/XI2\<1\>\/XI2\<0\>\/XI2\<1\>\/XI2\<1\>\/XI2\<0\>\/RR7 \
 (  \
 N_SEL5\<0\>_XI2\<1\>\/XI2\<1\>\/XI2\<0\>\/XI2\<1\>\/XI2\<0\>\/XI2\<1\>\/XI2\<1\>\/XI2\<0\>\/RR7_pos \
 N_WLSEL\<1717\>_XI2\<1\>\/XI2\<1\>\/XI2\<0\>\/XI2\<1\>\/XI2\<0\>\/XI2\<1\>\/XI2\<1\>\/XI2\<0\>\/RR7_neg \
 ) R_1X_LL w=1e-07 l=1e-07   res=0.149966
XXI2\<1\>\/XI2\<1\>\/XI2\<0\>\/XI2\<1\>\/XI2\<0\>\/XI2\<1\>\/XI2\<1\>\/XI2\<0\>\/RR6 \
 (  \
 N_SEL6\<1\>_XI2\<1\>\/XI2\<1\>\/XI2\<0\>\/XI2\<1\>\/XI2\<0\>\/XI2\<1\>\/XI2\<1\>\/XI2\<0\>\/RR6_pos \
 N_WLSEL\<1718\>_XI2\<1\>\/XI2\<1\>\/XI2\<0\>\/XI2\<1\>\/XI2\<0\>\/XI2\<1\>\/XI2\<1\>\/XI2\<0\>\/RR6_neg \
 ) R_1X_LL w=1e-07 l=1e-07   res=0.149966
XXI2\<1\>\/XI2\<1\>\/XI2\<0\>\/XI2\<1\>\/XI2\<0\>\/XI2\<1\>\/XI2\<1\>\/XI2\<0\>\/RR5 \
 (  \
 N_SEL7\<1\>_XI2\<1\>\/XI2\<1\>\/XI2\<0\>\/XI2\<1\>\/XI2\<0\>\/XI2\<1\>\/XI2\<1\>\/XI2\<0\>\/RR5_pos \
 N_WLSEL\<1719\>_XI2\<1\>\/XI2\<1\>\/XI2\<0\>\/XI2\<1\>\/XI2\<0\>\/XI2\<1\>\/XI2\<1\>\/XI2\<0\>\/RR5_neg \
 ) R_1X_LL w=1e-07 l=1e-07   res=0.149966
XXI2\<1\>\/XI2\<1\>\/XI2\<0\>\/XI2\<1\>\/XI2\<0\>\/XI2\<1\>\/XI2\<1\>\/XI2\<1\>\/RR0 \
 (  \
 N_SEL0\<1\>_XI2\<1\>\/XI2\<1\>\/XI2\<0\>\/XI2\<1\>\/XI2\<0\>\/XI2\<1\>\/XI2\<1\>\/XI2\<1\>\/RR0_pos \
 N_WLSEL\<1720\>_XI2\<1\>\/XI2\<1\>\/XI2\<0\>\/XI2\<1\>\/XI2\<0\>\/XI2\<1\>\/XI2\<1\>\/XI2\<1\>\/RR0_neg \
 ) R_1X_LL w=1e-07 l=1e-07   res=0.149966
XXI2\<1\>\/XI2\<1\>\/XI2\<0\>\/XI2\<1\>\/XI2\<0\>\/XI2\<1\>\/XI2\<1\>\/XI2\<1\>\/RR1 \
 (  \
 N_SEL1\<1\>_XI2\<1\>\/XI2\<1\>\/XI2\<0\>\/XI2\<1\>\/XI2\<0\>\/XI2\<1\>\/XI2\<1\>\/XI2\<1\>\/RR1_pos \
 N_WLSEL\<1721\>_XI2\<1\>\/XI2\<1\>\/XI2\<0\>\/XI2\<1\>\/XI2\<0\>\/XI2\<1\>\/XI2\<1\>\/XI2\<1\>\/RR1_neg \
 ) R_1X_LL w=1e-07 l=1e-07   res=0.149966
XXI2\<1\>\/XI2\<1\>\/XI2\<0\>\/XI2\<1\>\/XI2\<0\>\/XI2\<1\>\/XI2\<1\>\/XI2\<1\>\/RR2 \
 (  \
 N_SEL2\<1\>_XI2\<1\>\/XI2\<1\>\/XI2\<0\>\/XI2\<1\>\/XI2\<0\>\/XI2\<1\>\/XI2\<1\>\/XI2\<1\>\/RR2_pos \
 N_WLSEL\<1722\>_XI2\<1\>\/XI2\<1\>\/XI2\<0\>\/XI2\<1\>\/XI2\<0\>\/XI2\<1\>\/XI2\<1\>\/XI2\<1\>\/RR2_neg \
 ) R_1X_LL w=1e-07 l=1e-07   res=0.149966
XXI2\<1\>\/XI2\<1\>\/XI2\<0\>\/XI2\<1\>\/XI2\<0\>\/XI2\<1\>\/XI2\<1\>\/XI2\<1\>\/RR3 \
 (  \
 N_SEL3\<0\>_XI2\<1\>\/XI2\<1\>\/XI2\<0\>\/XI2\<1\>\/XI2\<0\>\/XI2\<1\>\/XI2\<1\>\/XI2\<1\>\/RR3_pos \
 N_WLSEL\<1723\>_XI2\<1\>\/XI2\<1\>\/XI2\<0\>\/XI2\<1\>\/XI2\<0\>\/XI2\<1\>\/XI2\<1\>\/XI2\<1\>\/RR3_neg \
 ) R_1X_LL w=1e-07 l=1e-07   res=0.149966
XXI2\<1\>\/XI2\<1\>\/XI2\<0\>\/XI2\<1\>\/XI2\<0\>\/XI2\<1\>\/XI2\<1\>\/XI2\<1\>\/RR4 \
 (  \
 N_SEL4\<1\>_XI2\<1\>\/XI2\<1\>\/XI2\<0\>\/XI2\<1\>\/XI2\<0\>\/XI2\<1\>\/XI2\<1\>\/XI2\<1\>\/RR4_pos \
 N_WLSEL\<1724\>_XI2\<1\>\/XI2\<1\>\/XI2\<0\>\/XI2\<1\>\/XI2\<0\>\/XI2\<1\>\/XI2\<1\>\/XI2\<1\>\/RR4_neg \
 ) R_1X_LL w=1e-07 l=1e-07   res=0.149966
XXI2\<1\>\/XI2\<1\>\/XI2\<0\>\/XI2\<1\>\/XI2\<0\>\/XI2\<1\>\/XI2\<1\>\/XI2\<1\>\/RR7 \
 (  \
 N_SEL5\<0\>_XI2\<1\>\/XI2\<1\>\/XI2\<0\>\/XI2\<1\>\/XI2\<0\>\/XI2\<1\>\/XI2\<1\>\/XI2\<1\>\/RR7_pos \
 N_WLSEL\<1725\>_XI2\<1\>\/XI2\<1\>\/XI2\<0\>\/XI2\<1\>\/XI2\<0\>\/XI2\<1\>\/XI2\<1\>\/XI2\<1\>\/RR7_neg \
 ) R_1X_LL w=1e-07 l=1e-07   res=0.149966
XXI2\<1\>\/XI2\<0\>\/XI2\<0\>\/XI2\<0\>\/XI2\<1\>\/XI2\<1\>\/XI2\<0\>\/XI2\<1\>\/RR6 \
 (  \
 N_SEL6\<0\>_XI2\<1\>\/XI2\<0\>\/XI2\<0\>\/XI2\<0\>\/XI2\<1\>\/XI2\<1\>\/XI2\<0\>\/XI2\<1\>\/RR6_pos \
 N_WLSEL\<1134\>_XI2\<1\>\/XI2\<0\>\/XI2\<0\>\/XI2\<0\>\/XI2\<1\>\/XI2\<1\>\/XI2\<0\>\/XI2\<1\>\/RR6_neg \
 ) R_1X_LL w=1e-07 l=1e-07   res=0.149966
XXI2\<1\>\/XI2\<0\>\/XI2\<0\>\/XI2\<0\>\/XI2\<1\>\/XI2\<1\>\/XI2\<0\>\/XI2\<1\>\/RR5 \
 (  \
 N_SEL7\<1\>_XI2\<1\>\/XI2\<0\>\/XI2\<0\>\/XI2\<0\>\/XI2\<1\>\/XI2\<1\>\/XI2\<0\>\/XI2\<1\>\/RR5_pos \
 N_WLSEL\<1135\>_XI2\<1\>\/XI2\<0\>\/XI2\<0\>\/XI2\<0\>\/XI2\<1\>\/XI2\<1\>\/XI2\<0\>\/XI2\<1\>\/RR5_neg \
 ) R_1X_LL w=1e-07 l=1e-07   res=0.149966
XXI2\<1\>\/XI2\<0\>\/XI2\<0\>\/XI2\<0\>\/XI2\<1\>\/XI2\<1\>\/XI2\<1\>\/XI2\<0\>\/RR0 \
 (  \
 N_SEL0\<0\>_XI2\<1\>\/XI2\<0\>\/XI2\<0\>\/XI2\<0\>\/XI2\<1\>\/XI2\<1\>\/XI2\<1\>\/XI2\<0\>\/RR0_pos \
 N_WLSEL\<1136\>_XI2\<1\>\/XI2\<0\>\/XI2\<0\>\/XI2\<0\>\/XI2\<1\>\/XI2\<1\>\/XI2\<1\>\/XI2\<0\>\/RR0_neg \
 ) R_1X_LL w=1e-07 l=1e-07   res=0.149966
XXI2\<1\>\/XI2\<0\>\/XI2\<0\>\/XI2\<0\>\/XI2\<1\>\/XI2\<1\>\/XI2\<1\>\/XI2\<0\>\/RR1 \
 (  \
 N_SEL1\<1\>_XI2\<1\>\/XI2\<0\>\/XI2\<0\>\/XI2\<0\>\/XI2\<1\>\/XI2\<1\>\/XI2\<1\>\/XI2\<0\>\/RR1_pos \
 N_WLSEL\<1137\>_XI2\<1\>\/XI2\<0\>\/XI2\<0\>\/XI2\<0\>\/XI2\<1\>\/XI2\<1\>\/XI2\<1\>\/XI2\<0\>\/RR1_neg \
 ) R_1X_LL w=1e-07 l=1e-07   res=0.149966
XXI2\<1\>\/XI2\<0\>\/XI2\<0\>\/XI2\<0\>\/XI2\<1\>\/XI2\<1\>\/XI2\<1\>\/XI2\<0\>\/RR2 \
 (  \
 N_SEL2\<1\>_XI2\<1\>\/XI2\<0\>\/XI2\<0\>\/XI2\<0\>\/XI2\<1\>\/XI2\<1\>\/XI2\<1\>\/XI2\<0\>\/RR2_pos \
 N_WLSEL\<1138\>_XI2\<1\>\/XI2\<0\>\/XI2\<0\>\/XI2\<0\>\/XI2\<1\>\/XI2\<1\>\/XI2\<1\>\/XI2\<0\>\/RR2_neg \
 ) R_1X_LL w=1e-07 l=1e-07   res=0.149966
XXI2\<1\>\/XI2\<0\>\/XI2\<0\>\/XI2\<0\>\/XI2\<1\>\/XI2\<1\>\/XI2\<1\>\/XI2\<0\>\/RR3 \
 (  \
 N_SEL3\<1\>_XI2\<1\>\/XI2\<0\>\/XI2\<0\>\/XI2\<0\>\/XI2\<1\>\/XI2\<1\>\/XI2\<1\>\/XI2\<0\>\/RR3_pos \
 N_WLSEL\<1139\>_XI2\<1\>\/XI2\<0\>\/XI2\<0\>\/XI2\<0\>\/XI2\<1\>\/XI2\<1\>\/XI2\<1\>\/XI2\<0\>\/RR3_neg \
 ) R_1X_LL w=1e-07 l=1e-07   res=0.149966
XXI2\<1\>\/XI2\<0\>\/XI2\<0\>\/XI2\<0\>\/XI2\<1\>\/XI2\<1\>\/XI2\<1\>\/XI2\<0\>\/RR4 \
 (  \
 N_SEL4\<0\>_XI2\<1\>\/XI2\<0\>\/XI2\<0\>\/XI2\<0\>\/XI2\<1\>\/XI2\<1\>\/XI2\<1\>\/XI2\<0\>\/RR4_pos \
 N_WLSEL\<1140\>_XI2\<1\>\/XI2\<0\>\/XI2\<0\>\/XI2\<0\>\/XI2\<1\>\/XI2\<1\>\/XI2\<1\>\/XI2\<0\>\/RR4_neg \
 ) R_1X_LL w=1e-07 l=1e-07   res=0.149966
XXI2\<1\>\/XI2\<0\>\/XI2\<0\>\/XI2\<0\>\/XI2\<1\>\/XI2\<1\>\/XI2\<1\>\/XI2\<0\>\/RR7 \
 (  \
 N_SEL5\<0\>_XI2\<1\>\/XI2\<0\>\/XI2\<0\>\/XI2\<0\>\/XI2\<1\>\/XI2\<1\>\/XI2\<1\>\/XI2\<0\>\/RR7_pos \
 N_WLSEL\<1141\>_XI2\<1\>\/XI2\<0\>\/XI2\<0\>\/XI2\<0\>\/XI2\<1\>\/XI2\<1\>\/XI2\<1\>\/XI2\<0\>\/RR7_neg \
 ) R_1X_LL w=1e-07 l=1e-07   res=0.149966
XXI2\<1\>\/XI2\<0\>\/XI2\<0\>\/XI2\<0\>\/XI2\<1\>\/XI2\<1\>\/XI2\<1\>\/XI2\<0\>\/RR6 \
 (  \
 N_SEL6\<0\>_XI2\<1\>\/XI2\<0\>\/XI2\<0\>\/XI2\<0\>\/XI2\<1\>\/XI2\<1\>\/XI2\<1\>\/XI2\<0\>\/RR6_pos \
 N_WLSEL\<1142\>_XI2\<1\>\/XI2\<0\>\/XI2\<0\>\/XI2\<0\>\/XI2\<1\>\/XI2\<1\>\/XI2\<1\>\/XI2\<0\>\/RR6_neg \
 ) R_1X_LL w=1e-07 l=1e-07   res=0.149966
XXI2\<1\>\/XI2\<0\>\/XI2\<0\>\/XI2\<0\>\/XI2\<1\>\/XI2\<1\>\/XI2\<1\>\/XI2\<0\>\/RR5 \
 (  \
 N_SEL7\<1\>_XI2\<1\>\/XI2\<0\>\/XI2\<0\>\/XI2\<0\>\/XI2\<1\>\/XI2\<1\>\/XI2\<1\>\/XI2\<0\>\/RR5_pos \
 N_WLSEL\<1143\>_XI2\<1\>\/XI2\<0\>\/XI2\<0\>\/XI2\<0\>\/XI2\<1\>\/XI2\<1\>\/XI2\<1\>\/XI2\<0\>\/RR5_neg \
 ) R_1X_LL w=1e-07 l=1e-07   res=0.149966
XXI2\<1\>\/XI2\<0\>\/XI2\<0\>\/XI2\<0\>\/XI2\<1\>\/XI2\<1\>\/XI2\<1\>\/XI2\<1\>\/RR0 \
 (  \
 N_SEL0\<1\>_XI2\<1\>\/XI2\<0\>\/XI2\<0\>\/XI2\<0\>\/XI2\<1\>\/XI2\<1\>\/XI2\<1\>\/XI2\<1\>\/RR0_pos \
 N_WLSEL\<1144\>_XI2\<1\>\/XI2\<0\>\/XI2\<0\>\/XI2\<0\>\/XI2\<1\>\/XI2\<1\>\/XI2\<1\>\/XI2\<1\>\/RR0_neg \
 ) R_1X_LL w=1e-07 l=1e-07   res=0.149966
XXI2\<1\>\/XI2\<0\>\/XI2\<0\>\/XI2\<0\>\/XI2\<1\>\/XI2\<1\>\/XI2\<1\>\/XI2\<1\>\/RR1 \
 (  \
 N_SEL1\<1\>_XI2\<1\>\/XI2\<0\>\/XI2\<0\>\/XI2\<0\>\/XI2\<1\>\/XI2\<1\>\/XI2\<1\>\/XI2\<1\>\/RR1_pos \
 N_WLSEL\<1145\>_XI2\<1\>\/XI2\<0\>\/XI2\<0\>\/XI2\<0\>\/XI2\<1\>\/XI2\<1\>\/XI2\<1\>\/XI2\<1\>\/RR1_neg \
 ) R_1X_LL w=1e-07 l=1e-07   res=0.149966
XXI2\<1\>\/XI2\<0\>\/XI2\<0\>\/XI2\<0\>\/XI2\<1\>\/XI2\<1\>\/XI2\<1\>\/XI2\<1\>\/RR2 \
 (  \
 N_SEL2\<1\>_XI2\<1\>\/XI2\<0\>\/XI2\<0\>\/XI2\<0\>\/XI2\<1\>\/XI2\<1\>\/XI2\<1\>\/XI2\<1\>\/RR2_pos \
 N_WLSEL\<1146\>_XI2\<1\>\/XI2\<0\>\/XI2\<0\>\/XI2\<0\>\/XI2\<1\>\/XI2\<1\>\/XI2\<1\>\/XI2\<1\>\/RR2_neg \
 ) R_1X_LL w=1e-07 l=1e-07   res=0.149966
XXI2\<1\>\/XI2\<0\>\/XI2\<0\>\/XI2\<0\>\/XI2\<1\>\/XI2\<1\>\/XI2\<1\>\/XI2\<1\>\/RR3 \
 (  \
 N_SEL3\<1\>_XI2\<1\>\/XI2\<0\>\/XI2\<0\>\/XI2\<0\>\/XI2\<1\>\/XI2\<1\>\/XI2\<1\>\/XI2\<1\>\/RR3_pos \
 N_WLSEL\<1147\>_XI2\<1\>\/XI2\<0\>\/XI2\<0\>\/XI2\<0\>\/XI2\<1\>\/XI2\<1\>\/XI2\<1\>\/XI2\<1\>\/RR3_neg \
 ) R_1X_LL w=1e-07 l=1e-07   res=0.149966
XXI2\<1\>\/XI2\<0\>\/XI2\<0\>\/XI2\<0\>\/XI2\<1\>\/XI2\<1\>\/XI2\<1\>\/XI2\<1\>\/RR4 \
 (  \
 N_SEL4\<0\>_XI2\<1\>\/XI2\<0\>\/XI2\<0\>\/XI2\<0\>\/XI2\<1\>\/XI2\<1\>\/XI2\<1\>\/XI2\<1\>\/RR4_pos \
 N_WLSEL\<1148\>_XI2\<1\>\/XI2\<0\>\/XI2\<0\>\/XI2\<0\>\/XI2\<1\>\/XI2\<1\>\/XI2\<1\>\/XI2\<1\>\/RR4_neg \
 ) R_1X_LL w=1e-07 l=1e-07   res=0.149966
XXI2\<1\>\/XI2\<0\>\/XI2\<0\>\/XI2\<0\>\/XI2\<1\>\/XI2\<1\>\/XI2\<1\>\/XI2\<1\>\/RR7 \
 (  \
 N_SEL5\<0\>_XI2\<1\>\/XI2\<0\>\/XI2\<0\>\/XI2\<0\>\/XI2\<1\>\/XI2\<1\>\/XI2\<1\>\/XI2\<1\>\/RR7_pos \
 N_WLSEL\<1149\>_XI2\<1\>\/XI2\<0\>\/XI2\<0\>\/XI2\<0\>\/XI2\<1\>\/XI2\<1\>\/XI2\<1\>\/XI2\<1\>\/RR7_neg \
 ) R_1X_LL w=1e-07 l=1e-07   res=0.149966
XXI2\<1\>\/XI2\<0\>\/XI2\<0\>\/XI2\<0\>\/XI2\<1\>\/XI2\<1\>\/XI2\<1\>\/XI2\<1\>\/RR6 \
 (  \
 N_SEL6\<0\>_XI2\<1\>\/XI2\<0\>\/XI2\<0\>\/XI2\<0\>\/XI2\<1\>\/XI2\<1\>\/XI2\<1\>\/XI2\<1\>\/RR6_pos \
 N_WLSEL\<1150\>_XI2\<1\>\/XI2\<0\>\/XI2\<0\>\/XI2\<0\>\/XI2\<1\>\/XI2\<1\>\/XI2\<1\>\/XI2\<1\>\/RR6_neg \
 ) R_1X_LL w=1e-07 l=1e-07   res=0.149966
XXI2\<1\>\/XI2\<0\>\/XI2\<0\>\/XI2\<0\>\/XI2\<1\>\/XI2\<1\>\/XI2\<1\>\/XI2\<1\>\/RR5 \
 (  \
 N_SEL7\<1\>_XI2\<1\>\/XI2\<0\>\/XI2\<0\>\/XI2\<0\>\/XI2\<1\>\/XI2\<1\>\/XI2\<1\>\/XI2\<1\>\/RR5_pos \
 N_WLSEL\<1151\>_XI2\<1\>\/XI2\<0\>\/XI2\<0\>\/XI2\<0\>\/XI2\<1\>\/XI2\<1\>\/XI2\<1\>\/XI2\<1\>\/RR5_neg \
 ) R_1X_LL w=1e-07 l=1e-07   res=0.149966
XXI2\<1\>\/XI2\<0\>\/XI2\<0\>\/XI2\<1\>\/XI2\<0\>\/XI2\<0\>\/XI2\<0\>\/XI2\<0\>\/RR0 \
 (  \
 N_SEL0\<0\>_XI2\<1\>\/XI2\<0\>\/XI2\<0\>\/XI2\<1\>\/XI2\<0\>\/XI2\<0\>\/XI2\<0\>\/XI2\<0\>\/RR0_pos \
 N_WLSEL\<1152\>_XI2\<1\>\/XI2\<0\>\/XI2\<0\>\/XI2\<1\>\/XI2\<0\>\/XI2\<0\>\/XI2\<0\>\/XI2\<0\>\/RR0_neg \
 ) R_1X_LL w=1e-07 l=1e-07   res=0.149966
XXI2\<1\>\/XI2\<0\>\/XI2\<0\>\/XI2\<1\>\/XI2\<0\>\/XI2\<0\>\/XI2\<0\>\/XI2\<0\>\/RR1 \
 (  \
 N_SEL1\<0\>_XI2\<1\>\/XI2\<0\>\/XI2\<0\>\/XI2\<1\>\/XI2\<0\>\/XI2\<0\>\/XI2\<0\>\/XI2\<0\>\/RR1_pos \
 N_WLSEL\<1153\>_XI2\<1\>\/XI2\<0\>\/XI2\<0\>\/XI2\<1\>\/XI2\<0\>\/XI2\<0\>\/XI2\<0\>\/XI2\<0\>\/RR1_neg \
 ) R_1X_LL w=1e-07 l=1e-07   res=0.149966
XXI2\<1\>\/XI2\<0\>\/XI2\<0\>\/XI2\<1\>\/XI2\<0\>\/XI2\<0\>\/XI2\<0\>\/XI2\<0\>\/RR2 \
 (  \
 N_SEL2\<0\>_XI2\<1\>\/XI2\<0\>\/XI2\<0\>\/XI2\<1\>\/XI2\<0\>\/XI2\<0\>\/XI2\<0\>\/XI2\<0\>\/RR2_pos \
 N_WLSEL\<1154\>_XI2\<1\>\/XI2\<0\>\/XI2\<0\>\/XI2\<1\>\/XI2\<0\>\/XI2\<0\>\/XI2\<0\>\/XI2\<0\>\/RR2_neg \
 ) R_1X_LL w=1e-07 l=1e-07   res=0.149966
XXI2\<1\>\/XI2\<0\>\/XI2\<0\>\/XI2\<1\>\/XI2\<0\>\/XI2\<0\>\/XI2\<0\>\/XI2\<0\>\/RR3 \
 (  \
 N_SEL3\<0\>_XI2\<1\>\/XI2\<0\>\/XI2\<0\>\/XI2\<1\>\/XI2\<0\>\/XI2\<0\>\/XI2\<0\>\/XI2\<0\>\/RR3_pos \
 N_WLSEL\<1155\>_XI2\<1\>\/XI2\<0\>\/XI2\<0\>\/XI2\<1\>\/XI2\<0\>\/XI2\<0\>\/XI2\<0\>\/XI2\<0\>\/RR3_neg \
 ) R_1X_LL w=1e-07 l=1e-07   res=0.149966
XXI2\<1\>\/XI2\<0\>\/XI2\<0\>\/XI2\<1\>\/XI2\<0\>\/XI2\<0\>\/XI2\<0\>\/XI2\<0\>\/RR4 \
 (  \
 N_SEL4\<1\>_XI2\<1\>\/XI2\<0\>\/XI2\<0\>\/XI2\<1\>\/XI2\<0\>\/XI2\<0\>\/XI2\<0\>\/XI2\<0\>\/RR4_pos \
 N_WLSEL\<1156\>_XI2\<1\>\/XI2\<0\>\/XI2\<0\>\/XI2\<1\>\/XI2\<0\>\/XI2\<0\>\/XI2\<0\>\/XI2\<0\>\/RR4_neg \
 ) R_1X_LL w=1e-07 l=1e-07   res=0.149966
XXI2\<1\>\/XI2\<0\>\/XI2\<0\>\/XI2\<1\>\/XI2\<0\>\/XI2\<0\>\/XI2\<0\>\/XI2\<0\>\/RR7 \
 (  \
 N_SEL5\<0\>_XI2\<1\>\/XI2\<0\>\/XI2\<0\>\/XI2\<1\>\/XI2\<0\>\/XI2\<0\>\/XI2\<0\>\/XI2\<0\>\/RR7_pos \
 N_WLSEL\<1157\>_XI2\<1\>\/XI2\<0\>\/XI2\<0\>\/XI2\<1\>\/XI2\<0\>\/XI2\<0\>\/XI2\<0\>\/XI2\<0\>\/RR7_neg \
 ) R_1X_LL w=1e-07 l=1e-07   res=0.149966
XXI2\<1\>\/XI2\<0\>\/XI2\<0\>\/XI2\<1\>\/XI2\<0\>\/XI2\<0\>\/XI2\<0\>\/XI2\<0\>\/RR6 \
 (  \
 N_SEL6\<0\>_XI2\<1\>\/XI2\<0\>\/XI2\<0\>\/XI2\<1\>\/XI2\<0\>\/XI2\<0\>\/XI2\<0\>\/XI2\<0\>\/RR6_pos \
 N_WLSEL\<1158\>_XI2\<1\>\/XI2\<0\>\/XI2\<0\>\/XI2\<1\>\/XI2\<0\>\/XI2\<0\>\/XI2\<0\>\/XI2\<0\>\/RR6_neg \
 ) R_1X_LL w=1e-07 l=1e-07   res=0.149966
XXI2\<1\>\/XI2\<0\>\/XI2\<0\>\/XI2\<1\>\/XI2\<0\>\/XI2\<0\>\/XI2\<0\>\/XI2\<0\>\/RR5 \
 (  \
 N_SEL7\<1\>_XI2\<1\>\/XI2\<0\>\/XI2\<0\>\/XI2\<1\>\/XI2\<0\>\/XI2\<0\>\/XI2\<0\>\/XI2\<0\>\/RR5_pos \
 N_WLSEL\<1159\>_XI2\<1\>\/XI2\<0\>\/XI2\<0\>\/XI2\<1\>\/XI2\<0\>\/XI2\<0\>\/XI2\<0\>\/XI2\<0\>\/RR5_neg \
 ) R_1X_LL w=1e-07 l=1e-07   res=0.149966
XXI2\<1\>\/XI2\<0\>\/XI2\<0\>\/XI2\<1\>\/XI2\<0\>\/XI2\<0\>\/XI2\<0\>\/XI2\<1\>\/RR0 \
 (  \
 N_SEL0\<1\>_XI2\<1\>\/XI2\<0\>\/XI2\<0\>\/XI2\<1\>\/XI2\<0\>\/XI2\<0\>\/XI2\<0\>\/XI2\<1\>\/RR0_pos \
 N_WLSEL\<1160\>_XI2\<1\>\/XI2\<0\>\/XI2\<0\>\/XI2\<1\>\/XI2\<0\>\/XI2\<0\>\/XI2\<0\>\/XI2\<1\>\/RR0_neg \
 ) R_1X_LL w=1e-07 l=1e-07   res=0.149966
XXI2\<1\>\/XI2\<0\>\/XI2\<0\>\/XI2\<1\>\/XI2\<0\>\/XI2\<0\>\/XI2\<0\>\/XI2\<1\>\/RR1 \
 (  \
 N_SEL1\<0\>_XI2\<1\>\/XI2\<0\>\/XI2\<0\>\/XI2\<1\>\/XI2\<0\>\/XI2\<0\>\/XI2\<0\>\/XI2\<1\>\/RR1_pos \
 N_WLSEL\<1161\>_XI2\<1\>\/XI2\<0\>\/XI2\<0\>\/XI2\<1\>\/XI2\<0\>\/XI2\<0\>\/XI2\<0\>\/XI2\<1\>\/RR1_neg \
 ) R_1X_LL w=1e-07 l=1e-07   res=0.149966
XXI2\<1\>\/XI2\<0\>\/XI2\<0\>\/XI2\<1\>\/XI2\<0\>\/XI2\<0\>\/XI2\<0\>\/XI2\<1\>\/RR2 \
 (  \
 N_SEL2\<0\>_XI2\<1\>\/XI2\<0\>\/XI2\<0\>\/XI2\<1\>\/XI2\<0\>\/XI2\<0\>\/XI2\<0\>\/XI2\<1\>\/RR2_pos \
 N_WLSEL\<1162\>_XI2\<1\>\/XI2\<0\>\/XI2\<0\>\/XI2\<1\>\/XI2\<0\>\/XI2\<0\>\/XI2\<0\>\/XI2\<1\>\/RR2_neg \
 ) R_1X_LL w=1e-07 l=1e-07   res=0.149966
XXI2\<1\>\/XI2\<0\>\/XI2\<0\>\/XI2\<1\>\/XI2\<0\>\/XI2\<0\>\/XI2\<0\>\/XI2\<1\>\/RR3 \
 (  \
 N_SEL3\<0\>_XI2\<1\>\/XI2\<0\>\/XI2\<0\>\/XI2\<1\>\/XI2\<0\>\/XI2\<0\>\/XI2\<0\>\/XI2\<1\>\/RR3_pos \
 N_WLSEL\<1163\>_XI2\<1\>\/XI2\<0\>\/XI2\<0\>\/XI2\<1\>\/XI2\<0\>\/XI2\<0\>\/XI2\<0\>\/XI2\<1\>\/RR3_neg \
 ) R_1X_LL w=1e-07 l=1e-07   res=0.149966
XXI2\<1\>\/XI2\<0\>\/XI2\<0\>\/XI2\<1\>\/XI2\<0\>\/XI2\<0\>\/XI2\<0\>\/XI2\<1\>\/RR4 \
 (  \
 N_SEL4\<1\>_XI2\<1\>\/XI2\<0\>\/XI2\<0\>\/XI2\<1\>\/XI2\<0\>\/XI2\<0\>\/XI2\<0\>\/XI2\<1\>\/RR4_pos \
 N_WLSEL\<1164\>_XI2\<1\>\/XI2\<0\>\/XI2\<0\>\/XI2\<1\>\/XI2\<0\>\/XI2\<0\>\/XI2\<0\>\/XI2\<1\>\/RR4_neg \
 ) R_1X_LL w=1e-07 l=1e-07   res=0.149966
XXI2\<1\>\/XI2\<0\>\/XI2\<0\>\/XI2\<1\>\/XI2\<0\>\/XI2\<0\>\/XI2\<0\>\/XI2\<1\>\/RR7 \
 (  \
 N_SEL5\<0\>_XI2\<1\>\/XI2\<0\>\/XI2\<0\>\/XI2\<1\>\/XI2\<0\>\/XI2\<0\>\/XI2\<0\>\/XI2\<1\>\/RR7_pos \
 N_WLSEL\<1165\>_XI2\<1\>\/XI2\<0\>\/XI2\<0\>\/XI2\<1\>\/XI2\<0\>\/XI2\<0\>\/XI2\<0\>\/XI2\<1\>\/RR7_neg \
 ) R_1X_LL w=1e-07 l=1e-07   res=0.149966
XXI2\<1\>\/XI2\<0\>\/XI2\<0\>\/XI2\<1\>\/XI2\<0\>\/XI2\<0\>\/XI2\<0\>\/XI2\<1\>\/RR6 \
 (  \
 N_SEL6\<0\>_XI2\<1\>\/XI2\<0\>\/XI2\<0\>\/XI2\<1\>\/XI2\<0\>\/XI2\<0\>\/XI2\<0\>\/XI2\<1\>\/RR6_pos \
 N_WLSEL\<1166\>_XI2\<1\>\/XI2\<0\>\/XI2\<0\>\/XI2\<1\>\/XI2\<0\>\/XI2\<0\>\/XI2\<0\>\/XI2\<1\>\/RR6_neg \
 ) R_1X_LL w=1e-07 l=1e-07   res=0.149966
XXI2\<1\>\/XI2\<0\>\/XI2\<0\>\/XI2\<1\>\/XI2\<0\>\/XI2\<0\>\/XI2\<0\>\/XI2\<1\>\/RR5 \
 (  \
 N_SEL7\<1\>_XI2\<1\>\/XI2\<0\>\/XI2\<0\>\/XI2\<1\>\/XI2\<0\>\/XI2\<0\>\/XI2\<0\>\/XI2\<1\>\/RR5_pos \
 N_WLSEL\<1167\>_XI2\<1\>\/XI2\<0\>\/XI2\<0\>\/XI2\<1\>\/XI2\<0\>\/XI2\<0\>\/XI2\<0\>\/XI2\<1\>\/RR5_neg \
 ) R_1X_LL w=1e-07 l=1e-07   res=0.149966
XXI2\<1\>\/XI2\<0\>\/XI2\<0\>\/XI2\<1\>\/XI2\<0\>\/XI2\<0\>\/XI2\<1\>\/XI2\<0\>\/RR0 \
 (  \
 N_SEL0\<0\>_XI2\<1\>\/XI2\<0\>\/XI2\<0\>\/XI2\<1\>\/XI2\<0\>\/XI2\<0\>\/XI2\<1\>\/XI2\<0\>\/RR0_pos \
 N_WLSEL\<1168\>_XI2\<1\>\/XI2\<0\>\/XI2\<0\>\/XI2\<1\>\/XI2\<0\>\/XI2\<0\>\/XI2\<1\>\/XI2\<0\>\/RR0_neg \
 ) R_1X_LL w=1e-07 l=1e-07   res=0.149966
XXI2\<1\>\/XI2\<0\>\/XI2\<0\>\/XI2\<1\>\/XI2\<0\>\/XI2\<0\>\/XI2\<1\>\/XI2\<0\>\/RR1 \
 (  \
 N_SEL1\<1\>_XI2\<1\>\/XI2\<0\>\/XI2\<0\>\/XI2\<1\>\/XI2\<0\>\/XI2\<0\>\/XI2\<1\>\/XI2\<0\>\/RR1_pos \
 N_WLSEL\<1169\>_XI2\<1\>\/XI2\<0\>\/XI2\<0\>\/XI2\<1\>\/XI2\<0\>\/XI2\<0\>\/XI2\<1\>\/XI2\<0\>\/RR1_neg \
 ) R_1X_LL w=1e-07 l=1e-07   res=0.149966
XXI2\<1\>\/XI2\<0\>\/XI2\<0\>\/XI2\<1\>\/XI2\<0\>\/XI2\<0\>\/XI2\<1\>\/XI2\<0\>\/RR2 \
 (  \
 N_SEL2\<0\>_XI2\<1\>\/XI2\<0\>\/XI2\<0\>\/XI2\<1\>\/XI2\<0\>\/XI2\<0\>\/XI2\<1\>\/XI2\<0\>\/RR2_pos \
 N_WLSEL\<1170\>_XI2\<1\>\/XI2\<0\>\/XI2\<0\>\/XI2\<1\>\/XI2\<0\>\/XI2\<0\>\/XI2\<1\>\/XI2\<0\>\/RR2_neg \
 ) R_1X_LL w=1e-07 l=1e-07   res=0.149966
XXI2\<1\>\/XI2\<0\>\/XI2\<0\>\/XI2\<1\>\/XI2\<0\>\/XI2\<0\>\/XI2\<1\>\/XI2\<0\>\/RR3 \
 (  \
 N_SEL3\<0\>_XI2\<1\>\/XI2\<0\>\/XI2\<0\>\/XI2\<1\>\/XI2\<0\>\/XI2\<0\>\/XI2\<1\>\/XI2\<0\>\/RR3_pos \
 N_WLSEL\<1171\>_XI2\<1\>\/XI2\<0\>\/XI2\<0\>\/XI2\<1\>\/XI2\<0\>\/XI2\<0\>\/XI2\<1\>\/XI2\<0\>\/RR3_neg \
 ) R_1X_LL w=1e-07 l=1e-07   res=0.149966
XXI2\<1\>\/XI2\<0\>\/XI2\<0\>\/XI2\<1\>\/XI2\<0\>\/XI2\<0\>\/XI2\<1\>\/XI2\<0\>\/RR4 \
 (  \
 N_SEL4\<1\>_XI2\<1\>\/XI2\<0\>\/XI2\<0\>\/XI2\<1\>\/XI2\<0\>\/XI2\<0\>\/XI2\<1\>\/XI2\<0\>\/RR4_pos \
 N_WLSEL\<1172\>_XI2\<1\>\/XI2\<0\>\/XI2\<0\>\/XI2\<1\>\/XI2\<0\>\/XI2\<0\>\/XI2\<1\>\/XI2\<0\>\/RR4_neg \
 ) R_1X_LL w=1e-07 l=1e-07   res=0.149966
XXI2\<1\>\/XI2\<0\>\/XI2\<0\>\/XI2\<1\>\/XI2\<0\>\/XI2\<0\>\/XI2\<1\>\/XI2\<0\>\/RR7 \
 (  \
 N_SEL5\<0\>_XI2\<1\>\/XI2\<0\>\/XI2\<0\>\/XI2\<1\>\/XI2\<0\>\/XI2\<0\>\/XI2\<1\>\/XI2\<0\>\/RR7_pos \
 N_WLSEL\<1173\>_XI2\<1\>\/XI2\<0\>\/XI2\<0\>\/XI2\<1\>\/XI2\<0\>\/XI2\<0\>\/XI2\<1\>\/XI2\<0\>\/RR7_neg \
 ) R_1X_LL w=1e-07 l=1e-07   res=0.149966
XXI2\<1\>\/XI2\<0\>\/XI2\<0\>\/XI2\<1\>\/XI2\<0\>\/XI2\<0\>\/XI2\<1\>\/XI2\<0\>\/RR6 \
 (  \
 N_SEL6\<0\>_XI2\<1\>\/XI2\<0\>\/XI2\<0\>\/XI2\<1\>\/XI2\<0\>\/XI2\<0\>\/XI2\<1\>\/XI2\<0\>\/RR6_pos \
 N_WLSEL\<1174\>_XI2\<1\>\/XI2\<0\>\/XI2\<0\>\/XI2\<1\>\/XI2\<0\>\/XI2\<0\>\/XI2\<1\>\/XI2\<0\>\/RR6_neg \
 ) R_1X_LL w=1e-07 l=1e-07   res=0.149966
XXI2\<1\>\/XI2\<0\>\/XI2\<0\>\/XI2\<1\>\/XI2\<0\>\/XI2\<0\>\/XI2\<1\>\/XI2\<0\>\/RR5 \
 (  \
 N_SEL7\<1\>_XI2\<1\>\/XI2\<0\>\/XI2\<0\>\/XI2\<1\>\/XI2\<0\>\/XI2\<0\>\/XI2\<1\>\/XI2\<0\>\/RR5_pos \
 N_WLSEL\<1175\>_XI2\<1\>\/XI2\<0\>\/XI2\<0\>\/XI2\<1\>\/XI2\<0\>\/XI2\<0\>\/XI2\<1\>\/XI2\<0\>\/RR5_neg \
 ) R_1X_LL w=1e-07 l=1e-07   res=0.149966
XXI2\<1\>\/XI2\<0\>\/XI2\<0\>\/XI2\<1\>\/XI2\<0\>\/XI2\<0\>\/XI2\<1\>\/XI2\<1\>\/RR0 \
 (  \
 N_SEL0\<1\>_XI2\<1\>\/XI2\<0\>\/XI2\<0\>\/XI2\<1\>\/XI2\<0\>\/XI2\<0\>\/XI2\<1\>\/XI2\<1\>\/RR0_pos \
 N_WLSEL\<1176\>_XI2\<1\>\/XI2\<0\>\/XI2\<0\>\/XI2\<1\>\/XI2\<0\>\/XI2\<0\>\/XI2\<1\>\/XI2\<1\>\/RR0_neg \
 ) R_1X_LL w=1e-07 l=1e-07   res=0.149966
XXI2\<1\>\/XI2\<0\>\/XI2\<0\>\/XI2\<1\>\/XI2\<0\>\/XI2\<0\>\/XI2\<1\>\/XI2\<1\>\/RR1 \
 (  \
 N_SEL1\<1\>_XI2\<1\>\/XI2\<0\>\/XI2\<0\>\/XI2\<1\>\/XI2\<0\>\/XI2\<0\>\/XI2\<1\>\/XI2\<1\>\/RR1_pos \
 N_WLSEL\<1177\>_XI2\<1\>\/XI2\<0\>\/XI2\<0\>\/XI2\<1\>\/XI2\<0\>\/XI2\<0\>\/XI2\<1\>\/XI2\<1\>\/RR1_neg \
 ) R_1X_LL w=1e-07 l=1e-07   res=0.149966
XXI2\<1\>\/XI2\<0\>\/XI2\<0\>\/XI2\<1\>\/XI2\<0\>\/XI2\<0\>\/XI2\<1\>\/XI2\<1\>\/RR2 \
 (  \
 N_SEL2\<0\>_XI2\<1\>\/XI2\<0\>\/XI2\<0\>\/XI2\<1\>\/XI2\<0\>\/XI2\<0\>\/XI2\<1\>\/XI2\<1\>\/RR2_pos \
 N_WLSEL\<1178\>_XI2\<1\>\/XI2\<0\>\/XI2\<0\>\/XI2\<1\>\/XI2\<0\>\/XI2\<0\>\/XI2\<1\>\/XI2\<1\>\/RR2_neg \
 ) R_1X_LL w=1e-07 l=1e-07   res=0.149966
XXI2\<1\>\/XI2\<0\>\/XI2\<0\>\/XI2\<1\>\/XI2\<0\>\/XI2\<0\>\/XI2\<1\>\/XI2\<1\>\/RR3 \
 (  \
 N_SEL3\<0\>_XI2\<1\>\/XI2\<0\>\/XI2\<0\>\/XI2\<1\>\/XI2\<0\>\/XI2\<0\>\/XI2\<1\>\/XI2\<1\>\/RR3_pos \
 N_WLSEL\<1179\>_XI2\<1\>\/XI2\<0\>\/XI2\<0\>\/XI2\<1\>\/XI2\<0\>\/XI2\<0\>\/XI2\<1\>\/XI2\<1\>\/RR3_neg \
 ) R_1X_LL w=1e-07 l=1e-07   res=0.149966
XXI2\<1\>\/XI2\<0\>\/XI2\<0\>\/XI2\<1\>\/XI2\<0\>\/XI2\<0\>\/XI2\<1\>\/XI2\<1\>\/RR4 \
 (  \
 N_SEL4\<1\>_XI2\<1\>\/XI2\<0\>\/XI2\<0\>\/XI2\<1\>\/XI2\<0\>\/XI2\<0\>\/XI2\<1\>\/XI2\<1\>\/RR4_pos \
 N_WLSEL\<1180\>_XI2\<1\>\/XI2\<0\>\/XI2\<0\>\/XI2\<1\>\/XI2\<0\>\/XI2\<0\>\/XI2\<1\>\/XI2\<1\>\/RR4_neg \
 ) R_1X_LL w=1e-07 l=1e-07   res=0.149966
XXI2\<1\>\/XI2\<0\>\/XI2\<0\>\/XI2\<1\>\/XI2\<0\>\/XI2\<0\>\/XI2\<1\>\/XI2\<1\>\/RR7 \
 (  \
 N_SEL5\<0\>_XI2\<1\>\/XI2\<0\>\/XI2\<0\>\/XI2\<1\>\/XI2\<0\>\/XI2\<0\>\/XI2\<1\>\/XI2\<1\>\/RR7_pos \
 N_WLSEL\<1181\>_XI2\<1\>\/XI2\<0\>\/XI2\<0\>\/XI2\<1\>\/XI2\<0\>\/XI2\<0\>\/XI2\<1\>\/XI2\<1\>\/RR7_neg \
 ) R_1X_LL w=1e-07 l=1e-07   res=0.149966
XXI2\<1\>\/XI2\<0\>\/XI2\<0\>\/XI2\<1\>\/XI2\<0\>\/XI2\<0\>\/XI2\<1\>\/XI2\<1\>\/RR6 \
 (  \
 N_SEL6\<0\>_XI2\<1\>\/XI2\<0\>\/XI2\<0\>\/XI2\<1\>\/XI2\<0\>\/XI2\<0\>\/XI2\<1\>\/XI2\<1\>\/RR6_pos \
 N_WLSEL\<1182\>_XI2\<1\>\/XI2\<0\>\/XI2\<0\>\/XI2\<1\>\/XI2\<0\>\/XI2\<0\>\/XI2\<1\>\/XI2\<1\>\/RR6_neg \
 ) R_1X_LL w=1e-07 l=1e-07   res=0.149966
XXI2\<1\>\/XI2\<0\>\/XI2\<0\>\/XI2\<1\>\/XI2\<0\>\/XI2\<0\>\/XI2\<1\>\/XI2\<1\>\/RR5 \
 (  \
 N_SEL7\<1\>_XI2\<1\>\/XI2\<0\>\/XI2\<0\>\/XI2\<1\>\/XI2\<0\>\/XI2\<0\>\/XI2\<1\>\/XI2\<1\>\/RR5_pos \
 N_WLSEL\<1183\>_XI2\<1\>\/XI2\<0\>\/XI2\<0\>\/XI2\<1\>\/XI2\<0\>\/XI2\<0\>\/XI2\<1\>\/XI2\<1\>\/RR5_neg \
 ) R_1X_LL w=1e-07 l=1e-07   res=0.149966
XXI2\<1\>\/XI2\<0\>\/XI2\<0\>\/XI2\<1\>\/XI2\<0\>\/XI2\<1\>\/XI2\<0\>\/XI2\<0\>\/RR0 \
 (  \
 N_SEL0\<0\>_XI2\<1\>\/XI2\<0\>\/XI2\<0\>\/XI2\<1\>\/XI2\<0\>\/XI2\<1\>\/XI2\<0\>\/XI2\<0\>\/RR0_pos \
 N_WLSEL\<1184\>_XI2\<1\>\/XI2\<0\>\/XI2\<0\>\/XI2\<1\>\/XI2\<0\>\/XI2\<1\>\/XI2\<0\>\/XI2\<0\>\/RR0_neg \
 ) R_1X_LL w=1e-07 l=1e-07   res=0.149966
XXI2\<1\>\/XI2\<0\>\/XI2\<0\>\/XI2\<1\>\/XI2\<0\>\/XI2\<1\>\/XI2\<0\>\/XI2\<0\>\/RR1 \
 (  \
 N_SEL1\<0\>_XI2\<1\>\/XI2\<0\>\/XI2\<0\>\/XI2\<1\>\/XI2\<0\>\/XI2\<1\>\/XI2\<0\>\/XI2\<0\>\/RR1_pos \
 N_WLSEL\<1185\>_XI2\<1\>\/XI2\<0\>\/XI2\<0\>\/XI2\<1\>\/XI2\<0\>\/XI2\<1\>\/XI2\<0\>\/XI2\<0\>\/RR1_neg \
 ) R_1X_LL w=1e-07 l=1e-07   res=0.149966
XXI2\<1\>\/XI2\<0\>\/XI2\<0\>\/XI2\<1\>\/XI2\<0\>\/XI2\<1\>\/XI2\<0\>\/XI2\<0\>\/RR2 \
 (  \
 N_SEL2\<1\>_XI2\<1\>\/XI2\<0\>\/XI2\<0\>\/XI2\<1\>\/XI2\<0\>\/XI2\<1\>\/XI2\<0\>\/XI2\<0\>\/RR2_pos \
 N_WLSEL\<1186\>_XI2\<1\>\/XI2\<0\>\/XI2\<0\>\/XI2\<1\>\/XI2\<0\>\/XI2\<1\>\/XI2\<0\>\/XI2\<0\>\/RR2_neg \
 ) R_1X_LL w=1e-07 l=1e-07   res=0.149966
XXI2\<1\>\/XI2\<0\>\/XI2\<0\>\/XI2\<1\>\/XI2\<0\>\/XI2\<1\>\/XI2\<0\>\/XI2\<0\>\/RR3 \
 (  \
 N_SEL3\<0\>_XI2\<1\>\/XI2\<0\>\/XI2\<0\>\/XI2\<1\>\/XI2\<0\>\/XI2\<1\>\/XI2\<0\>\/XI2\<0\>\/RR3_pos \
 N_WLSEL\<1187\>_XI2\<1\>\/XI2\<0\>\/XI2\<0\>\/XI2\<1\>\/XI2\<0\>\/XI2\<1\>\/XI2\<0\>\/XI2\<0\>\/RR3_neg \
 ) R_1X_LL w=1e-07 l=1e-07   res=0.149966
XXI2\<1\>\/XI2\<0\>\/XI2\<0\>\/XI2\<1\>\/XI2\<0\>\/XI2\<1\>\/XI2\<0\>\/XI2\<0\>\/RR4 \
 (  \
 N_SEL4\<1\>_XI2\<1\>\/XI2\<0\>\/XI2\<0\>\/XI2\<1\>\/XI2\<0\>\/XI2\<1\>\/XI2\<0\>\/XI2\<0\>\/RR4_pos \
 N_WLSEL\<1188\>_XI2\<1\>\/XI2\<0\>\/XI2\<0\>\/XI2\<1\>\/XI2\<0\>\/XI2\<1\>\/XI2\<0\>\/XI2\<0\>\/RR4_neg \
 ) R_1X_LL w=1e-07 l=1e-07   res=0.149966
XXI2\<1\>\/XI2\<0\>\/XI2\<0\>\/XI2\<1\>\/XI2\<0\>\/XI2\<1\>\/XI2\<0\>\/XI2\<0\>\/RR7 \
 (  \
 N_SEL5\<0\>_XI2\<1\>\/XI2\<0\>\/XI2\<0\>\/XI2\<1\>\/XI2\<0\>\/XI2\<1\>\/XI2\<0\>\/XI2\<0\>\/RR7_pos \
 N_WLSEL\<1189\>_XI2\<1\>\/XI2\<0\>\/XI2\<0\>\/XI2\<1\>\/XI2\<0\>\/XI2\<1\>\/XI2\<0\>\/XI2\<0\>\/RR7_neg \
 ) R_1X_LL w=1e-07 l=1e-07   res=0.149966
XXI2\<1\>\/XI2\<0\>\/XI2\<0\>\/XI2\<1\>\/XI2\<0\>\/XI2\<1\>\/XI2\<0\>\/XI2\<0\>\/RR6 \
 (  \
 N_SEL6\<0\>_XI2\<1\>\/XI2\<0\>\/XI2\<0\>\/XI2\<1\>\/XI2\<0\>\/XI2\<1\>\/XI2\<0\>\/XI2\<0\>\/RR6_pos \
 N_WLSEL\<1190\>_XI2\<1\>\/XI2\<0\>\/XI2\<0\>\/XI2\<1\>\/XI2\<0\>\/XI2\<1\>\/XI2\<0\>\/XI2\<0\>\/RR6_neg \
 ) R_1X_LL w=1e-07 l=1e-07   res=0.149966
XXI2\<1\>\/XI2\<0\>\/XI2\<0\>\/XI2\<1\>\/XI2\<0\>\/XI2\<1\>\/XI2\<0\>\/XI2\<0\>\/RR5 \
 (  \
 N_SEL7\<1\>_XI2\<1\>\/XI2\<0\>\/XI2\<0\>\/XI2\<1\>\/XI2\<0\>\/XI2\<1\>\/XI2\<0\>\/XI2\<0\>\/RR5_pos \
 N_WLSEL\<1191\>_XI2\<1\>\/XI2\<0\>\/XI2\<0\>\/XI2\<1\>\/XI2\<0\>\/XI2\<1\>\/XI2\<0\>\/XI2\<0\>\/RR5_neg \
 ) R_1X_LL w=1e-07 l=1e-07   res=0.149966
XXI2\<1\>\/XI2\<0\>\/XI2\<0\>\/XI2\<1\>\/XI2\<0\>\/XI2\<1\>\/XI2\<0\>\/XI2\<1\>\/RR0 \
 (  \
 N_SEL0\<1\>_XI2\<1\>\/XI2\<0\>\/XI2\<0\>\/XI2\<1\>\/XI2\<0\>\/XI2\<1\>\/XI2\<0\>\/XI2\<1\>\/RR0_pos \
 N_WLSEL\<1192\>_XI2\<1\>\/XI2\<0\>\/XI2\<0\>\/XI2\<1\>\/XI2\<0\>\/XI2\<1\>\/XI2\<0\>\/XI2\<1\>\/RR0_neg \
 ) R_1X_LL w=1e-07 l=1e-07   res=0.149966
XXI2\<1\>\/XI2\<0\>\/XI2\<0\>\/XI2\<1\>\/XI2\<0\>\/XI2\<1\>\/XI2\<0\>\/XI2\<1\>\/RR1 \
 (  \
 N_SEL1\<0\>_XI2\<1\>\/XI2\<0\>\/XI2\<0\>\/XI2\<1\>\/XI2\<0\>\/XI2\<1\>\/XI2\<0\>\/XI2\<1\>\/RR1_pos \
 N_WLSEL\<1193\>_XI2\<1\>\/XI2\<0\>\/XI2\<0\>\/XI2\<1\>\/XI2\<0\>\/XI2\<1\>\/XI2\<0\>\/XI2\<1\>\/RR1_neg \
 ) R_1X_LL w=1e-07 l=1e-07   res=0.149966
XXI2\<1\>\/XI2\<0\>\/XI2\<0\>\/XI2\<1\>\/XI2\<0\>\/XI2\<1\>\/XI2\<0\>\/XI2\<1\>\/RR2 \
 (  \
 N_SEL2\<1\>_XI2\<1\>\/XI2\<0\>\/XI2\<0\>\/XI2\<1\>\/XI2\<0\>\/XI2\<1\>\/XI2\<0\>\/XI2\<1\>\/RR2_pos \
 N_WLSEL\<1194\>_XI2\<1\>\/XI2\<0\>\/XI2\<0\>\/XI2\<1\>\/XI2\<0\>\/XI2\<1\>\/XI2\<0\>\/XI2\<1\>\/RR2_neg \
 ) R_1X_LL w=1e-07 l=1e-07   res=0.149966
XXI2\<1\>\/XI2\<0\>\/XI2\<0\>\/XI2\<1\>\/XI2\<0\>\/XI2\<1\>\/XI2\<0\>\/XI2\<1\>\/RR3 \
 (  \
 N_SEL3\<0\>_XI2\<1\>\/XI2\<0\>\/XI2\<0\>\/XI2\<1\>\/XI2\<0\>\/XI2\<1\>\/XI2\<0\>\/XI2\<1\>\/RR3_pos \
 N_WLSEL\<1195\>_XI2\<1\>\/XI2\<0\>\/XI2\<0\>\/XI2\<1\>\/XI2\<0\>\/XI2\<1\>\/XI2\<0\>\/XI2\<1\>\/RR3_neg \
 ) R_1X_LL w=1e-07 l=1e-07   res=0.149966
XXI2\<1\>\/XI2\<0\>\/XI2\<0\>\/XI2\<1\>\/XI2\<0\>\/XI2\<1\>\/XI2\<0\>\/XI2\<1\>\/RR4 \
 (  \
 N_SEL4\<1\>_XI2\<1\>\/XI2\<0\>\/XI2\<0\>\/XI2\<1\>\/XI2\<0\>\/XI2\<1\>\/XI2\<0\>\/XI2\<1\>\/RR4_pos \
 N_WLSEL\<1196\>_XI2\<1\>\/XI2\<0\>\/XI2\<0\>\/XI2\<1\>\/XI2\<0\>\/XI2\<1\>\/XI2\<0\>\/XI2\<1\>\/RR4_neg \
 ) R_1X_LL w=1e-07 l=1e-07   res=0.149966
XXI2\<1\>\/XI2\<0\>\/XI2\<0\>\/XI2\<1\>\/XI2\<0\>\/XI2\<1\>\/XI2\<0\>\/XI2\<1\>\/RR7 \
 (  \
 N_SEL5\<0\>_XI2\<1\>\/XI2\<0\>\/XI2\<0\>\/XI2\<1\>\/XI2\<0\>\/XI2\<1\>\/XI2\<0\>\/XI2\<1\>\/RR7_pos \
 N_WLSEL\<1197\>_XI2\<1\>\/XI2\<0\>\/XI2\<0\>\/XI2\<1\>\/XI2\<0\>\/XI2\<1\>\/XI2\<0\>\/XI2\<1\>\/RR7_neg \
 ) R_1X_LL w=1e-07 l=1e-07   res=0.149966
XXI2\<1\>\/XI2\<0\>\/XI2\<0\>\/XI2\<1\>\/XI2\<0\>\/XI2\<1\>\/XI2\<0\>\/XI2\<1\>\/RR6 \
 (  \
 N_SEL6\<0\>_XI2\<1\>\/XI2\<0\>\/XI2\<0\>\/XI2\<1\>\/XI2\<0\>\/XI2\<1\>\/XI2\<0\>\/XI2\<1\>\/RR6_pos \
 N_WLSEL\<1198\>_XI2\<1\>\/XI2\<0\>\/XI2\<0\>\/XI2\<1\>\/XI2\<0\>\/XI2\<1\>\/XI2\<0\>\/XI2\<1\>\/RR6_neg \
 ) R_1X_LL w=1e-07 l=1e-07   res=0.149966
XXI2\<1\>\/XI2\<0\>\/XI2\<0\>\/XI2\<1\>\/XI2\<0\>\/XI2\<1\>\/XI2\<0\>\/XI2\<1\>\/RR5 \
 (  \
 N_SEL7\<1\>_XI2\<1\>\/XI2\<0\>\/XI2\<0\>\/XI2\<1\>\/XI2\<0\>\/XI2\<1\>\/XI2\<0\>\/XI2\<1\>\/RR5_pos \
 N_WLSEL\<1199\>_XI2\<1\>\/XI2\<0\>\/XI2\<0\>\/XI2\<1\>\/XI2\<0\>\/XI2\<1\>\/XI2\<0\>\/XI2\<1\>\/RR5_neg \
 ) R_1X_LL w=1e-07 l=1e-07   res=0.149966
XXI2\<1\>\/XI2\<0\>\/XI2\<0\>\/XI2\<1\>\/XI2\<0\>\/XI2\<1\>\/XI2\<1\>\/XI2\<0\>\/RR0 \
 (  \
 N_SEL0\<0\>_XI2\<1\>\/XI2\<0\>\/XI2\<0\>\/XI2\<1\>\/XI2\<0\>\/XI2\<1\>\/XI2\<1\>\/XI2\<0\>\/RR0_pos \
 N_WLSEL\<1200\>_XI2\<1\>\/XI2\<0\>\/XI2\<0\>\/XI2\<1\>\/XI2\<0\>\/XI2\<1\>\/XI2\<1\>\/XI2\<0\>\/RR0_neg \
 ) R_1X_LL w=1e-07 l=1e-07   res=0.149966
XXI2\<1\>\/XI2\<0\>\/XI2\<0\>\/XI2\<1\>\/XI2\<0\>\/XI2\<1\>\/XI2\<1\>\/XI2\<0\>\/RR1 \
 (  \
 N_SEL1\<1\>_XI2\<1\>\/XI2\<0\>\/XI2\<0\>\/XI2\<1\>\/XI2\<0\>\/XI2\<1\>\/XI2\<1\>\/XI2\<0\>\/RR1_pos \
 N_WLSEL\<1201\>_XI2\<1\>\/XI2\<0\>\/XI2\<0\>\/XI2\<1\>\/XI2\<0\>\/XI2\<1\>\/XI2\<1\>\/XI2\<0\>\/RR1_neg \
 ) R_1X_LL w=1e-07 l=1e-07   res=0.149966
XXI2\<1\>\/XI2\<0\>\/XI2\<0\>\/XI2\<1\>\/XI2\<0\>\/XI2\<1\>\/XI2\<1\>\/XI2\<0\>\/RR2 \
 (  \
 N_SEL2\<1\>_XI2\<1\>\/XI2\<0\>\/XI2\<0\>\/XI2\<1\>\/XI2\<0\>\/XI2\<1\>\/XI2\<1\>\/XI2\<0\>\/RR2_pos \
 N_WLSEL\<1202\>_XI2\<1\>\/XI2\<0\>\/XI2\<0\>\/XI2\<1\>\/XI2\<0\>\/XI2\<1\>\/XI2\<1\>\/XI2\<0\>\/RR2_neg \
 ) R_1X_LL w=1e-07 l=1e-07   res=0.149966
XXI2\<1\>\/XI2\<0\>\/XI2\<0\>\/XI2\<1\>\/XI2\<0\>\/XI2\<1\>\/XI2\<1\>\/XI2\<0\>\/RR3 \
 (  \
 N_SEL3\<0\>_XI2\<1\>\/XI2\<0\>\/XI2\<0\>\/XI2\<1\>\/XI2\<0\>\/XI2\<1\>\/XI2\<1\>\/XI2\<0\>\/RR3_pos \
 N_WLSEL\<1203\>_XI2\<1\>\/XI2\<0\>\/XI2\<0\>\/XI2\<1\>\/XI2\<0\>\/XI2\<1\>\/XI2\<1\>\/XI2\<0\>\/RR3_neg \
 ) R_1X_LL w=1e-07 l=1e-07   res=0.149966
XXI2\<1\>\/XI2\<0\>\/XI2\<0\>\/XI2\<1\>\/XI2\<0\>\/XI2\<1\>\/XI2\<1\>\/XI2\<0\>\/RR4 \
 (  \
 N_SEL4\<1\>_XI2\<1\>\/XI2\<0\>\/XI2\<0\>\/XI2\<1\>\/XI2\<0\>\/XI2\<1\>\/XI2\<1\>\/XI2\<0\>\/RR4_pos \
 N_WLSEL\<1204\>_XI2\<1\>\/XI2\<0\>\/XI2\<0\>\/XI2\<1\>\/XI2\<0\>\/XI2\<1\>\/XI2\<1\>\/XI2\<0\>\/RR4_neg \
 ) R_1X_LL w=1e-07 l=1e-07   res=0.149966
XXI2\<1\>\/XI2\<0\>\/XI2\<0\>\/XI2\<1\>\/XI2\<0\>\/XI2\<1\>\/XI2\<1\>\/XI2\<0\>\/RR7 \
 (  \
 N_SEL5\<0\>_XI2\<1\>\/XI2\<0\>\/XI2\<0\>\/XI2\<1\>\/XI2\<0\>\/XI2\<1\>\/XI2\<1\>\/XI2\<0\>\/RR7_pos \
 N_WLSEL\<1205\>_XI2\<1\>\/XI2\<0\>\/XI2\<0\>\/XI2\<1\>\/XI2\<0\>\/XI2\<1\>\/XI2\<1\>\/XI2\<0\>\/RR7_neg \
 ) R_1X_LL w=1e-07 l=1e-07   res=0.149966
XXI2\<1\>\/XI2\<0\>\/XI2\<0\>\/XI2\<1\>\/XI2\<0\>\/XI2\<1\>\/XI2\<1\>\/XI2\<0\>\/RR6 \
 (  \
 N_SEL6\<0\>_XI2\<1\>\/XI2\<0\>\/XI2\<0\>\/XI2\<1\>\/XI2\<0\>\/XI2\<1\>\/XI2\<1\>\/XI2\<0\>\/RR6_pos \
 N_WLSEL\<1206\>_XI2\<1\>\/XI2\<0\>\/XI2\<0\>\/XI2\<1\>\/XI2\<0\>\/XI2\<1\>\/XI2\<1\>\/XI2\<0\>\/RR6_neg \
 ) R_1X_LL w=1e-07 l=1e-07   res=0.149966
XXI2\<1\>\/XI2\<0\>\/XI2\<0\>\/XI2\<1\>\/XI2\<0\>\/XI2\<1\>\/XI2\<1\>\/XI2\<0\>\/RR5 \
 (  \
 N_SEL7\<1\>_XI2\<1\>\/XI2\<0\>\/XI2\<0\>\/XI2\<1\>\/XI2\<0\>\/XI2\<1\>\/XI2\<1\>\/XI2\<0\>\/RR5_pos \
 N_WLSEL\<1207\>_XI2\<1\>\/XI2\<0\>\/XI2\<0\>\/XI2\<1\>\/XI2\<0\>\/XI2\<1\>\/XI2\<1\>\/XI2\<0\>\/RR5_neg \
 ) R_1X_LL w=1e-07 l=1e-07   res=0.149966
XXI2\<1\>\/XI2\<0\>\/XI2\<0\>\/XI2\<1\>\/XI2\<0\>\/XI2\<1\>\/XI2\<1\>\/XI2\<1\>\/RR0 \
 (  \
 N_SEL0\<1\>_XI2\<1\>\/XI2\<0\>\/XI2\<0\>\/XI2\<1\>\/XI2\<0\>\/XI2\<1\>\/XI2\<1\>\/XI2\<1\>\/RR0_pos \
 N_WLSEL\<1208\>_XI2\<1\>\/XI2\<0\>\/XI2\<0\>\/XI2\<1\>\/XI2\<0\>\/XI2\<1\>\/XI2\<1\>\/XI2\<1\>\/RR0_neg \
 ) R_1X_LL w=1e-07 l=1e-07   res=0.149966
XXI2\<1\>\/XI2\<0\>\/XI2\<0\>\/XI2\<1\>\/XI2\<0\>\/XI2\<1\>\/XI2\<1\>\/XI2\<1\>\/RR1 \
 (  \
 N_SEL1\<1\>_XI2\<1\>\/XI2\<0\>\/XI2\<0\>\/XI2\<1\>\/XI2\<0\>\/XI2\<1\>\/XI2\<1\>\/XI2\<1\>\/RR1_pos \
 N_WLSEL\<1209\>_XI2\<1\>\/XI2\<0\>\/XI2\<0\>\/XI2\<1\>\/XI2\<0\>\/XI2\<1\>\/XI2\<1\>\/XI2\<1\>\/RR1_neg \
 ) R_1X_LL w=1e-07 l=1e-07   res=0.149966
XXI2\<1\>\/XI2\<0\>\/XI2\<0\>\/XI2\<1\>\/XI2\<0\>\/XI2\<1\>\/XI2\<1\>\/XI2\<1\>\/RR2 \
 (  \
 N_SEL2\<1\>_XI2\<1\>\/XI2\<0\>\/XI2\<0\>\/XI2\<1\>\/XI2\<0\>\/XI2\<1\>\/XI2\<1\>\/XI2\<1\>\/RR2_pos \
 N_WLSEL\<1210\>_XI2\<1\>\/XI2\<0\>\/XI2\<0\>\/XI2\<1\>\/XI2\<0\>\/XI2\<1\>\/XI2\<1\>\/XI2\<1\>\/RR2_neg \
 ) R_1X_LL w=1e-07 l=1e-07   res=0.149966
XXI2\<1\>\/XI2\<0\>\/XI2\<0\>\/XI2\<1\>\/XI2\<0\>\/XI2\<1\>\/XI2\<1\>\/XI2\<1\>\/RR3 \
 (  \
 N_SEL3\<0\>_XI2\<1\>\/XI2\<0\>\/XI2\<0\>\/XI2\<1\>\/XI2\<0\>\/XI2\<1\>\/XI2\<1\>\/XI2\<1\>\/RR3_pos \
 N_WLSEL\<1211\>_XI2\<1\>\/XI2\<0\>\/XI2\<0\>\/XI2\<1\>\/XI2\<0\>\/XI2\<1\>\/XI2\<1\>\/XI2\<1\>\/RR3_neg \
 ) R_1X_LL w=1e-07 l=1e-07   res=0.149966
XXI2\<1\>\/XI2\<0\>\/XI2\<0\>\/XI2\<1\>\/XI2\<0\>\/XI2\<1\>\/XI2\<1\>\/XI2\<1\>\/RR4 \
 (  \
 N_SEL4\<1\>_XI2\<1\>\/XI2\<0\>\/XI2\<0\>\/XI2\<1\>\/XI2\<0\>\/XI2\<1\>\/XI2\<1\>\/XI2\<1\>\/RR4_pos \
 N_WLSEL\<1212\>_XI2\<1\>\/XI2\<0\>\/XI2\<0\>\/XI2\<1\>\/XI2\<0\>\/XI2\<1\>\/XI2\<1\>\/XI2\<1\>\/RR4_neg \
 ) R_1X_LL w=1e-07 l=1e-07   res=0.149966
XXI2\<1\>\/XI2\<0\>\/XI2\<0\>\/XI2\<1\>\/XI2\<0\>\/XI2\<1\>\/XI2\<1\>\/XI2\<1\>\/RR7 \
 (  \
 N_SEL5\<0\>_XI2\<1\>\/XI2\<0\>\/XI2\<0\>\/XI2\<1\>\/XI2\<0\>\/XI2\<1\>\/XI2\<1\>\/XI2\<1\>\/RR7_pos \
 N_WLSEL\<1213\>_XI2\<1\>\/XI2\<0\>\/XI2\<0\>\/XI2\<1\>\/XI2\<0\>\/XI2\<1\>\/XI2\<1\>\/XI2\<1\>\/RR7_neg \
 ) R_1X_LL w=1e-07 l=1e-07   res=0.149966
XXI2\<0\>\/XI2\<1\>\/XI2\<0\>\/XI2\<0\>\/XI2\<1\>\/XI2\<1\>\/XI2\<0\>\/XI2\<1\>\/RR6 \
 (  \
 N_SEL6\<1\>_XI2\<0\>\/XI2\<1\>\/XI2\<0\>\/XI2\<0\>\/XI2\<1\>\/XI2\<1\>\/XI2\<0\>\/XI2\<1\>\/RR6_pos \
 N_WLSEL\<622\>_XI2\<0\>\/XI2\<1\>\/XI2\<0\>\/XI2\<0\>\/XI2\<1\>\/XI2\<1\>\/XI2\<0\>\/XI2\<1\>\/RR6_neg \
 ) R_1X_LL w=1e-07 l=1e-07   res=0.149966
XXI2\<0\>\/XI2\<1\>\/XI2\<0\>\/XI2\<0\>\/XI2\<1\>\/XI2\<1\>\/XI2\<0\>\/XI2\<1\>\/RR5 \
 (  \
 N_SEL7\<0\>_XI2\<0\>\/XI2\<1\>\/XI2\<0\>\/XI2\<0\>\/XI2\<1\>\/XI2\<1\>\/XI2\<0\>\/XI2\<1\>\/RR5_pos \
 N_WLSEL\<623\>_XI2\<0\>\/XI2\<1\>\/XI2\<0\>\/XI2\<0\>\/XI2\<1\>\/XI2\<1\>\/XI2\<0\>\/XI2\<1\>\/RR5_neg \
 ) R_1X_LL w=1e-07 l=1e-07   res=0.149966
XXI2\<0\>\/XI2\<1\>\/XI2\<0\>\/XI2\<0\>\/XI2\<1\>\/XI2\<1\>\/XI2\<1\>\/XI2\<0\>\/RR0 \
 (  \
 N_SEL0\<0\>_XI2\<0\>\/XI2\<1\>\/XI2\<0\>\/XI2\<0\>\/XI2\<1\>\/XI2\<1\>\/XI2\<1\>\/XI2\<0\>\/RR0_pos \
 N_WLSEL\<624\>_XI2\<0\>\/XI2\<1\>\/XI2\<0\>\/XI2\<0\>\/XI2\<1\>\/XI2\<1\>\/XI2\<1\>\/XI2\<0\>\/RR0_neg \
 ) R_1X_LL w=1e-07 l=1e-07   res=0.149966
XXI2\<0\>\/XI2\<1\>\/XI2\<0\>\/XI2\<0\>\/XI2\<1\>\/XI2\<1\>\/XI2\<1\>\/XI2\<0\>\/RR1 \
 (  \
 N_SEL1\<1\>_XI2\<0\>\/XI2\<1\>\/XI2\<0\>\/XI2\<0\>\/XI2\<1\>\/XI2\<1\>\/XI2\<1\>\/XI2\<0\>\/RR1_pos \
 N_WLSEL\<625\>_XI2\<0\>\/XI2\<1\>\/XI2\<0\>\/XI2\<0\>\/XI2\<1\>\/XI2\<1\>\/XI2\<1\>\/XI2\<0\>\/RR1_neg \
 ) R_1X_LL w=1e-07 l=1e-07   res=0.149966
XXI2\<0\>\/XI2\<1\>\/XI2\<0\>\/XI2\<0\>\/XI2\<1\>\/XI2\<1\>\/XI2\<1\>\/XI2\<0\>\/RR2 \
 (  \
 N_SEL2\<1\>_XI2\<0\>\/XI2\<1\>\/XI2\<0\>\/XI2\<0\>\/XI2\<1\>\/XI2\<1\>\/XI2\<1\>\/XI2\<0\>\/RR2_pos \
 N_WLSEL\<626\>_XI2\<0\>\/XI2\<1\>\/XI2\<0\>\/XI2\<0\>\/XI2\<1\>\/XI2\<1\>\/XI2\<1\>\/XI2\<0\>\/RR2_neg \
 ) R_1X_LL w=1e-07 l=1e-07   res=0.149966
XXI2\<0\>\/XI2\<1\>\/XI2\<0\>\/XI2\<0\>\/XI2\<1\>\/XI2\<1\>\/XI2\<1\>\/XI2\<0\>\/RR3 \
 (  \
 N_SEL3\<1\>_XI2\<0\>\/XI2\<1\>\/XI2\<0\>\/XI2\<0\>\/XI2\<1\>\/XI2\<1\>\/XI2\<1\>\/XI2\<0\>\/RR3_pos \
 N_WLSEL\<627\>_XI2\<0\>\/XI2\<1\>\/XI2\<0\>\/XI2\<0\>\/XI2\<1\>\/XI2\<1\>\/XI2\<1\>\/XI2\<0\>\/RR3_neg \
 ) R_1X_LL w=1e-07 l=1e-07   res=0.149966
XXI2\<0\>\/XI2\<1\>\/XI2\<0\>\/XI2\<0\>\/XI2\<1\>\/XI2\<1\>\/XI2\<1\>\/XI2\<0\>\/RR4 \
 (  \
 N_SEL4\<0\>_XI2\<0\>\/XI2\<1\>\/XI2\<0\>\/XI2\<0\>\/XI2\<1\>\/XI2\<1\>\/XI2\<1\>\/XI2\<0\>\/RR4_pos \
 N_WLSEL\<628\>_XI2\<0\>\/XI2\<1\>\/XI2\<0\>\/XI2\<0\>\/XI2\<1\>\/XI2\<1\>\/XI2\<1\>\/XI2\<0\>\/RR4_neg \
 ) R_1X_LL w=1e-07 l=1e-07   res=0.149966
XXI2\<0\>\/XI2\<1\>\/XI2\<0\>\/XI2\<0\>\/XI2\<1\>\/XI2\<1\>\/XI2\<1\>\/XI2\<0\>\/RR7 \
 (  \
 N_SEL5\<0\>_XI2\<0\>\/XI2\<1\>\/XI2\<0\>\/XI2\<0\>\/XI2\<1\>\/XI2\<1\>\/XI2\<1\>\/XI2\<0\>\/RR7_pos \
 N_WLSEL\<629\>_XI2\<0\>\/XI2\<1\>\/XI2\<0\>\/XI2\<0\>\/XI2\<1\>\/XI2\<1\>\/XI2\<1\>\/XI2\<0\>\/RR7_neg \
 ) R_1X_LL w=1e-07 l=1e-07   res=0.149966
XXI2\<0\>\/XI2\<1\>\/XI2\<0\>\/XI2\<0\>\/XI2\<1\>\/XI2\<1\>\/XI2\<1\>\/XI2\<0\>\/RR6 \
 (  \
 N_SEL6\<1\>_XI2\<0\>\/XI2\<1\>\/XI2\<0\>\/XI2\<0\>\/XI2\<1\>\/XI2\<1\>\/XI2\<1\>\/XI2\<0\>\/RR6_pos \
 N_WLSEL\<630\>_XI2\<0\>\/XI2\<1\>\/XI2\<0\>\/XI2\<0\>\/XI2\<1\>\/XI2\<1\>\/XI2\<1\>\/XI2\<0\>\/RR6_neg \
 ) R_1X_LL w=1e-07 l=1e-07   res=0.149966
XXI2\<0\>\/XI2\<1\>\/XI2\<0\>\/XI2\<0\>\/XI2\<1\>\/XI2\<1\>\/XI2\<1\>\/XI2\<0\>\/RR5 \
 (  \
 N_SEL7\<0\>_XI2\<0\>\/XI2\<1\>\/XI2\<0\>\/XI2\<0\>\/XI2\<1\>\/XI2\<1\>\/XI2\<1\>\/XI2\<0\>\/RR5_pos \
 N_WLSEL\<631\>_XI2\<0\>\/XI2\<1\>\/XI2\<0\>\/XI2\<0\>\/XI2\<1\>\/XI2\<1\>\/XI2\<1\>\/XI2\<0\>\/RR5_neg \
 ) R_1X_LL w=1e-07 l=1e-07   res=0.149966
XXI2\<0\>\/XI2\<1\>\/XI2\<0\>\/XI2\<0\>\/XI2\<1\>\/XI2\<1\>\/XI2\<1\>\/XI2\<1\>\/RR0 \
 (  \
 N_SEL0\<1\>_XI2\<0\>\/XI2\<1\>\/XI2\<0\>\/XI2\<0\>\/XI2\<1\>\/XI2\<1\>\/XI2\<1\>\/XI2\<1\>\/RR0_pos \
 N_WLSEL\<632\>_XI2\<0\>\/XI2\<1\>\/XI2\<0\>\/XI2\<0\>\/XI2\<1\>\/XI2\<1\>\/XI2\<1\>\/XI2\<1\>\/RR0_neg \
 ) R_1X_LL w=1e-07 l=1e-07   res=0.149966
XXI2\<0\>\/XI2\<1\>\/XI2\<0\>\/XI2\<0\>\/XI2\<1\>\/XI2\<1\>\/XI2\<1\>\/XI2\<1\>\/RR1 \
 (  \
 N_SEL1\<1\>_XI2\<0\>\/XI2\<1\>\/XI2\<0\>\/XI2\<0\>\/XI2\<1\>\/XI2\<1\>\/XI2\<1\>\/XI2\<1\>\/RR1_pos \
 N_WLSEL\<633\>_XI2\<0\>\/XI2\<1\>\/XI2\<0\>\/XI2\<0\>\/XI2\<1\>\/XI2\<1\>\/XI2\<1\>\/XI2\<1\>\/RR1_neg \
 ) R_1X_LL w=1e-07 l=1e-07   res=0.149966
XXI2\<0\>\/XI2\<1\>\/XI2\<0\>\/XI2\<0\>\/XI2\<1\>\/XI2\<1\>\/XI2\<1\>\/XI2\<1\>\/RR2 \
 (  \
 N_SEL2\<1\>_XI2\<0\>\/XI2\<1\>\/XI2\<0\>\/XI2\<0\>\/XI2\<1\>\/XI2\<1\>\/XI2\<1\>\/XI2\<1\>\/RR2_pos \
 N_WLSEL\<634\>_XI2\<0\>\/XI2\<1\>\/XI2\<0\>\/XI2\<0\>\/XI2\<1\>\/XI2\<1\>\/XI2\<1\>\/XI2\<1\>\/RR2_neg \
 ) R_1X_LL w=1e-07 l=1e-07   res=0.149966
XXI2\<0\>\/XI2\<1\>\/XI2\<0\>\/XI2\<0\>\/XI2\<1\>\/XI2\<1\>\/XI2\<1\>\/XI2\<1\>\/RR3 \
 (  \
 N_SEL3\<1\>_XI2\<0\>\/XI2\<1\>\/XI2\<0\>\/XI2\<0\>\/XI2\<1\>\/XI2\<1\>\/XI2\<1\>\/XI2\<1\>\/RR3_pos \
 N_WLSEL\<635\>_XI2\<0\>\/XI2\<1\>\/XI2\<0\>\/XI2\<0\>\/XI2\<1\>\/XI2\<1\>\/XI2\<1\>\/XI2\<1\>\/RR3_neg \
 ) R_1X_LL w=1e-07 l=1e-07   res=0.149966
XXI2\<0\>\/XI2\<1\>\/XI2\<0\>\/XI2\<0\>\/XI2\<1\>\/XI2\<1\>\/XI2\<1\>\/XI2\<1\>\/RR4 \
 (  \
 N_SEL4\<0\>_XI2\<0\>\/XI2\<1\>\/XI2\<0\>\/XI2\<0\>\/XI2\<1\>\/XI2\<1\>\/XI2\<1\>\/XI2\<1\>\/RR4_pos \
 N_WLSEL\<636\>_XI2\<0\>\/XI2\<1\>\/XI2\<0\>\/XI2\<0\>\/XI2\<1\>\/XI2\<1\>\/XI2\<1\>\/XI2\<1\>\/RR4_neg \
 ) R_1X_LL w=1e-07 l=1e-07   res=0.149966
XXI2\<0\>\/XI2\<1\>\/XI2\<0\>\/XI2\<0\>\/XI2\<1\>\/XI2\<1\>\/XI2\<1\>\/XI2\<1\>\/RR7 \
 (  \
 N_SEL5\<0\>_XI2\<0\>\/XI2\<1\>\/XI2\<0\>\/XI2\<0\>\/XI2\<1\>\/XI2\<1\>\/XI2\<1\>\/XI2\<1\>\/RR7_pos \
 N_WLSEL\<637\>_XI2\<0\>\/XI2\<1\>\/XI2\<0\>\/XI2\<0\>\/XI2\<1\>\/XI2\<1\>\/XI2\<1\>\/XI2\<1\>\/RR7_neg \
 ) R_1X_LL w=1e-07 l=1e-07   res=0.149966
XXI2\<0\>\/XI2\<1\>\/XI2\<0\>\/XI2\<0\>\/XI2\<1\>\/XI2\<1\>\/XI2\<1\>\/XI2\<1\>\/RR6 \
 (  \
 N_SEL6\<1\>_XI2\<0\>\/XI2\<1\>\/XI2\<0\>\/XI2\<0\>\/XI2\<1\>\/XI2\<1\>\/XI2\<1\>\/XI2\<1\>\/RR6_pos \
 N_WLSEL\<638\>_XI2\<0\>\/XI2\<1\>\/XI2\<0\>\/XI2\<0\>\/XI2\<1\>\/XI2\<1\>\/XI2\<1\>\/XI2\<1\>\/RR6_neg \
 ) R_1X_LL w=1e-07 l=1e-07   res=0.149966
XXI2\<0\>\/XI2\<1\>\/XI2\<0\>\/XI2\<0\>\/XI2\<1\>\/XI2\<1\>\/XI2\<1\>\/XI2\<1\>\/RR5 \
 (  \
 N_SEL7\<0\>_XI2\<0\>\/XI2\<1\>\/XI2\<0\>\/XI2\<0\>\/XI2\<1\>\/XI2\<1\>\/XI2\<1\>\/XI2\<1\>\/RR5_pos \
 N_WLSEL\<639\>_XI2\<0\>\/XI2\<1\>\/XI2\<0\>\/XI2\<0\>\/XI2\<1\>\/XI2\<1\>\/XI2\<1\>\/XI2\<1\>\/RR5_neg \
 ) R_1X_LL w=1e-07 l=1e-07   res=0.149966
XXI2\<0\>\/XI2\<1\>\/XI2\<0\>\/XI2\<1\>\/XI2\<0\>\/XI2\<0\>\/XI2\<0\>\/XI2\<0\>\/RR0 \
 (  \
 N_SEL0\<0\>_XI2\<0\>\/XI2\<1\>\/XI2\<0\>\/XI2\<1\>\/XI2\<0\>\/XI2\<0\>\/XI2\<0\>\/XI2\<0\>\/RR0_pos \
 N_WLSEL\<640\>_XI2\<0\>\/XI2\<1\>\/XI2\<0\>\/XI2\<1\>\/XI2\<0\>\/XI2\<0\>\/XI2\<0\>\/XI2\<0\>\/RR0_neg \
 ) R_1X_LL w=1e-07 l=1e-07   res=0.149966
XXI2\<0\>\/XI2\<1\>\/XI2\<0\>\/XI2\<1\>\/XI2\<0\>\/XI2\<0\>\/XI2\<0\>\/XI2\<0\>\/RR1 \
 (  \
 N_SEL1\<0\>_XI2\<0\>\/XI2\<1\>\/XI2\<0\>\/XI2\<1\>\/XI2\<0\>\/XI2\<0\>\/XI2\<0\>\/XI2\<0\>\/RR1_pos \
 N_WLSEL\<641\>_XI2\<0\>\/XI2\<1\>\/XI2\<0\>\/XI2\<1\>\/XI2\<0\>\/XI2\<0\>\/XI2\<0\>\/XI2\<0\>\/RR1_neg \
 ) R_1X_LL w=1e-07 l=1e-07   res=0.149966
XXI2\<0\>\/XI2\<1\>\/XI2\<0\>\/XI2\<1\>\/XI2\<0\>\/XI2\<0\>\/XI2\<0\>\/XI2\<0\>\/RR2 \
 (  \
 N_SEL2\<0\>_XI2\<0\>\/XI2\<1\>\/XI2\<0\>\/XI2\<1\>\/XI2\<0\>\/XI2\<0\>\/XI2\<0\>\/XI2\<0\>\/RR2_pos \
 N_WLSEL\<642\>_XI2\<0\>\/XI2\<1\>\/XI2\<0\>\/XI2\<1\>\/XI2\<0\>\/XI2\<0\>\/XI2\<0\>\/XI2\<0\>\/RR2_neg \
 ) R_1X_LL w=1e-07 l=1e-07   res=0.149966
XXI2\<0\>\/XI2\<1\>\/XI2\<0\>\/XI2\<1\>\/XI2\<0\>\/XI2\<0\>\/XI2\<0\>\/XI2\<0\>\/RR3 \
 (  \
 N_SEL3\<0\>_XI2\<0\>\/XI2\<1\>\/XI2\<0\>\/XI2\<1\>\/XI2\<0\>\/XI2\<0\>\/XI2\<0\>\/XI2\<0\>\/RR3_pos \
 N_WLSEL\<643\>_XI2\<0\>\/XI2\<1\>\/XI2\<0\>\/XI2\<1\>\/XI2\<0\>\/XI2\<0\>\/XI2\<0\>\/XI2\<0\>\/RR3_neg \
 ) R_1X_LL w=1e-07 l=1e-07   res=0.149966
XXI2\<0\>\/XI2\<1\>\/XI2\<0\>\/XI2\<1\>\/XI2\<0\>\/XI2\<0\>\/XI2\<0\>\/XI2\<0\>\/RR4 \
 (  \
 N_SEL4\<1\>_XI2\<0\>\/XI2\<1\>\/XI2\<0\>\/XI2\<1\>\/XI2\<0\>\/XI2\<0\>\/XI2\<0\>\/XI2\<0\>\/RR4_pos \
 N_WLSEL\<644\>_XI2\<0\>\/XI2\<1\>\/XI2\<0\>\/XI2\<1\>\/XI2\<0\>\/XI2\<0\>\/XI2\<0\>\/XI2\<0\>\/RR4_neg \
 ) R_1X_LL w=1e-07 l=1e-07   res=0.149966
XXI2\<0\>\/XI2\<1\>\/XI2\<0\>\/XI2\<1\>\/XI2\<0\>\/XI2\<0\>\/XI2\<0\>\/XI2\<0\>\/RR7 \
 (  \
 N_SEL5\<0\>_XI2\<0\>\/XI2\<1\>\/XI2\<0\>\/XI2\<1\>\/XI2\<0\>\/XI2\<0\>\/XI2\<0\>\/XI2\<0\>\/RR7_pos \
 N_WLSEL\<645\>_XI2\<0\>\/XI2\<1\>\/XI2\<0\>\/XI2\<1\>\/XI2\<0\>\/XI2\<0\>\/XI2\<0\>\/XI2\<0\>\/RR7_neg \
 ) R_1X_LL w=1e-07 l=1e-07   res=0.149966
XXI2\<0\>\/XI2\<1\>\/XI2\<0\>\/XI2\<1\>\/XI2\<0\>\/XI2\<0\>\/XI2\<0\>\/XI2\<0\>\/RR6 \
 (  \
 N_SEL6\<1\>_XI2\<0\>\/XI2\<1\>\/XI2\<0\>\/XI2\<1\>\/XI2\<0\>\/XI2\<0\>\/XI2\<0\>\/XI2\<0\>\/RR6_pos \
 N_WLSEL\<646\>_XI2\<0\>\/XI2\<1\>\/XI2\<0\>\/XI2\<1\>\/XI2\<0\>\/XI2\<0\>\/XI2\<0\>\/XI2\<0\>\/RR6_neg \
 ) R_1X_LL w=1e-07 l=1e-07   res=0.149966
XXI2\<0\>\/XI2\<1\>\/XI2\<0\>\/XI2\<1\>\/XI2\<0\>\/XI2\<0\>\/XI2\<0\>\/XI2\<0\>\/RR5 \
 (  \
 N_SEL7\<0\>_XI2\<0\>\/XI2\<1\>\/XI2\<0\>\/XI2\<1\>\/XI2\<0\>\/XI2\<0\>\/XI2\<0\>\/XI2\<0\>\/RR5_pos \
 N_WLSEL\<647\>_XI2\<0\>\/XI2\<1\>\/XI2\<0\>\/XI2\<1\>\/XI2\<0\>\/XI2\<0\>\/XI2\<0\>\/XI2\<0\>\/RR5_neg \
 ) R_1X_LL w=1e-07 l=1e-07   res=0.149966
XXI2\<0\>\/XI2\<1\>\/XI2\<0\>\/XI2\<1\>\/XI2\<0\>\/XI2\<0\>\/XI2\<0\>\/XI2\<1\>\/RR0 \
 (  \
 N_SEL0\<1\>_XI2\<0\>\/XI2\<1\>\/XI2\<0\>\/XI2\<1\>\/XI2\<0\>\/XI2\<0\>\/XI2\<0\>\/XI2\<1\>\/RR0_pos \
 N_WLSEL\<648\>_XI2\<0\>\/XI2\<1\>\/XI2\<0\>\/XI2\<1\>\/XI2\<0\>\/XI2\<0\>\/XI2\<0\>\/XI2\<1\>\/RR0_neg \
 ) R_1X_LL w=1e-07 l=1e-07   res=0.149966
XXI2\<0\>\/XI2\<1\>\/XI2\<0\>\/XI2\<1\>\/XI2\<0\>\/XI2\<0\>\/XI2\<0\>\/XI2\<1\>\/RR1 \
 (  \
 N_SEL1\<0\>_XI2\<0\>\/XI2\<1\>\/XI2\<0\>\/XI2\<1\>\/XI2\<0\>\/XI2\<0\>\/XI2\<0\>\/XI2\<1\>\/RR1_pos \
 N_WLSEL\<649\>_XI2\<0\>\/XI2\<1\>\/XI2\<0\>\/XI2\<1\>\/XI2\<0\>\/XI2\<0\>\/XI2\<0\>\/XI2\<1\>\/RR1_neg \
 ) R_1X_LL w=1e-07 l=1e-07   res=0.149966
XXI2\<0\>\/XI2\<1\>\/XI2\<0\>\/XI2\<1\>\/XI2\<0\>\/XI2\<0\>\/XI2\<0\>\/XI2\<1\>\/RR2 \
 (  \
 N_SEL2\<0\>_XI2\<0\>\/XI2\<1\>\/XI2\<0\>\/XI2\<1\>\/XI2\<0\>\/XI2\<0\>\/XI2\<0\>\/XI2\<1\>\/RR2_pos \
 N_WLSEL\<650\>_XI2\<0\>\/XI2\<1\>\/XI2\<0\>\/XI2\<1\>\/XI2\<0\>\/XI2\<0\>\/XI2\<0\>\/XI2\<1\>\/RR2_neg \
 ) R_1X_LL w=1e-07 l=1e-07   res=0.149966
XXI2\<0\>\/XI2\<1\>\/XI2\<0\>\/XI2\<1\>\/XI2\<0\>\/XI2\<0\>\/XI2\<0\>\/XI2\<1\>\/RR3 \
 (  \
 N_SEL3\<0\>_XI2\<0\>\/XI2\<1\>\/XI2\<0\>\/XI2\<1\>\/XI2\<0\>\/XI2\<0\>\/XI2\<0\>\/XI2\<1\>\/RR3_pos \
 N_WLSEL\<651\>_XI2\<0\>\/XI2\<1\>\/XI2\<0\>\/XI2\<1\>\/XI2\<0\>\/XI2\<0\>\/XI2\<0\>\/XI2\<1\>\/RR3_neg \
 ) R_1X_LL w=1e-07 l=1e-07   res=0.149966
XXI2\<0\>\/XI2\<1\>\/XI2\<0\>\/XI2\<1\>\/XI2\<0\>\/XI2\<0\>\/XI2\<0\>\/XI2\<1\>\/RR4 \
 (  \
 N_SEL4\<1\>_XI2\<0\>\/XI2\<1\>\/XI2\<0\>\/XI2\<1\>\/XI2\<0\>\/XI2\<0\>\/XI2\<0\>\/XI2\<1\>\/RR4_pos \
 N_WLSEL\<652\>_XI2\<0\>\/XI2\<1\>\/XI2\<0\>\/XI2\<1\>\/XI2\<0\>\/XI2\<0\>\/XI2\<0\>\/XI2\<1\>\/RR4_neg \
 ) R_1X_LL w=1e-07 l=1e-07   res=0.149966
XXI2\<0\>\/XI2\<1\>\/XI2\<0\>\/XI2\<1\>\/XI2\<0\>\/XI2\<0\>\/XI2\<0\>\/XI2\<1\>\/RR7 \
 (  \
 N_SEL5\<0\>_XI2\<0\>\/XI2\<1\>\/XI2\<0\>\/XI2\<1\>\/XI2\<0\>\/XI2\<0\>\/XI2\<0\>\/XI2\<1\>\/RR7_pos \
 N_WLSEL\<653\>_XI2\<0\>\/XI2\<1\>\/XI2\<0\>\/XI2\<1\>\/XI2\<0\>\/XI2\<0\>\/XI2\<0\>\/XI2\<1\>\/RR7_neg \
 ) R_1X_LL w=1e-07 l=1e-07   res=0.149966
XXI2\<0\>\/XI2\<1\>\/XI2\<0\>\/XI2\<1\>\/XI2\<0\>\/XI2\<0\>\/XI2\<0\>\/XI2\<1\>\/RR6 \
 (  \
 N_SEL6\<1\>_XI2\<0\>\/XI2\<1\>\/XI2\<0\>\/XI2\<1\>\/XI2\<0\>\/XI2\<0\>\/XI2\<0\>\/XI2\<1\>\/RR6_pos \
 N_WLSEL\<654\>_XI2\<0\>\/XI2\<1\>\/XI2\<0\>\/XI2\<1\>\/XI2\<0\>\/XI2\<0\>\/XI2\<0\>\/XI2\<1\>\/RR6_neg \
 ) R_1X_LL w=1e-07 l=1e-07   res=0.149966
XXI2\<0\>\/XI2\<1\>\/XI2\<0\>\/XI2\<1\>\/XI2\<0\>\/XI2\<0\>\/XI2\<0\>\/XI2\<1\>\/RR5 \
 (  \
 N_SEL7\<0\>_XI2\<0\>\/XI2\<1\>\/XI2\<0\>\/XI2\<1\>\/XI2\<0\>\/XI2\<0\>\/XI2\<0\>\/XI2\<1\>\/RR5_pos \
 N_WLSEL\<655\>_XI2\<0\>\/XI2\<1\>\/XI2\<0\>\/XI2\<1\>\/XI2\<0\>\/XI2\<0\>\/XI2\<0\>\/XI2\<1\>\/RR5_neg \
 ) R_1X_LL w=1e-07 l=1e-07   res=0.149966
XXI2\<0\>\/XI2\<1\>\/XI2\<0\>\/XI2\<1\>\/XI2\<0\>\/XI2\<0\>\/XI2\<1\>\/XI2\<0\>\/RR0 \
 (  \
 N_SEL0\<0\>_XI2\<0\>\/XI2\<1\>\/XI2\<0\>\/XI2\<1\>\/XI2\<0\>\/XI2\<0\>\/XI2\<1\>\/XI2\<0\>\/RR0_pos \
 N_WLSEL\<656\>_XI2\<0\>\/XI2\<1\>\/XI2\<0\>\/XI2\<1\>\/XI2\<0\>\/XI2\<0\>\/XI2\<1\>\/XI2\<0\>\/RR0_neg \
 ) R_1X_LL w=1e-07 l=1e-07   res=0.149966
XXI2\<0\>\/XI2\<1\>\/XI2\<0\>\/XI2\<1\>\/XI2\<0\>\/XI2\<0\>\/XI2\<1\>\/XI2\<0\>\/RR1 \
 (  \
 N_SEL1\<1\>_XI2\<0\>\/XI2\<1\>\/XI2\<0\>\/XI2\<1\>\/XI2\<0\>\/XI2\<0\>\/XI2\<1\>\/XI2\<0\>\/RR1_pos \
 N_WLSEL\<657\>_XI2\<0\>\/XI2\<1\>\/XI2\<0\>\/XI2\<1\>\/XI2\<0\>\/XI2\<0\>\/XI2\<1\>\/XI2\<0\>\/RR1_neg \
 ) R_1X_LL w=1e-07 l=1e-07   res=0.149966
XXI2\<0\>\/XI2\<1\>\/XI2\<0\>\/XI2\<1\>\/XI2\<0\>\/XI2\<0\>\/XI2\<1\>\/XI2\<0\>\/RR2 \
 (  \
 N_SEL2\<0\>_XI2\<0\>\/XI2\<1\>\/XI2\<0\>\/XI2\<1\>\/XI2\<0\>\/XI2\<0\>\/XI2\<1\>\/XI2\<0\>\/RR2_pos \
 N_WLSEL\<658\>_XI2\<0\>\/XI2\<1\>\/XI2\<0\>\/XI2\<1\>\/XI2\<0\>\/XI2\<0\>\/XI2\<1\>\/XI2\<0\>\/RR2_neg \
 ) R_1X_LL w=1e-07 l=1e-07   res=0.149966
XXI2\<0\>\/XI2\<1\>\/XI2\<0\>\/XI2\<1\>\/XI2\<0\>\/XI2\<0\>\/XI2\<1\>\/XI2\<0\>\/RR3 \
 (  \
 N_SEL3\<0\>_XI2\<0\>\/XI2\<1\>\/XI2\<0\>\/XI2\<1\>\/XI2\<0\>\/XI2\<0\>\/XI2\<1\>\/XI2\<0\>\/RR3_pos \
 N_WLSEL\<659\>_XI2\<0\>\/XI2\<1\>\/XI2\<0\>\/XI2\<1\>\/XI2\<0\>\/XI2\<0\>\/XI2\<1\>\/XI2\<0\>\/RR3_neg \
 ) R_1X_LL w=1e-07 l=1e-07   res=0.149966
XXI2\<0\>\/XI2\<1\>\/XI2\<0\>\/XI2\<1\>\/XI2\<0\>\/XI2\<0\>\/XI2\<1\>\/XI2\<0\>\/RR4 \
 (  \
 N_SEL4\<1\>_XI2\<0\>\/XI2\<1\>\/XI2\<0\>\/XI2\<1\>\/XI2\<0\>\/XI2\<0\>\/XI2\<1\>\/XI2\<0\>\/RR4_pos \
 N_WLSEL\<660\>_XI2\<0\>\/XI2\<1\>\/XI2\<0\>\/XI2\<1\>\/XI2\<0\>\/XI2\<0\>\/XI2\<1\>\/XI2\<0\>\/RR4_neg \
 ) R_1X_LL w=1e-07 l=1e-07   res=0.149966
XXI2\<0\>\/XI2\<1\>\/XI2\<0\>\/XI2\<1\>\/XI2\<0\>\/XI2\<0\>\/XI2\<1\>\/XI2\<0\>\/RR7 \
 (  \
 N_SEL5\<0\>_XI2\<0\>\/XI2\<1\>\/XI2\<0\>\/XI2\<1\>\/XI2\<0\>\/XI2\<0\>\/XI2\<1\>\/XI2\<0\>\/RR7_pos \
 N_WLSEL\<661\>_XI2\<0\>\/XI2\<1\>\/XI2\<0\>\/XI2\<1\>\/XI2\<0\>\/XI2\<0\>\/XI2\<1\>\/XI2\<0\>\/RR7_neg \
 ) R_1X_LL w=1e-07 l=1e-07   res=0.149966
XXI2\<0\>\/XI2\<1\>\/XI2\<0\>\/XI2\<1\>\/XI2\<0\>\/XI2\<0\>\/XI2\<1\>\/XI2\<0\>\/RR6 \
 (  \
 N_SEL6\<1\>_XI2\<0\>\/XI2\<1\>\/XI2\<0\>\/XI2\<1\>\/XI2\<0\>\/XI2\<0\>\/XI2\<1\>\/XI2\<0\>\/RR6_pos \
 N_WLSEL\<662\>_XI2\<0\>\/XI2\<1\>\/XI2\<0\>\/XI2\<1\>\/XI2\<0\>\/XI2\<0\>\/XI2\<1\>\/XI2\<0\>\/RR6_neg \
 ) R_1X_LL w=1e-07 l=1e-07   res=0.149966
XXI2\<0\>\/XI2\<1\>\/XI2\<0\>\/XI2\<1\>\/XI2\<0\>\/XI2\<0\>\/XI2\<1\>\/XI2\<0\>\/RR5 \
 (  \
 N_SEL7\<0\>_XI2\<0\>\/XI2\<1\>\/XI2\<0\>\/XI2\<1\>\/XI2\<0\>\/XI2\<0\>\/XI2\<1\>\/XI2\<0\>\/RR5_pos \
 N_WLSEL\<663\>_XI2\<0\>\/XI2\<1\>\/XI2\<0\>\/XI2\<1\>\/XI2\<0\>\/XI2\<0\>\/XI2\<1\>\/XI2\<0\>\/RR5_neg \
 ) R_1X_LL w=1e-07 l=1e-07   res=0.149966
XXI2\<0\>\/XI2\<1\>\/XI2\<0\>\/XI2\<1\>\/XI2\<0\>\/XI2\<0\>\/XI2\<1\>\/XI2\<1\>\/RR0 \
 (  \
 N_SEL0\<1\>_XI2\<0\>\/XI2\<1\>\/XI2\<0\>\/XI2\<1\>\/XI2\<0\>\/XI2\<0\>\/XI2\<1\>\/XI2\<1\>\/RR0_pos \
 N_WLSEL\<664\>_XI2\<0\>\/XI2\<1\>\/XI2\<0\>\/XI2\<1\>\/XI2\<0\>\/XI2\<0\>\/XI2\<1\>\/XI2\<1\>\/RR0_neg \
 ) R_1X_LL w=1e-07 l=1e-07   res=0.149966
XXI2\<0\>\/XI2\<1\>\/XI2\<0\>\/XI2\<1\>\/XI2\<0\>\/XI2\<0\>\/XI2\<1\>\/XI2\<1\>\/RR1 \
 (  \
 N_SEL1\<1\>_XI2\<0\>\/XI2\<1\>\/XI2\<0\>\/XI2\<1\>\/XI2\<0\>\/XI2\<0\>\/XI2\<1\>\/XI2\<1\>\/RR1_pos \
 N_WLSEL\<665\>_XI2\<0\>\/XI2\<1\>\/XI2\<0\>\/XI2\<1\>\/XI2\<0\>\/XI2\<0\>\/XI2\<1\>\/XI2\<1\>\/RR1_neg \
 ) R_1X_LL w=1e-07 l=1e-07   res=0.149966
XXI2\<0\>\/XI2\<1\>\/XI2\<0\>\/XI2\<1\>\/XI2\<0\>\/XI2\<0\>\/XI2\<1\>\/XI2\<1\>\/RR2 \
 (  \
 N_SEL2\<0\>_XI2\<0\>\/XI2\<1\>\/XI2\<0\>\/XI2\<1\>\/XI2\<0\>\/XI2\<0\>\/XI2\<1\>\/XI2\<1\>\/RR2_pos \
 N_WLSEL\<666\>_XI2\<0\>\/XI2\<1\>\/XI2\<0\>\/XI2\<1\>\/XI2\<0\>\/XI2\<0\>\/XI2\<1\>\/XI2\<1\>\/RR2_neg \
 ) R_1X_LL w=1e-07 l=1e-07   res=0.149966
XXI2\<0\>\/XI2\<1\>\/XI2\<0\>\/XI2\<1\>\/XI2\<0\>\/XI2\<0\>\/XI2\<1\>\/XI2\<1\>\/RR3 \
 (  \
 N_SEL3\<0\>_XI2\<0\>\/XI2\<1\>\/XI2\<0\>\/XI2\<1\>\/XI2\<0\>\/XI2\<0\>\/XI2\<1\>\/XI2\<1\>\/RR3_pos \
 N_WLSEL\<667\>_XI2\<0\>\/XI2\<1\>\/XI2\<0\>\/XI2\<1\>\/XI2\<0\>\/XI2\<0\>\/XI2\<1\>\/XI2\<1\>\/RR3_neg \
 ) R_1X_LL w=1e-07 l=1e-07   res=0.149966
XXI2\<0\>\/XI2\<1\>\/XI2\<0\>\/XI2\<1\>\/XI2\<0\>\/XI2\<0\>\/XI2\<1\>\/XI2\<1\>\/RR4 \
 (  \
 N_SEL4\<1\>_XI2\<0\>\/XI2\<1\>\/XI2\<0\>\/XI2\<1\>\/XI2\<0\>\/XI2\<0\>\/XI2\<1\>\/XI2\<1\>\/RR4_pos \
 N_WLSEL\<668\>_XI2\<0\>\/XI2\<1\>\/XI2\<0\>\/XI2\<1\>\/XI2\<0\>\/XI2\<0\>\/XI2\<1\>\/XI2\<1\>\/RR4_neg \
 ) R_1X_LL w=1e-07 l=1e-07   res=0.149966
XXI2\<0\>\/XI2\<1\>\/XI2\<0\>\/XI2\<1\>\/XI2\<0\>\/XI2\<0\>\/XI2\<1\>\/XI2\<1\>\/RR7 \
 (  \
 N_SEL5\<0\>_XI2\<0\>\/XI2\<1\>\/XI2\<0\>\/XI2\<1\>\/XI2\<0\>\/XI2\<0\>\/XI2\<1\>\/XI2\<1\>\/RR7_pos \
 N_WLSEL\<669\>_XI2\<0\>\/XI2\<1\>\/XI2\<0\>\/XI2\<1\>\/XI2\<0\>\/XI2\<0\>\/XI2\<1\>\/XI2\<1\>\/RR7_neg \
 ) R_1X_LL w=1e-07 l=1e-07   res=0.149966
XXI2\<0\>\/XI2\<1\>\/XI2\<0\>\/XI2\<1\>\/XI2\<0\>\/XI2\<0\>\/XI2\<1\>\/XI2\<1\>\/RR6 \
 (  \
 N_SEL6\<1\>_XI2\<0\>\/XI2\<1\>\/XI2\<0\>\/XI2\<1\>\/XI2\<0\>\/XI2\<0\>\/XI2\<1\>\/XI2\<1\>\/RR6_pos \
 N_WLSEL\<670\>_XI2\<0\>\/XI2\<1\>\/XI2\<0\>\/XI2\<1\>\/XI2\<0\>\/XI2\<0\>\/XI2\<1\>\/XI2\<1\>\/RR6_neg \
 ) R_1X_LL w=1e-07 l=1e-07   res=0.149966
XXI2\<0\>\/XI2\<1\>\/XI2\<0\>\/XI2\<1\>\/XI2\<0\>\/XI2\<0\>\/XI2\<1\>\/XI2\<1\>\/RR5 \
 (  \
 N_SEL7\<0\>_XI2\<0\>\/XI2\<1\>\/XI2\<0\>\/XI2\<1\>\/XI2\<0\>\/XI2\<0\>\/XI2\<1\>\/XI2\<1\>\/RR5_pos \
 N_WLSEL\<671\>_XI2\<0\>\/XI2\<1\>\/XI2\<0\>\/XI2\<1\>\/XI2\<0\>\/XI2\<0\>\/XI2\<1\>\/XI2\<1\>\/RR5_neg \
 ) R_1X_LL w=1e-07 l=1e-07   res=0.149966
XXI2\<0\>\/XI2\<1\>\/XI2\<0\>\/XI2\<1\>\/XI2\<0\>\/XI2\<1\>\/XI2\<0\>\/XI2\<0\>\/RR0 \
 (  \
 N_SEL0\<0\>_XI2\<0\>\/XI2\<1\>\/XI2\<0\>\/XI2\<1\>\/XI2\<0\>\/XI2\<1\>\/XI2\<0\>\/XI2\<0\>\/RR0_pos \
 N_WLSEL\<672\>_XI2\<0\>\/XI2\<1\>\/XI2\<0\>\/XI2\<1\>\/XI2\<0\>\/XI2\<1\>\/XI2\<0\>\/XI2\<0\>\/RR0_neg \
 ) R_1X_LL w=1e-07 l=1e-07   res=0.149966
XXI2\<0\>\/XI2\<1\>\/XI2\<0\>\/XI2\<1\>\/XI2\<0\>\/XI2\<1\>\/XI2\<0\>\/XI2\<0\>\/RR1 \
 (  \
 N_SEL1\<0\>_XI2\<0\>\/XI2\<1\>\/XI2\<0\>\/XI2\<1\>\/XI2\<0\>\/XI2\<1\>\/XI2\<0\>\/XI2\<0\>\/RR1_pos \
 N_WLSEL\<673\>_XI2\<0\>\/XI2\<1\>\/XI2\<0\>\/XI2\<1\>\/XI2\<0\>\/XI2\<1\>\/XI2\<0\>\/XI2\<0\>\/RR1_neg \
 ) R_1X_LL w=1e-07 l=1e-07   res=0.149966
XXI2\<0\>\/XI2\<1\>\/XI2\<0\>\/XI2\<1\>\/XI2\<0\>\/XI2\<1\>\/XI2\<0\>\/XI2\<0\>\/RR2 \
 (  \
 N_SEL2\<1\>_XI2\<0\>\/XI2\<1\>\/XI2\<0\>\/XI2\<1\>\/XI2\<0\>\/XI2\<1\>\/XI2\<0\>\/XI2\<0\>\/RR2_pos \
 N_WLSEL\<674\>_XI2\<0\>\/XI2\<1\>\/XI2\<0\>\/XI2\<1\>\/XI2\<0\>\/XI2\<1\>\/XI2\<0\>\/XI2\<0\>\/RR2_neg \
 ) R_1X_LL w=1e-07 l=1e-07   res=0.149966
XXI2\<0\>\/XI2\<1\>\/XI2\<0\>\/XI2\<1\>\/XI2\<0\>\/XI2\<1\>\/XI2\<0\>\/XI2\<0\>\/RR3 \
 (  \
 N_SEL3\<0\>_XI2\<0\>\/XI2\<1\>\/XI2\<0\>\/XI2\<1\>\/XI2\<0\>\/XI2\<1\>\/XI2\<0\>\/XI2\<0\>\/RR3_pos \
 N_WLSEL\<675\>_XI2\<0\>\/XI2\<1\>\/XI2\<0\>\/XI2\<1\>\/XI2\<0\>\/XI2\<1\>\/XI2\<0\>\/XI2\<0\>\/RR3_neg \
 ) R_1X_LL w=1e-07 l=1e-07   res=0.149966
XXI2\<0\>\/XI2\<1\>\/XI2\<0\>\/XI2\<1\>\/XI2\<0\>\/XI2\<1\>\/XI2\<0\>\/XI2\<0\>\/RR4 \
 (  \
 N_SEL4\<1\>_XI2\<0\>\/XI2\<1\>\/XI2\<0\>\/XI2\<1\>\/XI2\<0\>\/XI2\<1\>\/XI2\<0\>\/XI2\<0\>\/RR4_pos \
 N_WLSEL\<676\>_XI2\<0\>\/XI2\<1\>\/XI2\<0\>\/XI2\<1\>\/XI2\<0\>\/XI2\<1\>\/XI2\<0\>\/XI2\<0\>\/RR4_neg \
 ) R_1X_LL w=1e-07 l=1e-07   res=0.149966
XXI2\<0\>\/XI2\<1\>\/XI2\<0\>\/XI2\<1\>\/XI2\<0\>\/XI2\<1\>\/XI2\<0\>\/XI2\<0\>\/RR7 \
 (  \
 N_SEL5\<0\>_XI2\<0\>\/XI2\<1\>\/XI2\<0\>\/XI2\<1\>\/XI2\<0\>\/XI2\<1\>\/XI2\<0\>\/XI2\<0\>\/RR7_pos \
 N_WLSEL\<677\>_XI2\<0\>\/XI2\<1\>\/XI2\<0\>\/XI2\<1\>\/XI2\<0\>\/XI2\<1\>\/XI2\<0\>\/XI2\<0\>\/RR7_neg \
 ) R_1X_LL w=1e-07 l=1e-07   res=0.149966
XXI2\<0\>\/XI2\<1\>\/XI2\<0\>\/XI2\<1\>\/XI2\<0\>\/XI2\<1\>\/XI2\<0\>\/XI2\<0\>\/RR6 \
 (  \
 N_SEL6\<1\>_XI2\<0\>\/XI2\<1\>\/XI2\<0\>\/XI2\<1\>\/XI2\<0\>\/XI2\<1\>\/XI2\<0\>\/XI2\<0\>\/RR6_pos \
 N_WLSEL\<678\>_XI2\<0\>\/XI2\<1\>\/XI2\<0\>\/XI2\<1\>\/XI2\<0\>\/XI2\<1\>\/XI2\<0\>\/XI2\<0\>\/RR6_neg \
 ) R_1X_LL w=1e-07 l=1e-07   res=0.149966
XXI2\<0\>\/XI2\<1\>\/XI2\<0\>\/XI2\<1\>\/XI2\<0\>\/XI2\<1\>\/XI2\<0\>\/XI2\<0\>\/RR5 \
 (  \
 N_SEL7\<0\>_XI2\<0\>\/XI2\<1\>\/XI2\<0\>\/XI2\<1\>\/XI2\<0\>\/XI2\<1\>\/XI2\<0\>\/XI2\<0\>\/RR5_pos \
 N_WLSEL\<679\>_XI2\<0\>\/XI2\<1\>\/XI2\<0\>\/XI2\<1\>\/XI2\<0\>\/XI2\<1\>\/XI2\<0\>\/XI2\<0\>\/RR5_neg \
 ) R_1X_LL w=1e-07 l=1e-07   res=0.149966
XXI2\<0\>\/XI2\<1\>\/XI2\<0\>\/XI2\<1\>\/XI2\<0\>\/XI2\<1\>\/XI2\<0\>\/XI2\<1\>\/RR0 \
 (  \
 N_SEL0\<1\>_XI2\<0\>\/XI2\<1\>\/XI2\<0\>\/XI2\<1\>\/XI2\<0\>\/XI2\<1\>\/XI2\<0\>\/XI2\<1\>\/RR0_pos \
 N_WLSEL\<680\>_XI2\<0\>\/XI2\<1\>\/XI2\<0\>\/XI2\<1\>\/XI2\<0\>\/XI2\<1\>\/XI2\<0\>\/XI2\<1\>\/RR0_neg \
 ) R_1X_LL w=1e-07 l=1e-07   res=0.149966
XXI2\<0\>\/XI2\<1\>\/XI2\<0\>\/XI2\<1\>\/XI2\<0\>\/XI2\<1\>\/XI2\<0\>\/XI2\<1\>\/RR1 \
 (  \
 N_SEL1\<0\>_XI2\<0\>\/XI2\<1\>\/XI2\<0\>\/XI2\<1\>\/XI2\<0\>\/XI2\<1\>\/XI2\<0\>\/XI2\<1\>\/RR1_pos \
 N_WLSEL\<681\>_XI2\<0\>\/XI2\<1\>\/XI2\<0\>\/XI2\<1\>\/XI2\<0\>\/XI2\<1\>\/XI2\<0\>\/XI2\<1\>\/RR1_neg \
 ) R_1X_LL w=1e-07 l=1e-07   res=0.149966
XXI2\<0\>\/XI2\<1\>\/XI2\<0\>\/XI2\<1\>\/XI2\<0\>\/XI2\<1\>\/XI2\<0\>\/XI2\<1\>\/RR2 \
 (  \
 N_SEL2\<1\>_XI2\<0\>\/XI2\<1\>\/XI2\<0\>\/XI2\<1\>\/XI2\<0\>\/XI2\<1\>\/XI2\<0\>\/XI2\<1\>\/RR2_pos \
 N_WLSEL\<682\>_XI2\<0\>\/XI2\<1\>\/XI2\<0\>\/XI2\<1\>\/XI2\<0\>\/XI2\<1\>\/XI2\<0\>\/XI2\<1\>\/RR2_neg \
 ) R_1X_LL w=1e-07 l=1e-07   res=0.149966
XXI2\<0\>\/XI2\<1\>\/XI2\<0\>\/XI2\<1\>\/XI2\<0\>\/XI2\<1\>\/XI2\<0\>\/XI2\<1\>\/RR3 \
 (  \
 N_SEL3\<0\>_XI2\<0\>\/XI2\<1\>\/XI2\<0\>\/XI2\<1\>\/XI2\<0\>\/XI2\<1\>\/XI2\<0\>\/XI2\<1\>\/RR3_pos \
 N_WLSEL\<683\>_XI2\<0\>\/XI2\<1\>\/XI2\<0\>\/XI2\<1\>\/XI2\<0\>\/XI2\<1\>\/XI2\<0\>\/XI2\<1\>\/RR3_neg \
 ) R_1X_LL w=1e-07 l=1e-07   res=0.149966
XXI2\<0\>\/XI2\<1\>\/XI2\<0\>\/XI2\<1\>\/XI2\<0\>\/XI2\<1\>\/XI2\<0\>\/XI2\<1\>\/RR4 \
 (  \
 N_SEL4\<1\>_XI2\<0\>\/XI2\<1\>\/XI2\<0\>\/XI2\<1\>\/XI2\<0\>\/XI2\<1\>\/XI2\<0\>\/XI2\<1\>\/RR4_pos \
 N_WLSEL\<684\>_XI2\<0\>\/XI2\<1\>\/XI2\<0\>\/XI2\<1\>\/XI2\<0\>\/XI2\<1\>\/XI2\<0\>\/XI2\<1\>\/RR4_neg \
 ) R_1X_LL w=1e-07 l=1e-07   res=0.149966
XXI2\<0\>\/XI2\<1\>\/XI2\<0\>\/XI2\<1\>\/XI2\<0\>\/XI2\<1\>\/XI2\<0\>\/XI2\<1\>\/RR7 \
 (  \
 N_SEL5\<0\>_XI2\<0\>\/XI2\<1\>\/XI2\<0\>\/XI2\<1\>\/XI2\<0\>\/XI2\<1\>\/XI2\<0\>\/XI2\<1\>\/RR7_pos \
 N_WLSEL\<685\>_XI2\<0\>\/XI2\<1\>\/XI2\<0\>\/XI2\<1\>\/XI2\<0\>\/XI2\<1\>\/XI2\<0\>\/XI2\<1\>\/RR7_neg \
 ) R_1X_LL w=1e-07 l=1e-07   res=0.149966
XXI2\<0\>\/XI2\<1\>\/XI2\<0\>\/XI2\<1\>\/XI2\<0\>\/XI2\<1\>\/XI2\<0\>\/XI2\<1\>\/RR6 \
 (  \
 N_SEL6\<1\>_XI2\<0\>\/XI2\<1\>\/XI2\<0\>\/XI2\<1\>\/XI2\<0\>\/XI2\<1\>\/XI2\<0\>\/XI2\<1\>\/RR6_pos \
 N_WLSEL\<686\>_XI2\<0\>\/XI2\<1\>\/XI2\<0\>\/XI2\<1\>\/XI2\<0\>\/XI2\<1\>\/XI2\<0\>\/XI2\<1\>\/RR6_neg \
 ) R_1X_LL w=1e-07 l=1e-07   res=0.149966
XXI2\<0\>\/XI2\<1\>\/XI2\<0\>\/XI2\<1\>\/XI2\<0\>\/XI2\<1\>\/XI2\<0\>\/XI2\<1\>\/RR5 \
 (  \
 N_SEL7\<0\>_XI2\<0\>\/XI2\<1\>\/XI2\<0\>\/XI2\<1\>\/XI2\<0\>\/XI2\<1\>\/XI2\<0\>\/XI2\<1\>\/RR5_pos \
 N_WLSEL\<687\>_XI2\<0\>\/XI2\<1\>\/XI2\<0\>\/XI2\<1\>\/XI2\<0\>\/XI2\<1\>\/XI2\<0\>\/XI2\<1\>\/RR5_neg \
 ) R_1X_LL w=1e-07 l=1e-07   res=0.149966
XXI2\<0\>\/XI2\<1\>\/XI2\<0\>\/XI2\<1\>\/XI2\<0\>\/XI2\<1\>\/XI2\<1\>\/XI2\<0\>\/RR0 \
 (  \
 N_SEL0\<0\>_XI2\<0\>\/XI2\<1\>\/XI2\<0\>\/XI2\<1\>\/XI2\<0\>\/XI2\<1\>\/XI2\<1\>\/XI2\<0\>\/RR0_pos \
 N_WLSEL\<688\>_XI2\<0\>\/XI2\<1\>\/XI2\<0\>\/XI2\<1\>\/XI2\<0\>\/XI2\<1\>\/XI2\<1\>\/XI2\<0\>\/RR0_neg \
 ) R_1X_LL w=1e-07 l=1e-07   res=0.149966
XXI2\<0\>\/XI2\<1\>\/XI2\<0\>\/XI2\<1\>\/XI2\<0\>\/XI2\<1\>\/XI2\<1\>\/XI2\<0\>\/RR1 \
 (  \
 N_SEL1\<1\>_XI2\<0\>\/XI2\<1\>\/XI2\<0\>\/XI2\<1\>\/XI2\<0\>\/XI2\<1\>\/XI2\<1\>\/XI2\<0\>\/RR1_pos \
 N_WLSEL\<689\>_XI2\<0\>\/XI2\<1\>\/XI2\<0\>\/XI2\<1\>\/XI2\<0\>\/XI2\<1\>\/XI2\<1\>\/XI2\<0\>\/RR1_neg \
 ) R_1X_LL w=1e-07 l=1e-07   res=0.149966
XXI2\<0\>\/XI2\<1\>\/XI2\<0\>\/XI2\<1\>\/XI2\<0\>\/XI2\<1\>\/XI2\<1\>\/XI2\<0\>\/RR2 \
 (  \
 N_SEL2\<1\>_XI2\<0\>\/XI2\<1\>\/XI2\<0\>\/XI2\<1\>\/XI2\<0\>\/XI2\<1\>\/XI2\<1\>\/XI2\<0\>\/RR2_pos \
 N_WLSEL\<690\>_XI2\<0\>\/XI2\<1\>\/XI2\<0\>\/XI2\<1\>\/XI2\<0\>\/XI2\<1\>\/XI2\<1\>\/XI2\<0\>\/RR2_neg \
 ) R_1X_LL w=1e-07 l=1e-07   res=0.149966
XXI2\<0\>\/XI2\<1\>\/XI2\<0\>\/XI2\<1\>\/XI2\<0\>\/XI2\<1\>\/XI2\<1\>\/XI2\<0\>\/RR3 \
 (  \
 N_SEL3\<0\>_XI2\<0\>\/XI2\<1\>\/XI2\<0\>\/XI2\<1\>\/XI2\<0\>\/XI2\<1\>\/XI2\<1\>\/XI2\<0\>\/RR3_pos \
 N_WLSEL\<691\>_XI2\<0\>\/XI2\<1\>\/XI2\<0\>\/XI2\<1\>\/XI2\<0\>\/XI2\<1\>\/XI2\<1\>\/XI2\<0\>\/RR3_neg \
 ) R_1X_LL w=1e-07 l=1e-07   res=0.149966
XXI2\<0\>\/XI2\<1\>\/XI2\<0\>\/XI2\<1\>\/XI2\<0\>\/XI2\<1\>\/XI2\<1\>\/XI2\<0\>\/RR4 \
 (  \
 N_SEL4\<1\>_XI2\<0\>\/XI2\<1\>\/XI2\<0\>\/XI2\<1\>\/XI2\<0\>\/XI2\<1\>\/XI2\<1\>\/XI2\<0\>\/RR4_pos \
 N_WLSEL\<692\>_XI2\<0\>\/XI2\<1\>\/XI2\<0\>\/XI2\<1\>\/XI2\<0\>\/XI2\<1\>\/XI2\<1\>\/XI2\<0\>\/RR4_neg \
 ) R_1X_LL w=1e-07 l=1e-07   res=0.149966
XXI2\<0\>\/XI2\<1\>\/XI2\<0\>\/XI2\<1\>\/XI2\<0\>\/XI2\<1\>\/XI2\<1\>\/XI2\<0\>\/RR7 \
 (  \
 N_SEL5\<0\>_XI2\<0\>\/XI2\<1\>\/XI2\<0\>\/XI2\<1\>\/XI2\<0\>\/XI2\<1\>\/XI2\<1\>\/XI2\<0\>\/RR7_pos \
 N_WLSEL\<693\>_XI2\<0\>\/XI2\<1\>\/XI2\<0\>\/XI2\<1\>\/XI2\<0\>\/XI2\<1\>\/XI2\<1\>\/XI2\<0\>\/RR7_neg \
 ) R_1X_LL w=1e-07 l=1e-07   res=0.149966
XXI2\<0\>\/XI2\<1\>\/XI2\<0\>\/XI2\<1\>\/XI2\<0\>\/XI2\<1\>\/XI2\<1\>\/XI2\<0\>\/RR6 \
 (  \
 N_SEL6\<1\>_XI2\<0\>\/XI2\<1\>\/XI2\<0\>\/XI2\<1\>\/XI2\<0\>\/XI2\<1\>\/XI2\<1\>\/XI2\<0\>\/RR6_pos \
 N_WLSEL\<694\>_XI2\<0\>\/XI2\<1\>\/XI2\<0\>\/XI2\<1\>\/XI2\<0\>\/XI2\<1\>\/XI2\<1\>\/XI2\<0\>\/RR6_neg \
 ) R_1X_LL w=1e-07 l=1e-07   res=0.149966
XXI2\<0\>\/XI2\<1\>\/XI2\<0\>\/XI2\<1\>\/XI2\<0\>\/XI2\<1\>\/XI2\<1\>\/XI2\<0\>\/RR5 \
 (  \
 N_SEL7\<0\>_XI2\<0\>\/XI2\<1\>\/XI2\<0\>\/XI2\<1\>\/XI2\<0\>\/XI2\<1\>\/XI2\<1\>\/XI2\<0\>\/RR5_pos \
 N_WLSEL\<695\>_XI2\<0\>\/XI2\<1\>\/XI2\<0\>\/XI2\<1\>\/XI2\<0\>\/XI2\<1\>\/XI2\<1\>\/XI2\<0\>\/RR5_neg \
 ) R_1X_LL w=1e-07 l=1e-07   res=0.149966
XXI2\<0\>\/XI2\<1\>\/XI2\<0\>\/XI2\<1\>\/XI2\<0\>\/XI2\<1\>\/XI2\<1\>\/XI2\<1\>\/RR0 \
 (  \
 N_SEL0\<1\>_XI2\<0\>\/XI2\<1\>\/XI2\<0\>\/XI2\<1\>\/XI2\<0\>\/XI2\<1\>\/XI2\<1\>\/XI2\<1\>\/RR0_pos \
 N_WLSEL\<696\>_XI2\<0\>\/XI2\<1\>\/XI2\<0\>\/XI2\<1\>\/XI2\<0\>\/XI2\<1\>\/XI2\<1\>\/XI2\<1\>\/RR0_neg \
 ) R_1X_LL w=1e-07 l=1e-07   res=0.149966
XXI2\<0\>\/XI2\<1\>\/XI2\<0\>\/XI2\<1\>\/XI2\<0\>\/XI2\<1\>\/XI2\<1\>\/XI2\<1\>\/RR1 \
 (  \
 N_SEL1\<1\>_XI2\<0\>\/XI2\<1\>\/XI2\<0\>\/XI2\<1\>\/XI2\<0\>\/XI2\<1\>\/XI2\<1\>\/XI2\<1\>\/RR1_pos \
 N_WLSEL\<697\>_XI2\<0\>\/XI2\<1\>\/XI2\<0\>\/XI2\<1\>\/XI2\<0\>\/XI2\<1\>\/XI2\<1\>\/XI2\<1\>\/RR1_neg \
 ) R_1X_LL w=1e-07 l=1e-07   res=0.149966
XXI2\<0\>\/XI2\<1\>\/XI2\<0\>\/XI2\<1\>\/XI2\<0\>\/XI2\<1\>\/XI2\<1\>\/XI2\<1\>\/RR2 \
 (  \
 N_SEL2\<1\>_XI2\<0\>\/XI2\<1\>\/XI2\<0\>\/XI2\<1\>\/XI2\<0\>\/XI2\<1\>\/XI2\<1\>\/XI2\<1\>\/RR2_pos \
 N_WLSEL\<698\>_XI2\<0\>\/XI2\<1\>\/XI2\<0\>\/XI2\<1\>\/XI2\<0\>\/XI2\<1\>\/XI2\<1\>\/XI2\<1\>\/RR2_neg \
 ) R_1X_LL w=1e-07 l=1e-07   res=0.149966
XXI2\<0\>\/XI2\<1\>\/XI2\<0\>\/XI2\<1\>\/XI2\<0\>\/XI2\<1\>\/XI2\<1\>\/XI2\<1\>\/RR3 \
 (  \
 N_SEL3\<0\>_XI2\<0\>\/XI2\<1\>\/XI2\<0\>\/XI2\<1\>\/XI2\<0\>\/XI2\<1\>\/XI2\<1\>\/XI2\<1\>\/RR3_pos \
 N_WLSEL\<699\>_XI2\<0\>\/XI2\<1\>\/XI2\<0\>\/XI2\<1\>\/XI2\<0\>\/XI2\<1\>\/XI2\<1\>\/XI2\<1\>\/RR3_neg \
 ) R_1X_LL w=1e-07 l=1e-07   res=0.149966
XXI2\<0\>\/XI2\<1\>\/XI2\<0\>\/XI2\<1\>\/XI2\<0\>\/XI2\<1\>\/XI2\<1\>\/XI2\<1\>\/RR4 \
 (  \
 N_SEL4\<1\>_XI2\<0\>\/XI2\<1\>\/XI2\<0\>\/XI2\<1\>\/XI2\<0\>\/XI2\<1\>\/XI2\<1\>\/XI2\<1\>\/RR4_pos \
 N_WLSEL\<700\>_XI2\<0\>\/XI2\<1\>\/XI2\<0\>\/XI2\<1\>\/XI2\<0\>\/XI2\<1\>\/XI2\<1\>\/XI2\<1\>\/RR4_neg \
 ) R_1X_LL w=1e-07 l=1e-07   res=0.149966
XXI2\<0\>\/XI2\<1\>\/XI2\<0\>\/XI2\<1\>\/XI2\<0\>\/XI2\<1\>\/XI2\<1\>\/XI2\<1\>\/RR7 \
 (  \
 N_SEL5\<0\>_XI2\<0\>\/XI2\<1\>\/XI2\<0\>\/XI2\<1\>\/XI2\<0\>\/XI2\<1\>\/XI2\<1\>\/XI2\<1\>\/RR7_pos \
 N_WLSEL\<701\>_XI2\<0\>\/XI2\<1\>\/XI2\<0\>\/XI2\<1\>\/XI2\<0\>\/XI2\<1\>\/XI2\<1\>\/XI2\<1\>\/RR7_neg \
 ) R_1X_LL w=1e-07 l=1e-07   res=0.149966
XXI2\<0\>\/XI2\<0\>\/XI2\<0\>\/XI2\<0\>\/XI2\<1\>\/XI2\<1\>\/XI2\<0\>\/XI2\<1\>\/RR6 \
 (  \
 N_SEL6\<0\>_XI2\<0\>\/XI2\<0\>\/XI2\<0\>\/XI2\<0\>\/XI2\<1\>\/XI2\<1\>\/XI2\<0\>\/XI2\<1\>\/RR6_pos \
 N_WLSEL\<110\>_XI2\<0\>\/XI2\<0\>\/XI2\<0\>\/XI2\<0\>\/XI2\<1\>\/XI2\<1\>\/XI2\<0\>\/XI2\<1\>\/RR6_neg \
 ) R_1X_LL w=1e-07 l=1e-07   res=0.149966
XXI2\<0\>\/XI2\<0\>\/XI2\<0\>\/XI2\<0\>\/XI2\<1\>\/XI2\<1\>\/XI2\<0\>\/XI2\<1\>\/RR5 \
 (  \
 N_SEL7\<0\>_XI2\<0\>\/XI2\<0\>\/XI2\<0\>\/XI2\<0\>\/XI2\<1\>\/XI2\<1\>\/XI2\<0\>\/XI2\<1\>\/RR5_pos \
 N_WLSEL\<111\>_XI2\<0\>\/XI2\<0\>\/XI2\<0\>\/XI2\<0\>\/XI2\<1\>\/XI2\<1\>\/XI2\<0\>\/XI2\<1\>\/RR5_neg \
 ) R_1X_LL w=1e-07 l=1e-07   res=0.149966
XXI2\<0\>\/XI2\<0\>\/XI2\<0\>\/XI2\<0\>\/XI2\<1\>\/XI2\<1\>\/XI2\<1\>\/XI2\<0\>\/RR0 \
 (  \
 N_SEL0\<0\>_XI2\<0\>\/XI2\<0\>\/XI2\<0\>\/XI2\<0\>\/XI2\<1\>\/XI2\<1\>\/XI2\<1\>\/XI2\<0\>\/RR0_pos \
 N_WLSEL\<112\>_XI2\<0\>\/XI2\<0\>\/XI2\<0\>\/XI2\<0\>\/XI2\<1\>\/XI2\<1\>\/XI2\<1\>\/XI2\<0\>\/RR0_neg \
 ) R_1X_LL w=1e-07 l=1e-07   res=0.149966
XXI2\<0\>\/XI2\<0\>\/XI2\<0\>\/XI2\<0\>\/XI2\<1\>\/XI2\<1\>\/XI2\<1\>\/XI2\<0\>\/RR1 \
 (  \
 N_SEL1\<1\>_XI2\<0\>\/XI2\<0\>\/XI2\<0\>\/XI2\<0\>\/XI2\<1\>\/XI2\<1\>\/XI2\<1\>\/XI2\<0\>\/RR1_pos \
 N_WLSEL\<113\>_XI2\<0\>\/XI2\<0\>\/XI2\<0\>\/XI2\<0\>\/XI2\<1\>\/XI2\<1\>\/XI2\<1\>\/XI2\<0\>\/RR1_neg \
 ) R_1X_LL w=1e-07 l=1e-07   res=0.149966
XXI2\<0\>\/XI2\<0\>\/XI2\<0\>\/XI2\<0\>\/XI2\<1\>\/XI2\<1\>\/XI2\<1\>\/XI2\<0\>\/RR2 \
 (  \
 N_SEL2\<1\>_XI2\<0\>\/XI2\<0\>\/XI2\<0\>\/XI2\<0\>\/XI2\<1\>\/XI2\<1\>\/XI2\<1\>\/XI2\<0\>\/RR2_pos \
 N_WLSEL\<114\>_XI2\<0\>\/XI2\<0\>\/XI2\<0\>\/XI2\<0\>\/XI2\<1\>\/XI2\<1\>\/XI2\<1\>\/XI2\<0\>\/RR2_neg \
 ) R_1X_LL w=1e-07 l=1e-07   res=0.149966
XXI2\<0\>\/XI2\<0\>\/XI2\<0\>\/XI2\<0\>\/XI2\<1\>\/XI2\<1\>\/XI2\<1\>\/XI2\<0\>\/RR3 \
 (  \
 N_SEL3\<1\>_XI2\<0\>\/XI2\<0\>\/XI2\<0\>\/XI2\<0\>\/XI2\<1\>\/XI2\<1\>\/XI2\<1\>\/XI2\<0\>\/RR3_pos \
 N_WLSEL\<115\>_XI2\<0\>\/XI2\<0\>\/XI2\<0\>\/XI2\<0\>\/XI2\<1\>\/XI2\<1\>\/XI2\<1\>\/XI2\<0\>\/RR3_neg \
 ) R_1X_LL w=1e-07 l=1e-07   res=0.149966
XXI2\<0\>\/XI2\<0\>\/XI2\<0\>\/XI2\<0\>\/XI2\<1\>\/XI2\<1\>\/XI2\<1\>\/XI2\<0\>\/RR4 \
 (  \
 N_SEL4\<0\>_XI2\<0\>\/XI2\<0\>\/XI2\<0\>\/XI2\<0\>\/XI2\<1\>\/XI2\<1\>\/XI2\<1\>\/XI2\<0\>\/RR4_pos \
 N_WLSEL\<116\>_XI2\<0\>\/XI2\<0\>\/XI2\<0\>\/XI2\<0\>\/XI2\<1\>\/XI2\<1\>\/XI2\<1\>\/XI2\<0\>\/RR4_neg \
 ) R_1X_LL w=1e-07 l=1e-07   res=0.149966
XXI2\<0\>\/XI2\<0\>\/XI2\<0\>\/XI2\<0\>\/XI2\<1\>\/XI2\<1\>\/XI2\<1\>\/XI2\<0\>\/RR7 \
 (  \
 N_SEL5\<0\>_XI2\<0\>\/XI2\<0\>\/XI2\<0\>\/XI2\<0\>\/XI2\<1\>\/XI2\<1\>\/XI2\<1\>\/XI2\<0\>\/RR7_pos \
 N_WLSEL\<117\>_XI2\<0\>\/XI2\<0\>\/XI2\<0\>\/XI2\<0\>\/XI2\<1\>\/XI2\<1\>\/XI2\<1\>\/XI2\<0\>\/RR7_neg \
 ) R_1X_LL w=1e-07 l=1e-07   res=0.149966
XXI2\<0\>\/XI2\<0\>\/XI2\<0\>\/XI2\<0\>\/XI2\<1\>\/XI2\<1\>\/XI2\<1\>\/XI2\<0\>\/RR6 \
 (  \
 N_SEL6\<0\>_XI2\<0\>\/XI2\<0\>\/XI2\<0\>\/XI2\<0\>\/XI2\<1\>\/XI2\<1\>\/XI2\<1\>\/XI2\<0\>\/RR6_pos \
 N_WLSEL\<118\>_XI2\<0\>\/XI2\<0\>\/XI2\<0\>\/XI2\<0\>\/XI2\<1\>\/XI2\<1\>\/XI2\<1\>\/XI2\<0\>\/RR6_neg \
 ) R_1X_LL w=1e-07 l=1e-07   res=0.149966
XXI2\<0\>\/XI2\<0\>\/XI2\<0\>\/XI2\<0\>\/XI2\<1\>\/XI2\<1\>\/XI2\<1\>\/XI2\<0\>\/RR5 \
 (  \
 N_SEL7\<0\>_XI2\<0\>\/XI2\<0\>\/XI2\<0\>\/XI2\<0\>\/XI2\<1\>\/XI2\<1\>\/XI2\<1\>\/XI2\<0\>\/RR5_pos \
 N_WLSEL\<119\>_XI2\<0\>\/XI2\<0\>\/XI2\<0\>\/XI2\<0\>\/XI2\<1\>\/XI2\<1\>\/XI2\<1\>\/XI2\<0\>\/RR5_neg \
 ) R_1X_LL w=1e-07 l=1e-07   res=0.149966
XXI2\<0\>\/XI2\<0\>\/XI2\<0\>\/XI2\<0\>\/XI2\<1\>\/XI2\<1\>\/XI2\<1\>\/XI2\<1\>\/RR0 \
 (  \
 N_SEL0\<1\>_XI2\<0\>\/XI2\<0\>\/XI2\<0\>\/XI2\<0\>\/XI2\<1\>\/XI2\<1\>\/XI2\<1\>\/XI2\<1\>\/RR0_pos \
 N_WLSEL\<120\>_XI2\<0\>\/XI2\<0\>\/XI2\<0\>\/XI2\<0\>\/XI2\<1\>\/XI2\<1\>\/XI2\<1\>\/XI2\<1\>\/RR0_neg \
 ) R_1X_LL w=1e-07 l=1e-07   res=0.149966
XXI2\<0\>\/XI2\<0\>\/XI2\<0\>\/XI2\<0\>\/XI2\<1\>\/XI2\<1\>\/XI2\<1\>\/XI2\<1\>\/RR1 \
 (  \
 N_SEL1\<1\>_XI2\<0\>\/XI2\<0\>\/XI2\<0\>\/XI2\<0\>\/XI2\<1\>\/XI2\<1\>\/XI2\<1\>\/XI2\<1\>\/RR1_pos \
 N_WLSEL\<121\>_XI2\<0\>\/XI2\<0\>\/XI2\<0\>\/XI2\<0\>\/XI2\<1\>\/XI2\<1\>\/XI2\<1\>\/XI2\<1\>\/RR1_neg \
 ) R_1X_LL w=1e-07 l=1e-07   res=0.149966
XXI2\<0\>\/XI2\<0\>\/XI2\<0\>\/XI2\<0\>\/XI2\<1\>\/XI2\<1\>\/XI2\<1\>\/XI2\<1\>\/RR2 \
 (  \
 N_SEL2\<1\>_XI2\<0\>\/XI2\<0\>\/XI2\<0\>\/XI2\<0\>\/XI2\<1\>\/XI2\<1\>\/XI2\<1\>\/XI2\<1\>\/RR2_pos \
 N_WLSEL\<122\>_XI2\<0\>\/XI2\<0\>\/XI2\<0\>\/XI2\<0\>\/XI2\<1\>\/XI2\<1\>\/XI2\<1\>\/XI2\<1\>\/RR2_neg \
 ) R_1X_LL w=1e-07 l=1e-07   res=0.149966
XXI2\<0\>\/XI2\<0\>\/XI2\<0\>\/XI2\<0\>\/XI2\<1\>\/XI2\<1\>\/XI2\<1\>\/XI2\<1\>\/RR3 \
 (  \
 N_SEL3\<1\>_XI2\<0\>\/XI2\<0\>\/XI2\<0\>\/XI2\<0\>\/XI2\<1\>\/XI2\<1\>\/XI2\<1\>\/XI2\<1\>\/RR3_pos \
 N_WLSEL\<123\>_XI2\<0\>\/XI2\<0\>\/XI2\<0\>\/XI2\<0\>\/XI2\<1\>\/XI2\<1\>\/XI2\<1\>\/XI2\<1\>\/RR3_neg \
 ) R_1X_LL w=1e-07 l=1e-07   res=0.149966
XXI2\<0\>\/XI2\<0\>\/XI2\<0\>\/XI2\<0\>\/XI2\<1\>\/XI2\<1\>\/XI2\<1\>\/XI2\<1\>\/RR4 \
 (  \
 N_SEL4\<0\>_XI2\<0\>\/XI2\<0\>\/XI2\<0\>\/XI2\<0\>\/XI2\<1\>\/XI2\<1\>\/XI2\<1\>\/XI2\<1\>\/RR4_pos \
 N_WLSEL\<124\>_XI2\<0\>\/XI2\<0\>\/XI2\<0\>\/XI2\<0\>\/XI2\<1\>\/XI2\<1\>\/XI2\<1\>\/XI2\<1\>\/RR4_neg \
 ) R_1X_LL w=1e-07 l=1e-07   res=0.149966
XXI2\<0\>\/XI2\<0\>\/XI2\<0\>\/XI2\<0\>\/XI2\<1\>\/XI2\<1\>\/XI2\<1\>\/XI2\<1\>\/RR7 \
 (  \
 N_SEL5\<0\>_XI2\<0\>\/XI2\<0\>\/XI2\<0\>\/XI2\<0\>\/XI2\<1\>\/XI2\<1\>\/XI2\<1\>\/XI2\<1\>\/RR7_pos \
 N_WLSEL\<125\>_XI2\<0\>\/XI2\<0\>\/XI2\<0\>\/XI2\<0\>\/XI2\<1\>\/XI2\<1\>\/XI2\<1\>\/XI2\<1\>\/RR7_neg \
 ) R_1X_LL w=1e-07 l=1e-07   res=0.149966
XXI2\<0\>\/XI2\<0\>\/XI2\<0\>\/XI2\<0\>\/XI2\<1\>\/XI2\<1\>\/XI2\<1\>\/XI2\<1\>\/RR6 \
 (  \
 N_SEL6\<0\>_XI2\<0\>\/XI2\<0\>\/XI2\<0\>\/XI2\<0\>\/XI2\<1\>\/XI2\<1\>\/XI2\<1\>\/XI2\<1\>\/RR6_pos \
 N_WLSEL\<126\>_XI2\<0\>\/XI2\<0\>\/XI2\<0\>\/XI2\<0\>\/XI2\<1\>\/XI2\<1\>\/XI2\<1\>\/XI2\<1\>\/RR6_neg \
 ) R_1X_LL w=1e-07 l=1e-07   res=0.149966
XXI2\<0\>\/XI2\<0\>\/XI2\<0\>\/XI2\<0\>\/XI2\<1\>\/XI2\<1\>\/XI2\<1\>\/XI2\<1\>\/RR5 \
 (  \
 N_SEL7\<0\>_XI2\<0\>\/XI2\<0\>\/XI2\<0\>\/XI2\<0\>\/XI2\<1\>\/XI2\<1\>\/XI2\<1\>\/XI2\<1\>\/RR5_pos \
 N_WLSEL\<127\>_XI2\<0\>\/XI2\<0\>\/XI2\<0\>\/XI2\<0\>\/XI2\<1\>\/XI2\<1\>\/XI2\<1\>\/XI2\<1\>\/RR5_neg \
 ) R_1X_LL w=1e-07 l=1e-07   res=0.149966
XXI2\<0\>\/XI2\<0\>\/XI2\<0\>\/XI2\<1\>\/XI2\<0\>\/XI2\<0\>\/XI2\<0\>\/XI2\<0\>\/RR0 \
 (  \
 N_SEL0\<0\>_XI2\<0\>\/XI2\<0\>\/XI2\<0\>\/XI2\<1\>\/XI2\<0\>\/XI2\<0\>\/XI2\<0\>\/XI2\<0\>\/RR0_pos \
 N_WLSEL\<128\>_XI2\<0\>\/XI2\<0\>\/XI2\<0\>\/XI2\<1\>\/XI2\<0\>\/XI2\<0\>\/XI2\<0\>\/XI2\<0\>\/RR0_neg \
 ) R_1X_LL w=1e-07 l=1e-07   res=0.149966
XXI2\<0\>\/XI2\<0\>\/XI2\<0\>\/XI2\<1\>\/XI2\<0\>\/XI2\<0\>\/XI2\<0\>\/XI2\<0\>\/RR1 \
 (  \
 N_SEL1\<0\>_XI2\<0\>\/XI2\<0\>\/XI2\<0\>\/XI2\<1\>\/XI2\<0\>\/XI2\<0\>\/XI2\<0\>\/XI2\<0\>\/RR1_pos \
 N_WLSEL\<129\>_XI2\<0\>\/XI2\<0\>\/XI2\<0\>\/XI2\<1\>\/XI2\<0\>\/XI2\<0\>\/XI2\<0\>\/XI2\<0\>\/RR1_neg \
 ) R_1X_LL w=1e-07 l=1e-07   res=0.149966
XXI2\<0\>\/XI2\<0\>\/XI2\<0\>\/XI2\<1\>\/XI2\<0\>\/XI2\<0\>\/XI2\<0\>\/XI2\<0\>\/RR2 \
 (  \
 N_SEL2\<0\>_XI2\<0\>\/XI2\<0\>\/XI2\<0\>\/XI2\<1\>\/XI2\<0\>\/XI2\<0\>\/XI2\<0\>\/XI2\<0\>\/RR2_pos \
 N_WLSEL\<130\>_XI2\<0\>\/XI2\<0\>\/XI2\<0\>\/XI2\<1\>\/XI2\<0\>\/XI2\<0\>\/XI2\<0\>\/XI2\<0\>\/RR2_neg \
 ) R_1X_LL w=1e-07 l=1e-07   res=0.149966
XXI2\<0\>\/XI2\<0\>\/XI2\<0\>\/XI2\<1\>\/XI2\<0\>\/XI2\<0\>\/XI2\<0\>\/XI2\<0\>\/RR3 \
 (  \
 N_SEL3\<0\>_XI2\<0\>\/XI2\<0\>\/XI2\<0\>\/XI2\<1\>\/XI2\<0\>\/XI2\<0\>\/XI2\<0\>\/XI2\<0\>\/RR3_pos \
 N_WLSEL\<131\>_XI2\<0\>\/XI2\<0\>\/XI2\<0\>\/XI2\<1\>\/XI2\<0\>\/XI2\<0\>\/XI2\<0\>\/XI2\<0\>\/RR3_neg \
 ) R_1X_LL w=1e-07 l=1e-07   res=0.149966
XXI2\<0\>\/XI2\<0\>\/XI2\<0\>\/XI2\<1\>\/XI2\<0\>\/XI2\<0\>\/XI2\<0\>\/XI2\<0\>\/RR4 \
 (  \
 N_SEL4\<1\>_XI2\<0\>\/XI2\<0\>\/XI2\<0\>\/XI2\<1\>\/XI2\<0\>\/XI2\<0\>\/XI2\<0\>\/XI2\<0\>\/RR4_pos \
 N_WLSEL\<132\>_XI2\<0\>\/XI2\<0\>\/XI2\<0\>\/XI2\<1\>\/XI2\<0\>\/XI2\<0\>\/XI2\<0\>\/XI2\<0\>\/RR4_neg \
 ) R_1X_LL w=1e-07 l=1e-07   res=0.149966
XXI2\<0\>\/XI2\<0\>\/XI2\<0\>\/XI2\<1\>\/XI2\<0\>\/XI2\<0\>\/XI2\<0\>\/XI2\<0\>\/RR7 \
 (  \
 N_SEL5\<0\>_XI2\<0\>\/XI2\<0\>\/XI2\<0\>\/XI2\<1\>\/XI2\<0\>\/XI2\<0\>\/XI2\<0\>\/XI2\<0\>\/RR7_pos \
 N_WLSEL\<133\>_XI2\<0\>\/XI2\<0\>\/XI2\<0\>\/XI2\<1\>\/XI2\<0\>\/XI2\<0\>\/XI2\<0\>\/XI2\<0\>\/RR7_neg \
 ) R_1X_LL w=1e-07 l=1e-07   res=0.149966
XXI2\<0\>\/XI2\<0\>\/XI2\<0\>\/XI2\<1\>\/XI2\<0\>\/XI2\<0\>\/XI2\<0\>\/XI2\<0\>\/RR6 \
 (  \
 N_SEL6\<0\>_XI2\<0\>\/XI2\<0\>\/XI2\<0\>\/XI2\<1\>\/XI2\<0\>\/XI2\<0\>\/XI2\<0\>\/XI2\<0\>\/RR6_pos \
 N_WLSEL\<134\>_XI2\<0\>\/XI2\<0\>\/XI2\<0\>\/XI2\<1\>\/XI2\<0\>\/XI2\<0\>\/XI2\<0\>\/XI2\<0\>\/RR6_neg \
 ) R_1X_LL w=1e-07 l=1e-07   res=0.149966
XXI2\<0\>\/XI2\<0\>\/XI2\<0\>\/XI2\<1\>\/XI2\<0\>\/XI2\<0\>\/XI2\<0\>\/XI2\<0\>\/RR5 \
 (  \
 N_SEL7\<0\>_XI2\<0\>\/XI2\<0\>\/XI2\<0\>\/XI2\<1\>\/XI2\<0\>\/XI2\<0\>\/XI2\<0\>\/XI2\<0\>\/RR5_pos \
 N_WLSEL\<135\>_XI2\<0\>\/XI2\<0\>\/XI2\<0\>\/XI2\<1\>\/XI2\<0\>\/XI2\<0\>\/XI2\<0\>\/XI2\<0\>\/RR5_neg \
 ) R_1X_LL w=1e-07 l=1e-07   res=0.149966
XXI2\<0\>\/XI2\<0\>\/XI2\<0\>\/XI2\<1\>\/XI2\<0\>\/XI2\<0\>\/XI2\<0\>\/XI2\<1\>\/RR0 \
 (  \
 N_SEL0\<1\>_XI2\<0\>\/XI2\<0\>\/XI2\<0\>\/XI2\<1\>\/XI2\<0\>\/XI2\<0\>\/XI2\<0\>\/XI2\<1\>\/RR0_pos \
 N_WLSEL\<136\>_XI2\<0\>\/XI2\<0\>\/XI2\<0\>\/XI2\<1\>\/XI2\<0\>\/XI2\<0\>\/XI2\<0\>\/XI2\<1\>\/RR0_neg \
 ) R_1X_LL w=1e-07 l=1e-07   res=0.149966
XXI2\<0\>\/XI2\<0\>\/XI2\<0\>\/XI2\<1\>\/XI2\<0\>\/XI2\<0\>\/XI2\<0\>\/XI2\<1\>\/RR1 \
 (  \
 N_SEL1\<0\>_XI2\<0\>\/XI2\<0\>\/XI2\<0\>\/XI2\<1\>\/XI2\<0\>\/XI2\<0\>\/XI2\<0\>\/XI2\<1\>\/RR1_pos \
 N_WLSEL\<137\>_XI2\<0\>\/XI2\<0\>\/XI2\<0\>\/XI2\<1\>\/XI2\<0\>\/XI2\<0\>\/XI2\<0\>\/XI2\<1\>\/RR1_neg \
 ) R_1X_LL w=1e-07 l=1e-07   res=0.149966
XXI2\<0\>\/XI2\<0\>\/XI2\<0\>\/XI2\<1\>\/XI2\<0\>\/XI2\<0\>\/XI2\<0\>\/XI2\<1\>\/RR2 \
 (  \
 N_SEL2\<0\>_XI2\<0\>\/XI2\<0\>\/XI2\<0\>\/XI2\<1\>\/XI2\<0\>\/XI2\<0\>\/XI2\<0\>\/XI2\<1\>\/RR2_pos \
 N_WLSEL\<138\>_XI2\<0\>\/XI2\<0\>\/XI2\<0\>\/XI2\<1\>\/XI2\<0\>\/XI2\<0\>\/XI2\<0\>\/XI2\<1\>\/RR2_neg \
 ) R_1X_LL w=1e-07 l=1e-07   res=0.149966
XXI2\<0\>\/XI2\<0\>\/XI2\<0\>\/XI2\<1\>\/XI2\<0\>\/XI2\<0\>\/XI2\<0\>\/XI2\<1\>\/RR3 \
 (  \
 N_SEL3\<0\>_XI2\<0\>\/XI2\<0\>\/XI2\<0\>\/XI2\<1\>\/XI2\<0\>\/XI2\<0\>\/XI2\<0\>\/XI2\<1\>\/RR3_pos \
 N_WLSEL\<139\>_XI2\<0\>\/XI2\<0\>\/XI2\<0\>\/XI2\<1\>\/XI2\<0\>\/XI2\<0\>\/XI2\<0\>\/XI2\<1\>\/RR3_neg \
 ) R_1X_LL w=1e-07 l=1e-07   res=0.149966
XXI2\<0\>\/XI2\<0\>\/XI2\<0\>\/XI2\<1\>\/XI2\<0\>\/XI2\<0\>\/XI2\<0\>\/XI2\<1\>\/RR4 \
 (  \
 N_SEL4\<1\>_XI2\<0\>\/XI2\<0\>\/XI2\<0\>\/XI2\<1\>\/XI2\<0\>\/XI2\<0\>\/XI2\<0\>\/XI2\<1\>\/RR4_pos \
 N_WLSEL\<140\>_XI2\<0\>\/XI2\<0\>\/XI2\<0\>\/XI2\<1\>\/XI2\<0\>\/XI2\<0\>\/XI2\<0\>\/XI2\<1\>\/RR4_neg \
 ) R_1X_LL w=1e-07 l=1e-07   res=0.149966
XXI2\<0\>\/XI2\<0\>\/XI2\<0\>\/XI2\<1\>\/XI2\<0\>\/XI2\<0\>\/XI2\<0\>\/XI2\<1\>\/RR7 \
 (  \
 N_SEL5\<0\>_XI2\<0\>\/XI2\<0\>\/XI2\<0\>\/XI2\<1\>\/XI2\<0\>\/XI2\<0\>\/XI2\<0\>\/XI2\<1\>\/RR7_pos \
 N_WLSEL\<141\>_XI2\<0\>\/XI2\<0\>\/XI2\<0\>\/XI2\<1\>\/XI2\<0\>\/XI2\<0\>\/XI2\<0\>\/XI2\<1\>\/RR7_neg \
 ) R_1X_LL w=1e-07 l=1e-07   res=0.149966
XXI2\<0\>\/XI2\<0\>\/XI2\<0\>\/XI2\<1\>\/XI2\<0\>\/XI2\<0\>\/XI2\<0\>\/XI2\<1\>\/RR6 \
 (  \
 N_SEL6\<0\>_XI2\<0\>\/XI2\<0\>\/XI2\<0\>\/XI2\<1\>\/XI2\<0\>\/XI2\<0\>\/XI2\<0\>\/XI2\<1\>\/RR6_pos \
 N_WLSEL\<142\>_XI2\<0\>\/XI2\<0\>\/XI2\<0\>\/XI2\<1\>\/XI2\<0\>\/XI2\<0\>\/XI2\<0\>\/XI2\<1\>\/RR6_neg \
 ) R_1X_LL w=1e-07 l=1e-07   res=0.149966
XXI2\<0\>\/XI2\<0\>\/XI2\<0\>\/XI2\<1\>\/XI2\<0\>\/XI2\<0\>\/XI2\<0\>\/XI2\<1\>\/RR5 \
 (  \
 N_SEL7\<0\>_XI2\<0\>\/XI2\<0\>\/XI2\<0\>\/XI2\<1\>\/XI2\<0\>\/XI2\<0\>\/XI2\<0\>\/XI2\<1\>\/RR5_pos \
 N_WLSEL\<143\>_XI2\<0\>\/XI2\<0\>\/XI2\<0\>\/XI2\<1\>\/XI2\<0\>\/XI2\<0\>\/XI2\<0\>\/XI2\<1\>\/RR5_neg \
 ) R_1X_LL w=1e-07 l=1e-07   res=0.149966
XXI2\<0\>\/XI2\<0\>\/XI2\<0\>\/XI2\<1\>\/XI2\<0\>\/XI2\<0\>\/XI2\<1\>\/XI2\<0\>\/RR0 \
 (  \
 N_SEL0\<0\>_XI2\<0\>\/XI2\<0\>\/XI2\<0\>\/XI2\<1\>\/XI2\<0\>\/XI2\<0\>\/XI2\<1\>\/XI2\<0\>\/RR0_pos \
 N_WLSEL\<144\>_XI2\<0\>\/XI2\<0\>\/XI2\<0\>\/XI2\<1\>\/XI2\<0\>\/XI2\<0\>\/XI2\<1\>\/XI2\<0\>\/RR0_neg \
 ) R_1X_LL w=1e-07 l=1e-07   res=0.149966
XXI2\<0\>\/XI2\<0\>\/XI2\<0\>\/XI2\<1\>\/XI2\<0\>\/XI2\<0\>\/XI2\<1\>\/XI2\<0\>\/RR1 \
 (  \
 N_SEL1\<1\>_XI2\<0\>\/XI2\<0\>\/XI2\<0\>\/XI2\<1\>\/XI2\<0\>\/XI2\<0\>\/XI2\<1\>\/XI2\<0\>\/RR1_pos \
 N_WLSEL\<145\>_XI2\<0\>\/XI2\<0\>\/XI2\<0\>\/XI2\<1\>\/XI2\<0\>\/XI2\<0\>\/XI2\<1\>\/XI2\<0\>\/RR1_neg \
 ) R_1X_LL w=1e-07 l=1e-07   res=0.149966
XXI2\<0\>\/XI2\<0\>\/XI2\<0\>\/XI2\<1\>\/XI2\<0\>\/XI2\<0\>\/XI2\<1\>\/XI2\<0\>\/RR2 \
 (  \
 N_SEL2\<0\>_XI2\<0\>\/XI2\<0\>\/XI2\<0\>\/XI2\<1\>\/XI2\<0\>\/XI2\<0\>\/XI2\<1\>\/XI2\<0\>\/RR2_pos \
 N_WLSEL\<146\>_XI2\<0\>\/XI2\<0\>\/XI2\<0\>\/XI2\<1\>\/XI2\<0\>\/XI2\<0\>\/XI2\<1\>\/XI2\<0\>\/RR2_neg \
 ) R_1X_LL w=1e-07 l=1e-07   res=0.149966
XXI2\<0\>\/XI2\<0\>\/XI2\<0\>\/XI2\<1\>\/XI2\<0\>\/XI2\<0\>\/XI2\<1\>\/XI2\<0\>\/RR3 \
 (  \
 N_SEL3\<0\>_XI2\<0\>\/XI2\<0\>\/XI2\<0\>\/XI2\<1\>\/XI2\<0\>\/XI2\<0\>\/XI2\<1\>\/XI2\<0\>\/RR3_pos \
 N_WLSEL\<147\>_XI2\<0\>\/XI2\<0\>\/XI2\<0\>\/XI2\<1\>\/XI2\<0\>\/XI2\<0\>\/XI2\<1\>\/XI2\<0\>\/RR3_neg \
 ) R_1X_LL w=1e-07 l=1e-07   res=0.149966
XXI2\<0\>\/XI2\<0\>\/XI2\<0\>\/XI2\<1\>\/XI2\<0\>\/XI2\<0\>\/XI2\<1\>\/XI2\<0\>\/RR4 \
 (  \
 N_SEL4\<1\>_XI2\<0\>\/XI2\<0\>\/XI2\<0\>\/XI2\<1\>\/XI2\<0\>\/XI2\<0\>\/XI2\<1\>\/XI2\<0\>\/RR4_pos \
 N_WLSEL\<148\>_XI2\<0\>\/XI2\<0\>\/XI2\<0\>\/XI2\<1\>\/XI2\<0\>\/XI2\<0\>\/XI2\<1\>\/XI2\<0\>\/RR4_neg \
 ) R_1X_LL w=1e-07 l=1e-07   res=0.149966
XXI2\<0\>\/XI2\<0\>\/XI2\<0\>\/XI2\<1\>\/XI2\<0\>\/XI2\<0\>\/XI2\<1\>\/XI2\<0\>\/RR7 \
 (  \
 N_SEL5\<0\>_XI2\<0\>\/XI2\<0\>\/XI2\<0\>\/XI2\<1\>\/XI2\<0\>\/XI2\<0\>\/XI2\<1\>\/XI2\<0\>\/RR7_pos \
 N_WLSEL\<149\>_XI2\<0\>\/XI2\<0\>\/XI2\<0\>\/XI2\<1\>\/XI2\<0\>\/XI2\<0\>\/XI2\<1\>\/XI2\<0\>\/RR7_neg \
 ) R_1X_LL w=1e-07 l=1e-07   res=0.149966
XXI2\<0\>\/XI2\<0\>\/XI2\<0\>\/XI2\<1\>\/XI2\<0\>\/XI2\<0\>\/XI2\<1\>\/XI2\<0\>\/RR6 \
 (  \
 N_SEL6\<0\>_XI2\<0\>\/XI2\<0\>\/XI2\<0\>\/XI2\<1\>\/XI2\<0\>\/XI2\<0\>\/XI2\<1\>\/XI2\<0\>\/RR6_pos \
 N_WLSEL\<150\>_XI2\<0\>\/XI2\<0\>\/XI2\<0\>\/XI2\<1\>\/XI2\<0\>\/XI2\<0\>\/XI2\<1\>\/XI2\<0\>\/RR6_neg \
 ) R_1X_LL w=1e-07 l=1e-07   res=0.149966
XXI2\<0\>\/XI2\<0\>\/XI2\<0\>\/XI2\<1\>\/XI2\<0\>\/XI2\<0\>\/XI2\<1\>\/XI2\<0\>\/RR5 \
 (  \
 N_SEL7\<0\>_XI2\<0\>\/XI2\<0\>\/XI2\<0\>\/XI2\<1\>\/XI2\<0\>\/XI2\<0\>\/XI2\<1\>\/XI2\<0\>\/RR5_pos \
 N_WLSEL\<151\>_XI2\<0\>\/XI2\<0\>\/XI2\<0\>\/XI2\<1\>\/XI2\<0\>\/XI2\<0\>\/XI2\<1\>\/XI2\<0\>\/RR5_neg \
 ) R_1X_LL w=1e-07 l=1e-07   res=0.149966
XXI2\<0\>\/XI2\<0\>\/XI2\<0\>\/XI2\<1\>\/XI2\<0\>\/XI2\<0\>\/XI2\<1\>\/XI2\<1\>\/RR0 \
 (  \
 N_SEL0\<1\>_XI2\<0\>\/XI2\<0\>\/XI2\<0\>\/XI2\<1\>\/XI2\<0\>\/XI2\<0\>\/XI2\<1\>\/XI2\<1\>\/RR0_pos \
 N_WLSEL\<152\>_XI2\<0\>\/XI2\<0\>\/XI2\<0\>\/XI2\<1\>\/XI2\<0\>\/XI2\<0\>\/XI2\<1\>\/XI2\<1\>\/RR0_neg \
 ) R_1X_LL w=1e-07 l=1e-07   res=0.149966
XXI2\<0\>\/XI2\<0\>\/XI2\<0\>\/XI2\<1\>\/XI2\<0\>\/XI2\<0\>\/XI2\<1\>\/XI2\<1\>\/RR1 \
 (  \
 N_SEL1\<1\>_XI2\<0\>\/XI2\<0\>\/XI2\<0\>\/XI2\<1\>\/XI2\<0\>\/XI2\<0\>\/XI2\<1\>\/XI2\<1\>\/RR1_pos \
 N_WLSEL\<153\>_XI2\<0\>\/XI2\<0\>\/XI2\<0\>\/XI2\<1\>\/XI2\<0\>\/XI2\<0\>\/XI2\<1\>\/XI2\<1\>\/RR1_neg \
 ) R_1X_LL w=1e-07 l=1e-07   res=0.149966
XXI2\<0\>\/XI2\<0\>\/XI2\<0\>\/XI2\<1\>\/XI2\<0\>\/XI2\<0\>\/XI2\<1\>\/XI2\<1\>\/RR2 \
 (  \
 N_SEL2\<0\>_XI2\<0\>\/XI2\<0\>\/XI2\<0\>\/XI2\<1\>\/XI2\<0\>\/XI2\<0\>\/XI2\<1\>\/XI2\<1\>\/RR2_pos \
 N_WLSEL\<154\>_XI2\<0\>\/XI2\<0\>\/XI2\<0\>\/XI2\<1\>\/XI2\<0\>\/XI2\<0\>\/XI2\<1\>\/XI2\<1\>\/RR2_neg \
 ) R_1X_LL w=1e-07 l=1e-07   res=0.149966
XXI2\<0\>\/XI2\<0\>\/XI2\<0\>\/XI2\<1\>\/XI2\<0\>\/XI2\<0\>\/XI2\<1\>\/XI2\<1\>\/RR3 \
 (  \
 N_SEL3\<0\>_XI2\<0\>\/XI2\<0\>\/XI2\<0\>\/XI2\<1\>\/XI2\<0\>\/XI2\<0\>\/XI2\<1\>\/XI2\<1\>\/RR3_pos \
 N_WLSEL\<155\>_XI2\<0\>\/XI2\<0\>\/XI2\<0\>\/XI2\<1\>\/XI2\<0\>\/XI2\<0\>\/XI2\<1\>\/XI2\<1\>\/RR3_neg \
 ) R_1X_LL w=1e-07 l=1e-07   res=0.149966
XXI2\<0\>\/XI2\<0\>\/XI2\<0\>\/XI2\<1\>\/XI2\<0\>\/XI2\<0\>\/XI2\<1\>\/XI2\<1\>\/RR4 \
 (  \
 N_SEL4\<1\>_XI2\<0\>\/XI2\<0\>\/XI2\<0\>\/XI2\<1\>\/XI2\<0\>\/XI2\<0\>\/XI2\<1\>\/XI2\<1\>\/RR4_pos \
 N_WLSEL\<156\>_XI2\<0\>\/XI2\<0\>\/XI2\<0\>\/XI2\<1\>\/XI2\<0\>\/XI2\<0\>\/XI2\<1\>\/XI2\<1\>\/RR4_neg \
 ) R_1X_LL w=1e-07 l=1e-07   res=0.149966
XXI2\<0\>\/XI2\<0\>\/XI2\<0\>\/XI2\<1\>\/XI2\<0\>\/XI2\<0\>\/XI2\<1\>\/XI2\<1\>\/RR7 \
 (  \
 N_SEL5\<0\>_XI2\<0\>\/XI2\<0\>\/XI2\<0\>\/XI2\<1\>\/XI2\<0\>\/XI2\<0\>\/XI2\<1\>\/XI2\<1\>\/RR7_pos \
 N_WLSEL\<157\>_XI2\<0\>\/XI2\<0\>\/XI2\<0\>\/XI2\<1\>\/XI2\<0\>\/XI2\<0\>\/XI2\<1\>\/XI2\<1\>\/RR7_neg \
 ) R_1X_LL w=1e-07 l=1e-07   res=0.149966
XXI2\<0\>\/XI2\<0\>\/XI2\<0\>\/XI2\<1\>\/XI2\<0\>\/XI2\<0\>\/XI2\<1\>\/XI2\<1\>\/RR6 \
 (  \
 N_SEL6\<0\>_XI2\<0\>\/XI2\<0\>\/XI2\<0\>\/XI2\<1\>\/XI2\<0\>\/XI2\<0\>\/XI2\<1\>\/XI2\<1\>\/RR6_pos \
 N_WLSEL\<158\>_XI2\<0\>\/XI2\<0\>\/XI2\<0\>\/XI2\<1\>\/XI2\<0\>\/XI2\<0\>\/XI2\<1\>\/XI2\<1\>\/RR6_neg \
 ) R_1X_LL w=1e-07 l=1e-07   res=0.149966
XXI2\<0\>\/XI2\<0\>\/XI2\<0\>\/XI2\<1\>\/XI2\<0\>\/XI2\<0\>\/XI2\<1\>\/XI2\<1\>\/RR5 \
 (  \
 N_SEL7\<0\>_XI2\<0\>\/XI2\<0\>\/XI2\<0\>\/XI2\<1\>\/XI2\<0\>\/XI2\<0\>\/XI2\<1\>\/XI2\<1\>\/RR5_pos \
 N_WLSEL\<159\>_XI2\<0\>\/XI2\<0\>\/XI2\<0\>\/XI2\<1\>\/XI2\<0\>\/XI2\<0\>\/XI2\<1\>\/XI2\<1\>\/RR5_neg \
 ) R_1X_LL w=1e-07 l=1e-07   res=0.149966
XXI2\<0\>\/XI2\<0\>\/XI2\<0\>\/XI2\<1\>\/XI2\<0\>\/XI2\<1\>\/XI2\<0\>\/XI2\<0\>\/RR0 \
 (  \
 N_SEL0\<0\>_XI2\<0\>\/XI2\<0\>\/XI2\<0\>\/XI2\<1\>\/XI2\<0\>\/XI2\<1\>\/XI2\<0\>\/XI2\<0\>\/RR0_pos \
 N_WLSEL\<160\>_XI2\<0\>\/XI2\<0\>\/XI2\<0\>\/XI2\<1\>\/XI2\<0\>\/XI2\<1\>\/XI2\<0\>\/XI2\<0\>\/RR0_neg \
 ) R_1X_LL w=1e-07 l=1e-07   res=0.149966
XXI2\<0\>\/XI2\<0\>\/XI2\<0\>\/XI2\<1\>\/XI2\<0\>\/XI2\<1\>\/XI2\<0\>\/XI2\<0\>\/RR1 \
 (  \
 N_SEL1\<0\>_XI2\<0\>\/XI2\<0\>\/XI2\<0\>\/XI2\<1\>\/XI2\<0\>\/XI2\<1\>\/XI2\<0\>\/XI2\<0\>\/RR1_pos \
 N_WLSEL\<161\>_XI2\<0\>\/XI2\<0\>\/XI2\<0\>\/XI2\<1\>\/XI2\<0\>\/XI2\<1\>\/XI2\<0\>\/XI2\<0\>\/RR1_neg \
 ) R_1X_LL w=1e-07 l=1e-07   res=0.149966
XXI2\<0\>\/XI2\<0\>\/XI2\<0\>\/XI2\<1\>\/XI2\<0\>\/XI2\<1\>\/XI2\<0\>\/XI2\<0\>\/RR2 \
 (  \
 N_SEL2\<1\>_XI2\<0\>\/XI2\<0\>\/XI2\<0\>\/XI2\<1\>\/XI2\<0\>\/XI2\<1\>\/XI2\<0\>\/XI2\<0\>\/RR2_pos \
 N_WLSEL\<162\>_XI2\<0\>\/XI2\<0\>\/XI2\<0\>\/XI2\<1\>\/XI2\<0\>\/XI2\<1\>\/XI2\<0\>\/XI2\<0\>\/RR2_neg \
 ) R_1X_LL w=1e-07 l=1e-07   res=0.149966
XXI2\<0\>\/XI2\<0\>\/XI2\<0\>\/XI2\<1\>\/XI2\<0\>\/XI2\<1\>\/XI2\<0\>\/XI2\<0\>\/RR3 \
 (  \
 N_SEL3\<0\>_XI2\<0\>\/XI2\<0\>\/XI2\<0\>\/XI2\<1\>\/XI2\<0\>\/XI2\<1\>\/XI2\<0\>\/XI2\<0\>\/RR3_pos \
 N_WLSEL\<163\>_XI2\<0\>\/XI2\<0\>\/XI2\<0\>\/XI2\<1\>\/XI2\<0\>\/XI2\<1\>\/XI2\<0\>\/XI2\<0\>\/RR3_neg \
 ) R_1X_LL w=1e-07 l=1e-07   res=0.149966
XXI2\<0\>\/XI2\<0\>\/XI2\<0\>\/XI2\<1\>\/XI2\<0\>\/XI2\<1\>\/XI2\<0\>\/XI2\<0\>\/RR4 \
 (  \
 N_SEL4\<1\>_XI2\<0\>\/XI2\<0\>\/XI2\<0\>\/XI2\<1\>\/XI2\<0\>\/XI2\<1\>\/XI2\<0\>\/XI2\<0\>\/RR4_pos \
 N_WLSEL\<164\>_XI2\<0\>\/XI2\<0\>\/XI2\<0\>\/XI2\<1\>\/XI2\<0\>\/XI2\<1\>\/XI2\<0\>\/XI2\<0\>\/RR4_neg \
 ) R_1X_LL w=1e-07 l=1e-07   res=0.149966
XXI2\<0\>\/XI2\<0\>\/XI2\<0\>\/XI2\<1\>\/XI2\<0\>\/XI2\<1\>\/XI2\<0\>\/XI2\<0\>\/RR7 \
 (  \
 N_SEL5\<0\>_XI2\<0\>\/XI2\<0\>\/XI2\<0\>\/XI2\<1\>\/XI2\<0\>\/XI2\<1\>\/XI2\<0\>\/XI2\<0\>\/RR7_pos \
 N_WLSEL\<165\>_XI2\<0\>\/XI2\<0\>\/XI2\<0\>\/XI2\<1\>\/XI2\<0\>\/XI2\<1\>\/XI2\<0\>\/XI2\<0\>\/RR7_neg \
 ) R_1X_LL w=1e-07 l=1e-07   res=0.149966
XXI2\<0\>\/XI2\<0\>\/XI2\<0\>\/XI2\<1\>\/XI2\<0\>\/XI2\<1\>\/XI2\<0\>\/XI2\<0\>\/RR6 \
 (  \
 N_SEL6\<0\>_XI2\<0\>\/XI2\<0\>\/XI2\<0\>\/XI2\<1\>\/XI2\<0\>\/XI2\<1\>\/XI2\<0\>\/XI2\<0\>\/RR6_pos \
 N_WLSEL\<166\>_XI2\<0\>\/XI2\<0\>\/XI2\<0\>\/XI2\<1\>\/XI2\<0\>\/XI2\<1\>\/XI2\<0\>\/XI2\<0\>\/RR6_neg \
 ) R_1X_LL w=1e-07 l=1e-07   res=0.149966
XXI2\<0\>\/XI2\<0\>\/XI2\<0\>\/XI2\<1\>\/XI2\<0\>\/XI2\<1\>\/XI2\<0\>\/XI2\<0\>\/RR5 \
 (  \
 N_SEL7\<0\>_XI2\<0\>\/XI2\<0\>\/XI2\<0\>\/XI2\<1\>\/XI2\<0\>\/XI2\<1\>\/XI2\<0\>\/XI2\<0\>\/RR5_pos \
 N_WLSEL\<167\>_XI2\<0\>\/XI2\<0\>\/XI2\<0\>\/XI2\<1\>\/XI2\<0\>\/XI2\<1\>\/XI2\<0\>\/XI2\<0\>\/RR5_neg \
 ) R_1X_LL w=1e-07 l=1e-07   res=0.149966
XXI2\<0\>\/XI2\<0\>\/XI2\<0\>\/XI2\<1\>\/XI2\<0\>\/XI2\<1\>\/XI2\<0\>\/XI2\<1\>\/RR0 \
 (  \
 N_SEL0\<1\>_XI2\<0\>\/XI2\<0\>\/XI2\<0\>\/XI2\<1\>\/XI2\<0\>\/XI2\<1\>\/XI2\<0\>\/XI2\<1\>\/RR0_pos \
 N_WLSEL\<168\>_XI2\<0\>\/XI2\<0\>\/XI2\<0\>\/XI2\<1\>\/XI2\<0\>\/XI2\<1\>\/XI2\<0\>\/XI2\<1\>\/RR0_neg \
 ) R_1X_LL w=1e-07 l=1e-07   res=0.149966
XXI2\<0\>\/XI2\<0\>\/XI2\<0\>\/XI2\<1\>\/XI2\<0\>\/XI2\<1\>\/XI2\<0\>\/XI2\<1\>\/RR1 \
 (  \
 N_SEL1\<0\>_XI2\<0\>\/XI2\<0\>\/XI2\<0\>\/XI2\<1\>\/XI2\<0\>\/XI2\<1\>\/XI2\<0\>\/XI2\<1\>\/RR1_pos \
 N_WLSEL\<169\>_XI2\<0\>\/XI2\<0\>\/XI2\<0\>\/XI2\<1\>\/XI2\<0\>\/XI2\<1\>\/XI2\<0\>\/XI2\<1\>\/RR1_neg \
 ) R_1X_LL w=1e-07 l=1e-07   res=0.149966
XXI2\<0\>\/XI2\<0\>\/XI2\<0\>\/XI2\<1\>\/XI2\<0\>\/XI2\<1\>\/XI2\<0\>\/XI2\<1\>\/RR2 \
 (  \
 N_SEL2\<1\>_XI2\<0\>\/XI2\<0\>\/XI2\<0\>\/XI2\<1\>\/XI2\<0\>\/XI2\<1\>\/XI2\<0\>\/XI2\<1\>\/RR2_pos \
 N_WLSEL\<170\>_XI2\<0\>\/XI2\<0\>\/XI2\<0\>\/XI2\<1\>\/XI2\<0\>\/XI2\<1\>\/XI2\<0\>\/XI2\<1\>\/RR2_neg \
 ) R_1X_LL w=1e-07 l=1e-07   res=0.149966
XXI2\<0\>\/XI2\<0\>\/XI2\<0\>\/XI2\<1\>\/XI2\<0\>\/XI2\<1\>\/XI2\<0\>\/XI2\<1\>\/RR3 \
 (  \
 N_SEL3\<0\>_XI2\<0\>\/XI2\<0\>\/XI2\<0\>\/XI2\<1\>\/XI2\<0\>\/XI2\<1\>\/XI2\<0\>\/XI2\<1\>\/RR3_pos \
 N_WLSEL\<171\>_XI2\<0\>\/XI2\<0\>\/XI2\<0\>\/XI2\<1\>\/XI2\<0\>\/XI2\<1\>\/XI2\<0\>\/XI2\<1\>\/RR3_neg \
 ) R_1X_LL w=1e-07 l=1e-07   res=0.149966
XXI2\<0\>\/XI2\<0\>\/XI2\<0\>\/XI2\<1\>\/XI2\<0\>\/XI2\<1\>\/XI2\<0\>\/XI2\<1\>\/RR4 \
 (  \
 N_SEL4\<1\>_XI2\<0\>\/XI2\<0\>\/XI2\<0\>\/XI2\<1\>\/XI2\<0\>\/XI2\<1\>\/XI2\<0\>\/XI2\<1\>\/RR4_pos \
 N_WLSEL\<172\>_XI2\<0\>\/XI2\<0\>\/XI2\<0\>\/XI2\<1\>\/XI2\<0\>\/XI2\<1\>\/XI2\<0\>\/XI2\<1\>\/RR4_neg \
 ) R_1X_LL w=1e-07 l=1e-07   res=0.149966
XXI2\<0\>\/XI2\<0\>\/XI2\<0\>\/XI2\<1\>\/XI2\<0\>\/XI2\<1\>\/XI2\<0\>\/XI2\<1\>\/RR7 \
 (  \
 N_SEL5\<0\>_XI2\<0\>\/XI2\<0\>\/XI2\<0\>\/XI2\<1\>\/XI2\<0\>\/XI2\<1\>\/XI2\<0\>\/XI2\<1\>\/RR7_pos \
 N_WLSEL\<173\>_XI2\<0\>\/XI2\<0\>\/XI2\<0\>\/XI2\<1\>\/XI2\<0\>\/XI2\<1\>\/XI2\<0\>\/XI2\<1\>\/RR7_neg \
 ) R_1X_LL w=1e-07 l=1e-07   res=0.149966
XXI2\<0\>\/XI2\<0\>\/XI2\<0\>\/XI2\<1\>\/XI2\<0\>\/XI2\<1\>\/XI2\<0\>\/XI2\<1\>\/RR6 \
 (  \
 N_SEL6\<0\>_XI2\<0\>\/XI2\<0\>\/XI2\<0\>\/XI2\<1\>\/XI2\<0\>\/XI2\<1\>\/XI2\<0\>\/XI2\<1\>\/RR6_pos \
 N_WLSEL\<174\>_XI2\<0\>\/XI2\<0\>\/XI2\<0\>\/XI2\<1\>\/XI2\<0\>\/XI2\<1\>\/XI2\<0\>\/XI2\<1\>\/RR6_neg \
 ) R_1X_LL w=1e-07 l=1e-07   res=0.149966
XXI2\<0\>\/XI2\<0\>\/XI2\<0\>\/XI2\<1\>\/XI2\<0\>\/XI2\<1\>\/XI2\<0\>\/XI2\<1\>\/RR5 \
 (  \
 N_SEL7\<0\>_XI2\<0\>\/XI2\<0\>\/XI2\<0\>\/XI2\<1\>\/XI2\<0\>\/XI2\<1\>\/XI2\<0\>\/XI2\<1\>\/RR5_pos \
 N_WLSEL\<175\>_XI2\<0\>\/XI2\<0\>\/XI2\<0\>\/XI2\<1\>\/XI2\<0\>\/XI2\<1\>\/XI2\<0\>\/XI2\<1\>\/RR5_neg \
 ) R_1X_LL w=1e-07 l=1e-07   res=0.149966
XXI2\<0\>\/XI2\<0\>\/XI2\<0\>\/XI2\<1\>\/XI2\<0\>\/XI2\<1\>\/XI2\<1\>\/XI2\<0\>\/RR0 \
 (  \
 N_SEL0\<0\>_XI2\<0\>\/XI2\<0\>\/XI2\<0\>\/XI2\<1\>\/XI2\<0\>\/XI2\<1\>\/XI2\<1\>\/XI2\<0\>\/RR0_pos \
 N_WLSEL\<176\>_XI2\<0\>\/XI2\<0\>\/XI2\<0\>\/XI2\<1\>\/XI2\<0\>\/XI2\<1\>\/XI2\<1\>\/XI2\<0\>\/RR0_neg \
 ) R_1X_LL w=1e-07 l=1e-07   res=0.149966
XXI2\<0\>\/XI2\<0\>\/XI2\<0\>\/XI2\<1\>\/XI2\<0\>\/XI2\<1\>\/XI2\<1\>\/XI2\<0\>\/RR1 \
 (  \
 N_SEL1\<1\>_XI2\<0\>\/XI2\<0\>\/XI2\<0\>\/XI2\<1\>\/XI2\<0\>\/XI2\<1\>\/XI2\<1\>\/XI2\<0\>\/RR1_pos \
 N_WLSEL\<177\>_XI2\<0\>\/XI2\<0\>\/XI2\<0\>\/XI2\<1\>\/XI2\<0\>\/XI2\<1\>\/XI2\<1\>\/XI2\<0\>\/RR1_neg \
 ) R_1X_LL w=1e-07 l=1e-07   res=0.149966
XXI2\<0\>\/XI2\<0\>\/XI2\<0\>\/XI2\<1\>\/XI2\<0\>\/XI2\<1\>\/XI2\<1\>\/XI2\<0\>\/RR2 \
 (  \
 N_SEL2\<1\>_XI2\<0\>\/XI2\<0\>\/XI2\<0\>\/XI2\<1\>\/XI2\<0\>\/XI2\<1\>\/XI2\<1\>\/XI2\<0\>\/RR2_pos \
 N_WLSEL\<178\>_XI2\<0\>\/XI2\<0\>\/XI2\<0\>\/XI2\<1\>\/XI2\<0\>\/XI2\<1\>\/XI2\<1\>\/XI2\<0\>\/RR2_neg \
 ) R_1X_LL w=1e-07 l=1e-07   res=0.149966
XXI2\<0\>\/XI2\<0\>\/XI2\<0\>\/XI2\<1\>\/XI2\<0\>\/XI2\<1\>\/XI2\<1\>\/XI2\<0\>\/RR3 \
 (  \
 N_SEL3\<0\>_XI2\<0\>\/XI2\<0\>\/XI2\<0\>\/XI2\<1\>\/XI2\<0\>\/XI2\<1\>\/XI2\<1\>\/XI2\<0\>\/RR3_pos \
 N_WLSEL\<179\>_XI2\<0\>\/XI2\<0\>\/XI2\<0\>\/XI2\<1\>\/XI2\<0\>\/XI2\<1\>\/XI2\<1\>\/XI2\<0\>\/RR3_neg \
 ) R_1X_LL w=1e-07 l=1e-07   res=0.149966
XXI2\<0\>\/XI2\<0\>\/XI2\<0\>\/XI2\<1\>\/XI2\<0\>\/XI2\<1\>\/XI2\<1\>\/XI2\<0\>\/RR4 \
 (  \
 N_SEL4\<1\>_XI2\<0\>\/XI2\<0\>\/XI2\<0\>\/XI2\<1\>\/XI2\<0\>\/XI2\<1\>\/XI2\<1\>\/XI2\<0\>\/RR4_pos \
 N_WLSEL\<180\>_XI2\<0\>\/XI2\<0\>\/XI2\<0\>\/XI2\<1\>\/XI2\<0\>\/XI2\<1\>\/XI2\<1\>\/XI2\<0\>\/RR4_neg \
 ) R_1X_LL w=1e-07 l=1e-07   res=0.149966
XXI2\<0\>\/XI2\<0\>\/XI2\<0\>\/XI2\<1\>\/XI2\<0\>\/XI2\<1\>\/XI2\<1\>\/XI2\<0\>\/RR7 \
 (  \
 N_SEL5\<0\>_XI2\<0\>\/XI2\<0\>\/XI2\<0\>\/XI2\<1\>\/XI2\<0\>\/XI2\<1\>\/XI2\<1\>\/XI2\<0\>\/RR7_pos \
 N_WLSEL\<181\>_XI2\<0\>\/XI2\<0\>\/XI2\<0\>\/XI2\<1\>\/XI2\<0\>\/XI2\<1\>\/XI2\<1\>\/XI2\<0\>\/RR7_neg \
 ) R_1X_LL w=1e-07 l=1e-07   res=0.149966
XXI2\<0\>\/XI2\<0\>\/XI2\<0\>\/XI2\<1\>\/XI2\<0\>\/XI2\<1\>\/XI2\<1\>\/XI2\<0\>\/RR6 \
 (  \
 N_SEL6\<0\>_XI2\<0\>\/XI2\<0\>\/XI2\<0\>\/XI2\<1\>\/XI2\<0\>\/XI2\<1\>\/XI2\<1\>\/XI2\<0\>\/RR6_pos \
 N_WLSEL\<182\>_XI2\<0\>\/XI2\<0\>\/XI2\<0\>\/XI2\<1\>\/XI2\<0\>\/XI2\<1\>\/XI2\<1\>\/XI2\<0\>\/RR6_neg \
 ) R_1X_LL w=1e-07 l=1e-07   res=0.149966
XXI2\<0\>\/XI2\<0\>\/XI2\<0\>\/XI2\<1\>\/XI2\<0\>\/XI2\<1\>\/XI2\<1\>\/XI2\<0\>\/RR5 \
 (  \
 N_SEL7\<0\>_XI2\<0\>\/XI2\<0\>\/XI2\<0\>\/XI2\<1\>\/XI2\<0\>\/XI2\<1\>\/XI2\<1\>\/XI2\<0\>\/RR5_pos \
 N_WLSEL\<183\>_XI2\<0\>\/XI2\<0\>\/XI2\<0\>\/XI2\<1\>\/XI2\<0\>\/XI2\<1\>\/XI2\<1\>\/XI2\<0\>\/RR5_neg \
 ) R_1X_LL w=1e-07 l=1e-07   res=0.149966
XXI2\<0\>\/XI2\<0\>\/XI2\<0\>\/XI2\<1\>\/XI2\<0\>\/XI2\<1\>\/XI2\<1\>\/XI2\<1\>\/RR0 \
 (  \
 N_SEL0\<1\>_XI2\<0\>\/XI2\<0\>\/XI2\<0\>\/XI2\<1\>\/XI2\<0\>\/XI2\<1\>\/XI2\<1\>\/XI2\<1\>\/RR0_pos \
 N_WLSEL\<184\>_XI2\<0\>\/XI2\<0\>\/XI2\<0\>\/XI2\<1\>\/XI2\<0\>\/XI2\<1\>\/XI2\<1\>\/XI2\<1\>\/RR0_neg \
 ) R_1X_LL w=1e-07 l=1e-07   res=0.149966
XXI2\<0\>\/XI2\<0\>\/XI2\<0\>\/XI2\<1\>\/XI2\<0\>\/XI2\<1\>\/XI2\<1\>\/XI2\<1\>\/RR1 \
 (  \
 N_SEL1\<1\>_XI2\<0\>\/XI2\<0\>\/XI2\<0\>\/XI2\<1\>\/XI2\<0\>\/XI2\<1\>\/XI2\<1\>\/XI2\<1\>\/RR1_pos \
 N_WLSEL\<185\>_XI2\<0\>\/XI2\<0\>\/XI2\<0\>\/XI2\<1\>\/XI2\<0\>\/XI2\<1\>\/XI2\<1\>\/XI2\<1\>\/RR1_neg \
 ) R_1X_LL w=1e-07 l=1e-07   res=0.149966
XXI2\<0\>\/XI2\<0\>\/XI2\<0\>\/XI2\<1\>\/XI2\<0\>\/XI2\<1\>\/XI2\<1\>\/XI2\<1\>\/RR2 \
 (  \
 N_SEL2\<1\>_XI2\<0\>\/XI2\<0\>\/XI2\<0\>\/XI2\<1\>\/XI2\<0\>\/XI2\<1\>\/XI2\<1\>\/XI2\<1\>\/RR2_pos \
 N_WLSEL\<186\>_XI2\<0\>\/XI2\<0\>\/XI2\<0\>\/XI2\<1\>\/XI2\<0\>\/XI2\<1\>\/XI2\<1\>\/XI2\<1\>\/RR2_neg \
 ) R_1X_LL w=1e-07 l=1e-07   res=0.149966
XXI2\<0\>\/XI2\<0\>\/XI2\<0\>\/XI2\<1\>\/XI2\<0\>\/XI2\<1\>\/XI2\<1\>\/XI2\<1\>\/RR3 \
 (  \
 N_SEL3\<0\>_XI2\<0\>\/XI2\<0\>\/XI2\<0\>\/XI2\<1\>\/XI2\<0\>\/XI2\<1\>\/XI2\<1\>\/XI2\<1\>\/RR3_pos \
 N_WLSEL\<187\>_XI2\<0\>\/XI2\<0\>\/XI2\<0\>\/XI2\<1\>\/XI2\<0\>\/XI2\<1\>\/XI2\<1\>\/XI2\<1\>\/RR3_neg \
 ) R_1X_LL w=1e-07 l=1e-07   res=0.149966
XXI2\<0\>\/XI2\<0\>\/XI2\<0\>\/XI2\<1\>\/XI2\<0\>\/XI2\<1\>\/XI2\<1\>\/XI2\<1\>\/RR4 \
 (  \
 N_SEL4\<1\>_XI2\<0\>\/XI2\<0\>\/XI2\<0\>\/XI2\<1\>\/XI2\<0\>\/XI2\<1\>\/XI2\<1\>\/XI2\<1\>\/RR4_pos \
 N_WLSEL\<188\>_XI2\<0\>\/XI2\<0\>\/XI2\<0\>\/XI2\<1\>\/XI2\<0\>\/XI2\<1\>\/XI2\<1\>\/XI2\<1\>\/RR4_neg \
 ) R_1X_LL w=1e-07 l=1e-07   res=0.149966
XXI2\<0\>\/XI2\<0\>\/XI2\<0\>\/XI2\<1\>\/XI2\<0\>\/XI2\<1\>\/XI2\<1\>\/XI2\<1\>\/RR7 \
 (  \
 N_SEL5\<0\>_XI2\<0\>\/XI2\<0\>\/XI2\<0\>\/XI2\<1\>\/XI2\<0\>\/XI2\<1\>\/XI2\<1\>\/XI2\<1\>\/RR7_pos \
 N_WLSEL\<189\>_XI2\<0\>\/XI2\<0\>\/XI2\<0\>\/XI2\<1\>\/XI2\<0\>\/XI2\<1\>\/XI2\<1\>\/XI2\<1\>\/RR7_neg \
 ) R_1X_LL w=1e-07 l=1e-07   res=0.149966
XXI2\<1\>\/XI2\<1\>\/XI2\<0\>\/XI2\<0\>\/XI2\<0\>\/XI2\<0\>\/XI2\<1\>\/XI2\<1\>\/RR7 \
 (  \
 N_SEL5\<0\>_XI2\<1\>\/XI2\<1\>\/XI2\<0\>\/XI2\<0\>\/XI2\<0\>\/XI2\<0\>\/XI2\<1\>\/XI2\<1\>\/RR7_pos \
 N_WLSEL\<1565\>_XI2\<1\>\/XI2\<1\>\/XI2\<0\>\/XI2\<0\>\/XI2\<0\>\/XI2\<0\>\/XI2\<1\>\/XI2\<1\>\/RR7_neg \
 ) R_1X_LL w=1e-07 l=1e-07   res=0.149966
XXI2\<1\>\/XI2\<1\>\/XI2\<0\>\/XI2\<0\>\/XI2\<0\>\/XI2\<0\>\/XI2\<1\>\/XI2\<1\>\/RR6 \
 (  \
 N_SEL6\<1\>_XI2\<1\>\/XI2\<1\>\/XI2\<0\>\/XI2\<0\>\/XI2\<0\>\/XI2\<0\>\/XI2\<1\>\/XI2\<1\>\/RR6_pos \
 N_WLSEL\<1566\>_XI2\<1\>\/XI2\<1\>\/XI2\<0\>\/XI2\<0\>\/XI2\<0\>\/XI2\<0\>\/XI2\<1\>\/XI2\<1\>\/RR6_neg \
 ) R_1X_LL w=1e-07 l=1e-07   res=0.149966
XXI2\<1\>\/XI2\<1\>\/XI2\<0\>\/XI2\<0\>\/XI2\<0\>\/XI2\<0\>\/XI2\<1\>\/XI2\<1\>\/RR5 \
 (  \
 N_SEL7\<1\>_XI2\<1\>\/XI2\<1\>\/XI2\<0\>\/XI2\<0\>\/XI2\<0\>\/XI2\<0\>\/XI2\<1\>\/XI2\<1\>\/RR5_pos \
 N_WLSEL\<1567\>_XI2\<1\>\/XI2\<1\>\/XI2\<0\>\/XI2\<0\>\/XI2\<0\>\/XI2\<0\>\/XI2\<1\>\/XI2\<1\>\/RR5_neg \
 ) R_1X_LL w=1e-07 l=1e-07   res=0.149966
XXI2\<1\>\/XI2\<1\>\/XI2\<0\>\/XI2\<0\>\/XI2\<0\>\/XI2\<1\>\/XI2\<0\>\/XI2\<0\>\/RR0 \
 (  \
 N_SEL0\<0\>_XI2\<1\>\/XI2\<1\>\/XI2\<0\>\/XI2\<0\>\/XI2\<0\>\/XI2\<1\>\/XI2\<0\>\/XI2\<0\>\/RR0_pos \
 N_WLSEL\<1568\>_XI2\<1\>\/XI2\<1\>\/XI2\<0\>\/XI2\<0\>\/XI2\<0\>\/XI2\<1\>\/XI2\<0\>\/XI2\<0\>\/RR0_neg \
 ) R_1X_LL w=1e-07 l=1e-07   res=0.149966
XXI2\<1\>\/XI2\<1\>\/XI2\<0\>\/XI2\<0\>\/XI2\<0\>\/XI2\<1\>\/XI2\<0\>\/XI2\<0\>\/RR1 \
 (  \
 N_SEL1\<0\>_XI2\<1\>\/XI2\<1\>\/XI2\<0\>\/XI2\<0\>\/XI2\<0\>\/XI2\<1\>\/XI2\<0\>\/XI2\<0\>\/RR1_pos \
 N_WLSEL\<1569\>_XI2\<1\>\/XI2\<1\>\/XI2\<0\>\/XI2\<0\>\/XI2\<0\>\/XI2\<1\>\/XI2\<0\>\/XI2\<0\>\/RR1_neg \
 ) R_1X_LL w=1e-07 l=1e-07   res=0.149966
XXI2\<1\>\/XI2\<1\>\/XI2\<0\>\/XI2\<0\>\/XI2\<0\>\/XI2\<1\>\/XI2\<0\>\/XI2\<0\>\/RR2 \
 (  \
 N_SEL2\<1\>_XI2\<1\>\/XI2\<1\>\/XI2\<0\>\/XI2\<0\>\/XI2\<0\>\/XI2\<1\>\/XI2\<0\>\/XI2\<0\>\/RR2_pos \
 N_WLSEL\<1570\>_XI2\<1\>\/XI2\<1\>\/XI2\<0\>\/XI2\<0\>\/XI2\<0\>\/XI2\<1\>\/XI2\<0\>\/XI2\<0\>\/RR2_neg \
 ) R_1X_LL w=1e-07 l=1e-07   res=0.149966
XXI2\<1\>\/XI2\<1\>\/XI2\<0\>\/XI2\<0\>\/XI2\<0\>\/XI2\<1\>\/XI2\<0\>\/XI2\<0\>\/RR3 \
 (  \
 N_SEL3\<0\>_XI2\<1\>\/XI2\<1\>\/XI2\<0\>\/XI2\<0\>\/XI2\<0\>\/XI2\<1\>\/XI2\<0\>\/XI2\<0\>\/RR3_pos \
 N_WLSEL\<1571\>_XI2\<1\>\/XI2\<1\>\/XI2\<0\>\/XI2\<0\>\/XI2\<0\>\/XI2\<1\>\/XI2\<0\>\/XI2\<0\>\/RR3_neg \
 ) R_1X_LL w=1e-07 l=1e-07   res=0.149966
XXI2\<1\>\/XI2\<1\>\/XI2\<0\>\/XI2\<0\>\/XI2\<0\>\/XI2\<1\>\/XI2\<0\>\/XI2\<0\>\/RR4 \
 (  \
 N_SEL4\<0\>_XI2\<1\>\/XI2\<1\>\/XI2\<0\>\/XI2\<0\>\/XI2\<0\>\/XI2\<1\>\/XI2\<0\>\/XI2\<0\>\/RR4_pos \
 N_WLSEL\<1572\>_XI2\<1\>\/XI2\<1\>\/XI2\<0\>\/XI2\<0\>\/XI2\<0\>\/XI2\<1\>\/XI2\<0\>\/XI2\<0\>\/RR4_neg \
 ) R_1X_LL w=1e-07 l=1e-07   res=0.149966
XXI2\<1\>\/XI2\<1\>\/XI2\<0\>\/XI2\<0\>\/XI2\<0\>\/XI2\<1\>\/XI2\<0\>\/XI2\<0\>\/RR7 \
 (  \
 N_SEL5\<0\>_XI2\<1\>\/XI2\<1\>\/XI2\<0\>\/XI2\<0\>\/XI2\<0\>\/XI2\<1\>\/XI2\<0\>\/XI2\<0\>\/RR7_pos \
 N_WLSEL\<1573\>_XI2\<1\>\/XI2\<1\>\/XI2\<0\>\/XI2\<0\>\/XI2\<0\>\/XI2\<1\>\/XI2\<0\>\/XI2\<0\>\/RR7_neg \
 ) R_1X_LL w=1e-07 l=1e-07   res=0.149966
XXI2\<1\>\/XI2\<1\>\/XI2\<0\>\/XI2\<0\>\/XI2\<0\>\/XI2\<1\>\/XI2\<0\>\/XI2\<0\>\/RR6 \
 (  \
 N_SEL6\<1\>_XI2\<1\>\/XI2\<1\>\/XI2\<0\>\/XI2\<0\>\/XI2\<0\>\/XI2\<1\>\/XI2\<0\>\/XI2\<0\>\/RR6_pos \
 N_WLSEL\<1574\>_XI2\<1\>\/XI2\<1\>\/XI2\<0\>\/XI2\<0\>\/XI2\<0\>\/XI2\<1\>\/XI2\<0\>\/XI2\<0\>\/RR6_neg \
 ) R_1X_LL w=1e-07 l=1e-07   res=0.149966
XXI2\<1\>\/XI2\<1\>\/XI2\<0\>\/XI2\<0\>\/XI2\<0\>\/XI2\<1\>\/XI2\<0\>\/XI2\<0\>\/RR5 \
 (  \
 N_SEL7\<1\>_XI2\<1\>\/XI2\<1\>\/XI2\<0\>\/XI2\<0\>\/XI2\<0\>\/XI2\<1\>\/XI2\<0\>\/XI2\<0\>\/RR5_pos \
 N_WLSEL\<1575\>_XI2\<1\>\/XI2\<1\>\/XI2\<0\>\/XI2\<0\>\/XI2\<0\>\/XI2\<1\>\/XI2\<0\>\/XI2\<0\>\/RR5_neg \
 ) R_1X_LL w=1e-07 l=1e-07   res=0.149966
XXI2\<1\>\/XI2\<1\>\/XI2\<0\>\/XI2\<0\>\/XI2\<0\>\/XI2\<1\>\/XI2\<0\>\/XI2\<1\>\/RR0 \
 (  \
 N_SEL0\<1\>_XI2\<1\>\/XI2\<1\>\/XI2\<0\>\/XI2\<0\>\/XI2\<0\>\/XI2\<1\>\/XI2\<0\>\/XI2\<1\>\/RR0_pos \
 N_WLSEL\<1576\>_XI2\<1\>\/XI2\<1\>\/XI2\<0\>\/XI2\<0\>\/XI2\<0\>\/XI2\<1\>\/XI2\<0\>\/XI2\<1\>\/RR0_neg \
 ) R_1X_LL w=1e-07 l=1e-07   res=0.149966
XXI2\<1\>\/XI2\<1\>\/XI2\<0\>\/XI2\<0\>\/XI2\<0\>\/XI2\<1\>\/XI2\<0\>\/XI2\<1\>\/RR1 \
 (  \
 N_SEL1\<0\>_XI2\<1\>\/XI2\<1\>\/XI2\<0\>\/XI2\<0\>\/XI2\<0\>\/XI2\<1\>\/XI2\<0\>\/XI2\<1\>\/RR1_pos \
 N_WLSEL\<1577\>_XI2\<1\>\/XI2\<1\>\/XI2\<0\>\/XI2\<0\>\/XI2\<0\>\/XI2\<1\>\/XI2\<0\>\/XI2\<1\>\/RR1_neg \
 ) R_1X_LL w=1e-07 l=1e-07   res=0.149966
XXI2\<1\>\/XI2\<1\>\/XI2\<0\>\/XI2\<0\>\/XI2\<0\>\/XI2\<1\>\/XI2\<0\>\/XI2\<1\>\/RR2 \
 (  \
 N_SEL2\<1\>_XI2\<1\>\/XI2\<1\>\/XI2\<0\>\/XI2\<0\>\/XI2\<0\>\/XI2\<1\>\/XI2\<0\>\/XI2\<1\>\/RR2_pos \
 N_WLSEL\<1578\>_XI2\<1\>\/XI2\<1\>\/XI2\<0\>\/XI2\<0\>\/XI2\<0\>\/XI2\<1\>\/XI2\<0\>\/XI2\<1\>\/RR2_neg \
 ) R_1X_LL w=1e-07 l=1e-07   res=0.149966
XXI2\<1\>\/XI2\<1\>\/XI2\<0\>\/XI2\<0\>\/XI2\<0\>\/XI2\<1\>\/XI2\<0\>\/XI2\<1\>\/RR3 \
 (  \
 N_SEL3\<0\>_XI2\<1\>\/XI2\<1\>\/XI2\<0\>\/XI2\<0\>\/XI2\<0\>\/XI2\<1\>\/XI2\<0\>\/XI2\<1\>\/RR3_pos \
 N_WLSEL\<1579\>_XI2\<1\>\/XI2\<1\>\/XI2\<0\>\/XI2\<0\>\/XI2\<0\>\/XI2\<1\>\/XI2\<0\>\/XI2\<1\>\/RR3_neg \
 ) R_1X_LL w=1e-07 l=1e-07   res=0.149966
XXI2\<1\>\/XI2\<1\>\/XI2\<0\>\/XI2\<0\>\/XI2\<0\>\/XI2\<1\>\/XI2\<0\>\/XI2\<1\>\/RR4 \
 (  \
 N_SEL4\<0\>_XI2\<1\>\/XI2\<1\>\/XI2\<0\>\/XI2\<0\>\/XI2\<0\>\/XI2\<1\>\/XI2\<0\>\/XI2\<1\>\/RR4_pos \
 N_WLSEL\<1580\>_XI2\<1\>\/XI2\<1\>\/XI2\<0\>\/XI2\<0\>\/XI2\<0\>\/XI2\<1\>\/XI2\<0\>\/XI2\<1\>\/RR4_neg \
 ) R_1X_LL w=1e-07 l=1e-07   res=0.149966
XXI2\<1\>\/XI2\<1\>\/XI2\<0\>\/XI2\<0\>\/XI2\<0\>\/XI2\<1\>\/XI2\<0\>\/XI2\<1\>\/RR7 \
 (  \
 N_SEL5\<0\>_XI2\<1\>\/XI2\<1\>\/XI2\<0\>\/XI2\<0\>\/XI2\<0\>\/XI2\<1\>\/XI2\<0\>\/XI2\<1\>\/RR7_pos \
 N_WLSEL\<1581\>_XI2\<1\>\/XI2\<1\>\/XI2\<0\>\/XI2\<0\>\/XI2\<0\>\/XI2\<1\>\/XI2\<0\>\/XI2\<1\>\/RR7_neg \
 ) R_1X_LL w=1e-07 l=1e-07   res=0.149966
XXI2\<1\>\/XI2\<1\>\/XI2\<0\>\/XI2\<0\>\/XI2\<0\>\/XI2\<1\>\/XI2\<0\>\/XI2\<1\>\/RR6 \
 (  \
 N_SEL6\<1\>_XI2\<1\>\/XI2\<1\>\/XI2\<0\>\/XI2\<0\>\/XI2\<0\>\/XI2\<1\>\/XI2\<0\>\/XI2\<1\>\/RR6_pos \
 N_WLSEL\<1582\>_XI2\<1\>\/XI2\<1\>\/XI2\<0\>\/XI2\<0\>\/XI2\<0\>\/XI2\<1\>\/XI2\<0\>\/XI2\<1\>\/RR6_neg \
 ) R_1X_LL w=1e-07 l=1e-07   res=0.149966
XXI2\<1\>\/XI2\<1\>\/XI2\<0\>\/XI2\<0\>\/XI2\<0\>\/XI2\<1\>\/XI2\<0\>\/XI2\<1\>\/RR5 \
 (  \
 N_SEL7\<1\>_XI2\<1\>\/XI2\<1\>\/XI2\<0\>\/XI2\<0\>\/XI2\<0\>\/XI2\<1\>\/XI2\<0\>\/XI2\<1\>\/RR5_pos \
 N_WLSEL\<1583\>_XI2\<1\>\/XI2\<1\>\/XI2\<0\>\/XI2\<0\>\/XI2\<0\>\/XI2\<1\>\/XI2\<0\>\/XI2\<1\>\/RR5_neg \
 ) R_1X_LL w=1e-07 l=1e-07   res=0.149966
XXI2\<1\>\/XI2\<1\>\/XI2\<0\>\/XI2\<0\>\/XI2\<0\>\/XI2\<1\>\/XI2\<1\>\/XI2\<0\>\/RR0 \
 (  \
 N_SEL0\<0\>_XI2\<1\>\/XI2\<1\>\/XI2\<0\>\/XI2\<0\>\/XI2\<0\>\/XI2\<1\>\/XI2\<1\>\/XI2\<0\>\/RR0_pos \
 N_WLSEL\<1584\>_XI2\<1\>\/XI2\<1\>\/XI2\<0\>\/XI2\<0\>\/XI2\<0\>\/XI2\<1\>\/XI2\<1\>\/XI2\<0\>\/RR0_neg \
 ) R_1X_LL w=1e-07 l=1e-07   res=0.149966
XXI2\<1\>\/XI2\<1\>\/XI2\<0\>\/XI2\<0\>\/XI2\<0\>\/XI2\<1\>\/XI2\<1\>\/XI2\<0\>\/RR1 \
 (  \
 N_SEL1\<1\>_XI2\<1\>\/XI2\<1\>\/XI2\<0\>\/XI2\<0\>\/XI2\<0\>\/XI2\<1\>\/XI2\<1\>\/XI2\<0\>\/RR1_pos \
 N_WLSEL\<1585\>_XI2\<1\>\/XI2\<1\>\/XI2\<0\>\/XI2\<0\>\/XI2\<0\>\/XI2\<1\>\/XI2\<1\>\/XI2\<0\>\/RR1_neg \
 ) R_1X_LL w=1e-07 l=1e-07   res=0.149966
XXI2\<1\>\/XI2\<1\>\/XI2\<0\>\/XI2\<0\>\/XI2\<0\>\/XI2\<1\>\/XI2\<1\>\/XI2\<0\>\/RR2 \
 (  \
 N_SEL2\<1\>_XI2\<1\>\/XI2\<1\>\/XI2\<0\>\/XI2\<0\>\/XI2\<0\>\/XI2\<1\>\/XI2\<1\>\/XI2\<0\>\/RR2_pos \
 N_WLSEL\<1586\>_XI2\<1\>\/XI2\<1\>\/XI2\<0\>\/XI2\<0\>\/XI2\<0\>\/XI2\<1\>\/XI2\<1\>\/XI2\<0\>\/RR2_neg \
 ) R_1X_LL w=1e-07 l=1e-07   res=0.149966
XXI2\<1\>\/XI2\<1\>\/XI2\<0\>\/XI2\<0\>\/XI2\<0\>\/XI2\<1\>\/XI2\<1\>\/XI2\<0\>\/RR3 \
 (  \
 N_SEL3\<0\>_XI2\<1\>\/XI2\<1\>\/XI2\<0\>\/XI2\<0\>\/XI2\<0\>\/XI2\<1\>\/XI2\<1\>\/XI2\<0\>\/RR3_pos \
 N_WLSEL\<1587\>_XI2\<1\>\/XI2\<1\>\/XI2\<0\>\/XI2\<0\>\/XI2\<0\>\/XI2\<1\>\/XI2\<1\>\/XI2\<0\>\/RR3_neg \
 ) R_1X_LL w=1e-07 l=1e-07   res=0.149966
XXI2\<1\>\/XI2\<1\>\/XI2\<0\>\/XI2\<0\>\/XI2\<0\>\/XI2\<1\>\/XI2\<1\>\/XI2\<0\>\/RR4 \
 (  \
 N_SEL4\<0\>_XI2\<1\>\/XI2\<1\>\/XI2\<0\>\/XI2\<0\>\/XI2\<0\>\/XI2\<1\>\/XI2\<1\>\/XI2\<0\>\/RR4_pos \
 N_WLSEL\<1588\>_XI2\<1\>\/XI2\<1\>\/XI2\<0\>\/XI2\<0\>\/XI2\<0\>\/XI2\<1\>\/XI2\<1\>\/XI2\<0\>\/RR4_neg \
 ) R_1X_LL w=1e-07 l=1e-07   res=0.149966
XXI2\<1\>\/XI2\<1\>\/XI2\<0\>\/XI2\<0\>\/XI2\<0\>\/XI2\<1\>\/XI2\<1\>\/XI2\<0\>\/RR7 \
 (  \
 N_SEL5\<0\>_XI2\<1\>\/XI2\<1\>\/XI2\<0\>\/XI2\<0\>\/XI2\<0\>\/XI2\<1\>\/XI2\<1\>\/XI2\<0\>\/RR7_pos \
 N_WLSEL\<1589\>_XI2\<1\>\/XI2\<1\>\/XI2\<0\>\/XI2\<0\>\/XI2\<0\>\/XI2\<1\>\/XI2\<1\>\/XI2\<0\>\/RR7_neg \
 ) R_1X_LL w=1e-07 l=1e-07   res=0.149966
XXI2\<1\>\/XI2\<1\>\/XI2\<0\>\/XI2\<0\>\/XI2\<0\>\/XI2\<1\>\/XI2\<1\>\/XI2\<0\>\/RR6 \
 (  \
 N_SEL6\<1\>_XI2\<1\>\/XI2\<1\>\/XI2\<0\>\/XI2\<0\>\/XI2\<0\>\/XI2\<1\>\/XI2\<1\>\/XI2\<0\>\/RR6_pos \
 N_WLSEL\<1590\>_XI2\<1\>\/XI2\<1\>\/XI2\<0\>\/XI2\<0\>\/XI2\<0\>\/XI2\<1\>\/XI2\<1\>\/XI2\<0\>\/RR6_neg \
 ) R_1X_LL w=1e-07 l=1e-07   res=0.149966
XXI2\<1\>\/XI2\<1\>\/XI2\<0\>\/XI2\<0\>\/XI2\<0\>\/XI2\<1\>\/XI2\<1\>\/XI2\<0\>\/RR5 \
 (  \
 N_SEL7\<1\>_XI2\<1\>\/XI2\<1\>\/XI2\<0\>\/XI2\<0\>\/XI2\<0\>\/XI2\<1\>\/XI2\<1\>\/XI2\<0\>\/RR5_pos \
 N_WLSEL\<1591\>_XI2\<1\>\/XI2\<1\>\/XI2\<0\>\/XI2\<0\>\/XI2\<0\>\/XI2\<1\>\/XI2\<1\>\/XI2\<0\>\/RR5_neg \
 ) R_1X_LL w=1e-07 l=1e-07   res=0.149966
XXI2\<1\>\/XI2\<1\>\/XI2\<0\>\/XI2\<0\>\/XI2\<0\>\/XI2\<1\>\/XI2\<1\>\/XI2\<1\>\/RR0 \
 (  \
 N_SEL0\<1\>_XI2\<1\>\/XI2\<1\>\/XI2\<0\>\/XI2\<0\>\/XI2\<0\>\/XI2\<1\>\/XI2\<1\>\/XI2\<1\>\/RR0_pos \
 N_WLSEL\<1592\>_XI2\<1\>\/XI2\<1\>\/XI2\<0\>\/XI2\<0\>\/XI2\<0\>\/XI2\<1\>\/XI2\<1\>\/XI2\<1\>\/RR0_neg \
 ) R_1X_LL w=1e-07 l=1e-07   res=0.149966
XXI2\<1\>\/XI2\<1\>\/XI2\<0\>\/XI2\<0\>\/XI2\<0\>\/XI2\<1\>\/XI2\<1\>\/XI2\<1\>\/RR1 \
 (  \
 N_SEL1\<1\>_XI2\<1\>\/XI2\<1\>\/XI2\<0\>\/XI2\<0\>\/XI2\<0\>\/XI2\<1\>\/XI2\<1\>\/XI2\<1\>\/RR1_pos \
 N_WLSEL\<1593\>_XI2\<1\>\/XI2\<1\>\/XI2\<0\>\/XI2\<0\>\/XI2\<0\>\/XI2\<1\>\/XI2\<1\>\/XI2\<1\>\/RR1_neg \
 ) R_1X_LL w=1e-07 l=1e-07   res=0.149966
XXI2\<1\>\/XI2\<1\>\/XI2\<0\>\/XI2\<0\>\/XI2\<0\>\/XI2\<1\>\/XI2\<1\>\/XI2\<1\>\/RR2 \
 (  \
 N_SEL2\<1\>_XI2\<1\>\/XI2\<1\>\/XI2\<0\>\/XI2\<0\>\/XI2\<0\>\/XI2\<1\>\/XI2\<1\>\/XI2\<1\>\/RR2_pos \
 N_WLSEL\<1594\>_XI2\<1\>\/XI2\<1\>\/XI2\<0\>\/XI2\<0\>\/XI2\<0\>\/XI2\<1\>\/XI2\<1\>\/XI2\<1\>\/RR2_neg \
 ) R_1X_LL w=1e-07 l=1e-07   res=0.149966
XXI2\<1\>\/XI2\<1\>\/XI2\<0\>\/XI2\<0\>\/XI2\<0\>\/XI2\<1\>\/XI2\<1\>\/XI2\<1\>\/RR3 \
 (  \
 N_SEL3\<0\>_XI2\<1\>\/XI2\<1\>\/XI2\<0\>\/XI2\<0\>\/XI2\<0\>\/XI2\<1\>\/XI2\<1\>\/XI2\<1\>\/RR3_pos \
 N_WLSEL\<1595\>_XI2\<1\>\/XI2\<1\>\/XI2\<0\>\/XI2\<0\>\/XI2\<0\>\/XI2\<1\>\/XI2\<1\>\/XI2\<1\>\/RR3_neg \
 ) R_1X_LL w=1e-07 l=1e-07   res=0.149966
XXI2\<1\>\/XI2\<1\>\/XI2\<0\>\/XI2\<0\>\/XI2\<0\>\/XI2\<1\>\/XI2\<1\>\/XI2\<1\>\/RR4 \
 (  \
 N_SEL4\<0\>_XI2\<1\>\/XI2\<1\>\/XI2\<0\>\/XI2\<0\>\/XI2\<0\>\/XI2\<1\>\/XI2\<1\>\/XI2\<1\>\/RR4_pos \
 N_WLSEL\<1596\>_XI2\<1\>\/XI2\<1\>\/XI2\<0\>\/XI2\<0\>\/XI2\<0\>\/XI2\<1\>\/XI2\<1\>\/XI2\<1\>\/RR4_neg \
 ) R_1X_LL w=1e-07 l=1e-07   res=0.149966
XXI2\<1\>\/XI2\<1\>\/XI2\<0\>\/XI2\<0\>\/XI2\<0\>\/XI2\<1\>\/XI2\<1\>\/XI2\<1\>\/RR7 \
 (  \
 N_SEL5\<0\>_XI2\<1\>\/XI2\<1\>\/XI2\<0\>\/XI2\<0\>\/XI2\<0\>\/XI2\<1\>\/XI2\<1\>\/XI2\<1\>\/RR7_pos \
 N_WLSEL\<1597\>_XI2\<1\>\/XI2\<1\>\/XI2\<0\>\/XI2\<0\>\/XI2\<0\>\/XI2\<1\>\/XI2\<1\>\/XI2\<1\>\/RR7_neg \
 ) R_1X_LL w=1e-07 l=1e-07   res=0.149966
XXI2\<1\>\/XI2\<1\>\/XI2\<0\>\/XI2\<0\>\/XI2\<0\>\/XI2\<1\>\/XI2\<1\>\/XI2\<1\>\/RR6 \
 (  \
 N_SEL6\<1\>_XI2\<1\>\/XI2\<1\>\/XI2\<0\>\/XI2\<0\>\/XI2\<0\>\/XI2\<1\>\/XI2\<1\>\/XI2\<1\>\/RR6_pos \
 N_WLSEL\<1598\>_XI2\<1\>\/XI2\<1\>\/XI2\<0\>\/XI2\<0\>\/XI2\<0\>\/XI2\<1\>\/XI2\<1\>\/XI2\<1\>\/RR6_neg \
 ) R_1X_LL w=1e-07 l=1e-07   res=0.149966
XXI2\<1\>\/XI2\<1\>\/XI2\<0\>\/XI2\<0\>\/XI2\<0\>\/XI2\<1\>\/XI2\<1\>\/XI2\<1\>\/RR5 \
 (  \
 N_SEL7\<1\>_XI2\<1\>\/XI2\<1\>\/XI2\<0\>\/XI2\<0\>\/XI2\<0\>\/XI2\<1\>\/XI2\<1\>\/XI2\<1\>\/RR5_pos \
 N_WLSEL\<1599\>_XI2\<1\>\/XI2\<1\>\/XI2\<0\>\/XI2\<0\>\/XI2\<0\>\/XI2\<1\>\/XI2\<1\>\/XI2\<1\>\/RR5_neg \
 ) R_1X_LL w=1e-07 l=1e-07   res=0.149966
XXI2\<1\>\/XI2\<1\>\/XI2\<0\>\/XI2\<0\>\/XI2\<1\>\/XI2\<0\>\/XI2\<0\>\/XI2\<0\>\/RR0 \
 (  \
 N_SEL0\<0\>_XI2\<1\>\/XI2\<1\>\/XI2\<0\>\/XI2\<0\>\/XI2\<1\>\/XI2\<0\>\/XI2\<0\>\/XI2\<0\>\/RR0_pos \
 N_WLSEL\<1600\>_XI2\<1\>\/XI2\<1\>\/XI2\<0\>\/XI2\<0\>\/XI2\<1\>\/XI2\<0\>\/XI2\<0\>\/XI2\<0\>\/RR0_neg \
 ) R_1X_LL w=1e-07 l=1e-07   res=0.149966
XXI2\<1\>\/XI2\<1\>\/XI2\<0\>\/XI2\<0\>\/XI2\<1\>\/XI2\<0\>\/XI2\<0\>\/XI2\<0\>\/RR1 \
 (  \
 N_SEL1\<0\>_XI2\<1\>\/XI2\<1\>\/XI2\<0\>\/XI2\<0\>\/XI2\<1\>\/XI2\<0\>\/XI2\<0\>\/XI2\<0\>\/RR1_pos \
 N_WLSEL\<1601\>_XI2\<1\>\/XI2\<1\>\/XI2\<0\>\/XI2\<0\>\/XI2\<1\>\/XI2\<0\>\/XI2\<0\>\/XI2\<0\>\/RR1_neg \
 ) R_1X_LL w=1e-07 l=1e-07   res=0.149966
XXI2\<1\>\/XI2\<1\>\/XI2\<0\>\/XI2\<0\>\/XI2\<1\>\/XI2\<0\>\/XI2\<0\>\/XI2\<0\>\/RR2 \
 (  \
 N_SEL2\<0\>_XI2\<1\>\/XI2\<1\>\/XI2\<0\>\/XI2\<0\>\/XI2\<1\>\/XI2\<0\>\/XI2\<0\>\/XI2\<0\>\/RR2_pos \
 N_WLSEL\<1602\>_XI2\<1\>\/XI2\<1\>\/XI2\<0\>\/XI2\<0\>\/XI2\<1\>\/XI2\<0\>\/XI2\<0\>\/XI2\<0\>\/RR2_neg \
 ) R_1X_LL w=1e-07 l=1e-07   res=0.149966
XXI2\<1\>\/XI2\<1\>\/XI2\<0\>\/XI2\<0\>\/XI2\<1\>\/XI2\<0\>\/XI2\<0\>\/XI2\<0\>\/RR3 \
 (  \
 N_SEL3\<1\>_XI2\<1\>\/XI2\<1\>\/XI2\<0\>\/XI2\<0\>\/XI2\<1\>\/XI2\<0\>\/XI2\<0\>\/XI2\<0\>\/RR3_pos \
 N_WLSEL\<1603\>_XI2\<1\>\/XI2\<1\>\/XI2\<0\>\/XI2\<0\>\/XI2\<1\>\/XI2\<0\>\/XI2\<0\>\/XI2\<0\>\/RR3_neg \
 ) R_1X_LL w=1e-07 l=1e-07   res=0.149966
XXI2\<1\>\/XI2\<1\>\/XI2\<0\>\/XI2\<0\>\/XI2\<1\>\/XI2\<0\>\/XI2\<0\>\/XI2\<0\>\/RR4 \
 (  \
 N_SEL4\<0\>_XI2\<1\>\/XI2\<1\>\/XI2\<0\>\/XI2\<0\>\/XI2\<1\>\/XI2\<0\>\/XI2\<0\>\/XI2\<0\>\/RR4_pos \
 N_WLSEL\<1604\>_XI2\<1\>\/XI2\<1\>\/XI2\<0\>\/XI2\<0\>\/XI2\<1\>\/XI2\<0\>\/XI2\<0\>\/XI2\<0\>\/RR4_neg \
 ) R_1X_LL w=1e-07 l=1e-07   res=0.149966
XXI2\<1\>\/XI2\<1\>\/XI2\<0\>\/XI2\<0\>\/XI2\<1\>\/XI2\<0\>\/XI2\<0\>\/XI2\<0\>\/RR7 \
 (  \
 N_SEL5\<0\>_XI2\<1\>\/XI2\<1\>\/XI2\<0\>\/XI2\<0\>\/XI2\<1\>\/XI2\<0\>\/XI2\<0\>\/XI2\<0\>\/RR7_pos \
 N_WLSEL\<1605\>_XI2\<1\>\/XI2\<1\>\/XI2\<0\>\/XI2\<0\>\/XI2\<1\>\/XI2\<0\>\/XI2\<0\>\/XI2\<0\>\/RR7_neg \
 ) R_1X_LL w=1e-07 l=1e-07   res=0.149966
XXI2\<1\>\/XI2\<1\>\/XI2\<0\>\/XI2\<0\>\/XI2\<1\>\/XI2\<0\>\/XI2\<0\>\/XI2\<0\>\/RR6 \
 (  \
 N_SEL6\<1\>_XI2\<1\>\/XI2\<1\>\/XI2\<0\>\/XI2\<0\>\/XI2\<1\>\/XI2\<0\>\/XI2\<0\>\/XI2\<0\>\/RR6_pos \
 N_WLSEL\<1606\>_XI2\<1\>\/XI2\<1\>\/XI2\<0\>\/XI2\<0\>\/XI2\<1\>\/XI2\<0\>\/XI2\<0\>\/XI2\<0\>\/RR6_neg \
 ) R_1X_LL w=1e-07 l=1e-07   res=0.149966
XXI2\<1\>\/XI2\<1\>\/XI2\<0\>\/XI2\<0\>\/XI2\<1\>\/XI2\<0\>\/XI2\<0\>\/XI2\<0\>\/RR5 \
 (  \
 N_SEL7\<1\>_XI2\<1\>\/XI2\<1\>\/XI2\<0\>\/XI2\<0\>\/XI2\<1\>\/XI2\<0\>\/XI2\<0\>\/XI2\<0\>\/RR5_pos \
 N_WLSEL\<1607\>_XI2\<1\>\/XI2\<1\>\/XI2\<0\>\/XI2\<0\>\/XI2\<1\>\/XI2\<0\>\/XI2\<0\>\/XI2\<0\>\/RR5_neg \
 ) R_1X_LL w=1e-07 l=1e-07   res=0.149966
XXI2\<1\>\/XI2\<1\>\/XI2\<0\>\/XI2\<0\>\/XI2\<1\>\/XI2\<0\>\/XI2\<0\>\/XI2\<1\>\/RR0 \
 (  \
 N_SEL0\<1\>_XI2\<1\>\/XI2\<1\>\/XI2\<0\>\/XI2\<0\>\/XI2\<1\>\/XI2\<0\>\/XI2\<0\>\/XI2\<1\>\/RR0_pos \
 N_WLSEL\<1608\>_XI2\<1\>\/XI2\<1\>\/XI2\<0\>\/XI2\<0\>\/XI2\<1\>\/XI2\<0\>\/XI2\<0\>\/XI2\<1\>\/RR0_neg \
 ) R_1X_LL w=1e-07 l=1e-07   res=0.149966
XXI2\<1\>\/XI2\<1\>\/XI2\<0\>\/XI2\<0\>\/XI2\<1\>\/XI2\<0\>\/XI2\<0\>\/XI2\<1\>\/RR1 \
 (  \
 N_SEL1\<0\>_XI2\<1\>\/XI2\<1\>\/XI2\<0\>\/XI2\<0\>\/XI2\<1\>\/XI2\<0\>\/XI2\<0\>\/XI2\<1\>\/RR1_pos \
 N_WLSEL\<1609\>_XI2\<1\>\/XI2\<1\>\/XI2\<0\>\/XI2\<0\>\/XI2\<1\>\/XI2\<0\>\/XI2\<0\>\/XI2\<1\>\/RR1_neg \
 ) R_1X_LL w=1e-07 l=1e-07   res=0.149966
XXI2\<1\>\/XI2\<1\>\/XI2\<0\>\/XI2\<0\>\/XI2\<1\>\/XI2\<0\>\/XI2\<0\>\/XI2\<1\>\/RR2 \
 (  \
 N_SEL2\<0\>_XI2\<1\>\/XI2\<1\>\/XI2\<0\>\/XI2\<0\>\/XI2\<1\>\/XI2\<0\>\/XI2\<0\>\/XI2\<1\>\/RR2_pos \
 N_WLSEL\<1610\>_XI2\<1\>\/XI2\<1\>\/XI2\<0\>\/XI2\<0\>\/XI2\<1\>\/XI2\<0\>\/XI2\<0\>\/XI2\<1\>\/RR2_neg \
 ) R_1X_LL w=1e-07 l=1e-07   res=0.149966
XXI2\<1\>\/XI2\<1\>\/XI2\<0\>\/XI2\<0\>\/XI2\<1\>\/XI2\<0\>\/XI2\<0\>\/XI2\<1\>\/RR3 \
 (  \
 N_SEL3\<1\>_XI2\<1\>\/XI2\<1\>\/XI2\<0\>\/XI2\<0\>\/XI2\<1\>\/XI2\<0\>\/XI2\<0\>\/XI2\<1\>\/RR3_pos \
 N_WLSEL\<1611\>_XI2\<1\>\/XI2\<1\>\/XI2\<0\>\/XI2\<0\>\/XI2\<1\>\/XI2\<0\>\/XI2\<0\>\/XI2\<1\>\/RR3_neg \
 ) R_1X_LL w=1e-07 l=1e-07   res=0.149966
XXI2\<1\>\/XI2\<1\>\/XI2\<0\>\/XI2\<0\>\/XI2\<1\>\/XI2\<0\>\/XI2\<0\>\/XI2\<1\>\/RR4 \
 (  \
 N_SEL4\<0\>_XI2\<1\>\/XI2\<1\>\/XI2\<0\>\/XI2\<0\>\/XI2\<1\>\/XI2\<0\>\/XI2\<0\>\/XI2\<1\>\/RR4_pos \
 N_WLSEL\<1612\>_XI2\<1\>\/XI2\<1\>\/XI2\<0\>\/XI2\<0\>\/XI2\<1\>\/XI2\<0\>\/XI2\<0\>\/XI2\<1\>\/RR4_neg \
 ) R_1X_LL w=1e-07 l=1e-07   res=0.149966
XXI2\<1\>\/XI2\<1\>\/XI2\<0\>\/XI2\<0\>\/XI2\<1\>\/XI2\<0\>\/XI2\<0\>\/XI2\<1\>\/RR7 \
 (  \
 N_SEL5\<0\>_XI2\<1\>\/XI2\<1\>\/XI2\<0\>\/XI2\<0\>\/XI2\<1\>\/XI2\<0\>\/XI2\<0\>\/XI2\<1\>\/RR7_pos \
 N_WLSEL\<1613\>_XI2\<1\>\/XI2\<1\>\/XI2\<0\>\/XI2\<0\>\/XI2\<1\>\/XI2\<0\>\/XI2\<0\>\/XI2\<1\>\/RR7_neg \
 ) R_1X_LL w=1e-07 l=1e-07   res=0.149966
XXI2\<1\>\/XI2\<1\>\/XI2\<0\>\/XI2\<0\>\/XI2\<1\>\/XI2\<0\>\/XI2\<0\>\/XI2\<1\>\/RR6 \
 (  \
 N_SEL6\<1\>_XI2\<1\>\/XI2\<1\>\/XI2\<0\>\/XI2\<0\>\/XI2\<1\>\/XI2\<0\>\/XI2\<0\>\/XI2\<1\>\/RR6_pos \
 N_WLSEL\<1614\>_XI2\<1\>\/XI2\<1\>\/XI2\<0\>\/XI2\<0\>\/XI2\<1\>\/XI2\<0\>\/XI2\<0\>\/XI2\<1\>\/RR6_neg \
 ) R_1X_LL w=1e-07 l=1e-07   res=0.149966
XXI2\<1\>\/XI2\<1\>\/XI2\<0\>\/XI2\<0\>\/XI2\<1\>\/XI2\<0\>\/XI2\<0\>\/XI2\<1\>\/RR5 \
 (  \
 N_SEL7\<1\>_XI2\<1\>\/XI2\<1\>\/XI2\<0\>\/XI2\<0\>\/XI2\<1\>\/XI2\<0\>\/XI2\<0\>\/XI2\<1\>\/RR5_pos \
 N_WLSEL\<1615\>_XI2\<1\>\/XI2\<1\>\/XI2\<0\>\/XI2\<0\>\/XI2\<1\>\/XI2\<0\>\/XI2\<0\>\/XI2\<1\>\/RR5_neg \
 ) R_1X_LL w=1e-07 l=1e-07   res=0.149966
XXI2\<1\>\/XI2\<1\>\/XI2\<0\>\/XI2\<0\>\/XI2\<1\>\/XI2\<0\>\/XI2\<1\>\/XI2\<0\>\/RR0 \
 (  \
 N_SEL0\<0\>_XI2\<1\>\/XI2\<1\>\/XI2\<0\>\/XI2\<0\>\/XI2\<1\>\/XI2\<0\>\/XI2\<1\>\/XI2\<0\>\/RR0_pos \
 N_WLSEL\<1616\>_XI2\<1\>\/XI2\<1\>\/XI2\<0\>\/XI2\<0\>\/XI2\<1\>\/XI2\<0\>\/XI2\<1\>\/XI2\<0\>\/RR0_neg \
 ) R_1X_LL w=1e-07 l=1e-07   res=0.149966
XXI2\<1\>\/XI2\<1\>\/XI2\<0\>\/XI2\<0\>\/XI2\<1\>\/XI2\<0\>\/XI2\<1\>\/XI2\<0\>\/RR1 \
 (  \
 N_SEL1\<1\>_XI2\<1\>\/XI2\<1\>\/XI2\<0\>\/XI2\<0\>\/XI2\<1\>\/XI2\<0\>\/XI2\<1\>\/XI2\<0\>\/RR1_pos \
 N_WLSEL\<1617\>_XI2\<1\>\/XI2\<1\>\/XI2\<0\>\/XI2\<0\>\/XI2\<1\>\/XI2\<0\>\/XI2\<1\>\/XI2\<0\>\/RR1_neg \
 ) R_1X_LL w=1e-07 l=1e-07   res=0.149966
XXI2\<1\>\/XI2\<1\>\/XI2\<0\>\/XI2\<0\>\/XI2\<1\>\/XI2\<0\>\/XI2\<1\>\/XI2\<0\>\/RR2 \
 (  \
 N_SEL2\<0\>_XI2\<1\>\/XI2\<1\>\/XI2\<0\>\/XI2\<0\>\/XI2\<1\>\/XI2\<0\>\/XI2\<1\>\/XI2\<0\>\/RR2_pos \
 N_WLSEL\<1618\>_XI2\<1\>\/XI2\<1\>\/XI2\<0\>\/XI2\<0\>\/XI2\<1\>\/XI2\<0\>\/XI2\<1\>\/XI2\<0\>\/RR2_neg \
 ) R_1X_LL w=1e-07 l=1e-07   res=0.149966
XXI2\<1\>\/XI2\<1\>\/XI2\<0\>\/XI2\<0\>\/XI2\<1\>\/XI2\<0\>\/XI2\<1\>\/XI2\<0\>\/RR3 \
 (  \
 N_SEL3\<1\>_XI2\<1\>\/XI2\<1\>\/XI2\<0\>\/XI2\<0\>\/XI2\<1\>\/XI2\<0\>\/XI2\<1\>\/XI2\<0\>\/RR3_pos \
 N_WLSEL\<1619\>_XI2\<1\>\/XI2\<1\>\/XI2\<0\>\/XI2\<0\>\/XI2\<1\>\/XI2\<0\>\/XI2\<1\>\/XI2\<0\>\/RR3_neg \
 ) R_1X_LL w=1e-07 l=1e-07   res=0.149966
XXI2\<1\>\/XI2\<1\>\/XI2\<0\>\/XI2\<0\>\/XI2\<1\>\/XI2\<0\>\/XI2\<1\>\/XI2\<0\>\/RR4 \
 (  \
 N_SEL4\<0\>_XI2\<1\>\/XI2\<1\>\/XI2\<0\>\/XI2\<0\>\/XI2\<1\>\/XI2\<0\>\/XI2\<1\>\/XI2\<0\>\/RR4_pos \
 N_WLSEL\<1620\>_XI2\<1\>\/XI2\<1\>\/XI2\<0\>\/XI2\<0\>\/XI2\<1\>\/XI2\<0\>\/XI2\<1\>\/XI2\<0\>\/RR4_neg \
 ) R_1X_LL w=1e-07 l=1e-07   res=0.149966
XXI2\<1\>\/XI2\<1\>\/XI2\<0\>\/XI2\<0\>\/XI2\<1\>\/XI2\<0\>\/XI2\<1\>\/XI2\<0\>\/RR7 \
 (  \
 N_SEL5\<0\>_XI2\<1\>\/XI2\<1\>\/XI2\<0\>\/XI2\<0\>\/XI2\<1\>\/XI2\<0\>\/XI2\<1\>\/XI2\<0\>\/RR7_pos \
 N_WLSEL\<1621\>_XI2\<1\>\/XI2\<1\>\/XI2\<0\>\/XI2\<0\>\/XI2\<1\>\/XI2\<0\>\/XI2\<1\>\/XI2\<0\>\/RR7_neg \
 ) R_1X_LL w=1e-07 l=1e-07   res=0.149966
XXI2\<1\>\/XI2\<1\>\/XI2\<0\>\/XI2\<0\>\/XI2\<1\>\/XI2\<0\>\/XI2\<1\>\/XI2\<0\>\/RR6 \
 (  \
 N_SEL6\<1\>_XI2\<1\>\/XI2\<1\>\/XI2\<0\>\/XI2\<0\>\/XI2\<1\>\/XI2\<0\>\/XI2\<1\>\/XI2\<0\>\/RR6_pos \
 N_WLSEL\<1622\>_XI2\<1\>\/XI2\<1\>\/XI2\<0\>\/XI2\<0\>\/XI2\<1\>\/XI2\<0\>\/XI2\<1\>\/XI2\<0\>\/RR6_neg \
 ) R_1X_LL w=1e-07 l=1e-07   res=0.149966
XXI2\<1\>\/XI2\<1\>\/XI2\<0\>\/XI2\<0\>\/XI2\<1\>\/XI2\<0\>\/XI2\<1\>\/XI2\<0\>\/RR5 \
 (  \
 N_SEL7\<1\>_XI2\<1\>\/XI2\<1\>\/XI2\<0\>\/XI2\<0\>\/XI2\<1\>\/XI2\<0\>\/XI2\<1\>\/XI2\<0\>\/RR5_pos \
 N_WLSEL\<1623\>_XI2\<1\>\/XI2\<1\>\/XI2\<0\>\/XI2\<0\>\/XI2\<1\>\/XI2\<0\>\/XI2\<1\>\/XI2\<0\>\/RR5_neg \
 ) R_1X_LL w=1e-07 l=1e-07   res=0.149966
XXI2\<1\>\/XI2\<1\>\/XI2\<0\>\/XI2\<0\>\/XI2\<1\>\/XI2\<0\>\/XI2\<1\>\/XI2\<1\>\/RR0 \
 (  \
 N_SEL0\<1\>_XI2\<1\>\/XI2\<1\>\/XI2\<0\>\/XI2\<0\>\/XI2\<1\>\/XI2\<0\>\/XI2\<1\>\/XI2\<1\>\/RR0_pos \
 N_WLSEL\<1624\>_XI2\<1\>\/XI2\<1\>\/XI2\<0\>\/XI2\<0\>\/XI2\<1\>\/XI2\<0\>\/XI2\<1\>\/XI2\<1\>\/RR0_neg \
 ) R_1X_LL w=1e-07 l=1e-07   res=0.149966
XXI2\<1\>\/XI2\<1\>\/XI2\<0\>\/XI2\<0\>\/XI2\<1\>\/XI2\<0\>\/XI2\<1\>\/XI2\<1\>\/RR1 \
 (  \
 N_SEL1\<1\>_XI2\<1\>\/XI2\<1\>\/XI2\<0\>\/XI2\<0\>\/XI2\<1\>\/XI2\<0\>\/XI2\<1\>\/XI2\<1\>\/RR1_pos \
 N_WLSEL\<1625\>_XI2\<1\>\/XI2\<1\>\/XI2\<0\>\/XI2\<0\>\/XI2\<1\>\/XI2\<0\>\/XI2\<1\>\/XI2\<1\>\/RR1_neg \
 ) R_1X_LL w=1e-07 l=1e-07   res=0.149966
XXI2\<1\>\/XI2\<1\>\/XI2\<0\>\/XI2\<0\>\/XI2\<1\>\/XI2\<0\>\/XI2\<1\>\/XI2\<1\>\/RR2 \
 (  \
 N_SEL2\<0\>_XI2\<1\>\/XI2\<1\>\/XI2\<0\>\/XI2\<0\>\/XI2\<1\>\/XI2\<0\>\/XI2\<1\>\/XI2\<1\>\/RR2_pos \
 N_WLSEL\<1626\>_XI2\<1\>\/XI2\<1\>\/XI2\<0\>\/XI2\<0\>\/XI2\<1\>\/XI2\<0\>\/XI2\<1\>\/XI2\<1\>\/RR2_neg \
 ) R_1X_LL w=1e-07 l=1e-07   res=0.149966
XXI2\<1\>\/XI2\<1\>\/XI2\<0\>\/XI2\<0\>\/XI2\<1\>\/XI2\<0\>\/XI2\<1\>\/XI2\<1\>\/RR3 \
 (  \
 N_SEL3\<1\>_XI2\<1\>\/XI2\<1\>\/XI2\<0\>\/XI2\<0\>\/XI2\<1\>\/XI2\<0\>\/XI2\<1\>\/XI2\<1\>\/RR3_pos \
 N_WLSEL\<1627\>_XI2\<1\>\/XI2\<1\>\/XI2\<0\>\/XI2\<0\>\/XI2\<1\>\/XI2\<0\>\/XI2\<1\>\/XI2\<1\>\/RR3_neg \
 ) R_1X_LL w=1e-07 l=1e-07   res=0.149966
XXI2\<1\>\/XI2\<1\>\/XI2\<0\>\/XI2\<0\>\/XI2\<1\>\/XI2\<0\>\/XI2\<1\>\/XI2\<1\>\/RR4 \
 (  \
 N_SEL4\<0\>_XI2\<1\>\/XI2\<1\>\/XI2\<0\>\/XI2\<0\>\/XI2\<1\>\/XI2\<0\>\/XI2\<1\>\/XI2\<1\>\/RR4_pos \
 N_WLSEL\<1628\>_XI2\<1\>\/XI2\<1\>\/XI2\<0\>\/XI2\<0\>\/XI2\<1\>\/XI2\<0\>\/XI2\<1\>\/XI2\<1\>\/RR4_neg \
 ) R_1X_LL w=1e-07 l=1e-07   res=0.149966
XXI2\<1\>\/XI2\<1\>\/XI2\<0\>\/XI2\<0\>\/XI2\<1\>\/XI2\<0\>\/XI2\<1\>\/XI2\<1\>\/RR7 \
 (  \
 N_SEL5\<0\>_XI2\<1\>\/XI2\<1\>\/XI2\<0\>\/XI2\<0\>\/XI2\<1\>\/XI2\<0\>\/XI2\<1\>\/XI2\<1\>\/RR7_pos \
 N_WLSEL\<1629\>_XI2\<1\>\/XI2\<1\>\/XI2\<0\>\/XI2\<0\>\/XI2\<1\>\/XI2\<0\>\/XI2\<1\>\/XI2\<1\>\/RR7_neg \
 ) R_1X_LL w=1e-07 l=1e-07   res=0.149966
XXI2\<1\>\/XI2\<1\>\/XI2\<0\>\/XI2\<0\>\/XI2\<1\>\/XI2\<0\>\/XI2\<1\>\/XI2\<1\>\/RR6 \
 (  \
 N_SEL6\<1\>_XI2\<1\>\/XI2\<1\>\/XI2\<0\>\/XI2\<0\>\/XI2\<1\>\/XI2\<0\>\/XI2\<1\>\/XI2\<1\>\/RR6_pos \
 N_WLSEL\<1630\>_XI2\<1\>\/XI2\<1\>\/XI2\<0\>\/XI2\<0\>\/XI2\<1\>\/XI2\<0\>\/XI2\<1\>\/XI2\<1\>\/RR6_neg \
 ) R_1X_LL w=1e-07 l=1e-07   res=0.149966
XXI2\<1\>\/XI2\<1\>\/XI2\<0\>\/XI2\<0\>\/XI2\<1\>\/XI2\<0\>\/XI2\<1\>\/XI2\<1\>\/RR5 \
 (  \
 N_SEL7\<1\>_XI2\<1\>\/XI2\<1\>\/XI2\<0\>\/XI2\<0\>\/XI2\<1\>\/XI2\<0\>\/XI2\<1\>\/XI2\<1\>\/RR5_pos \
 N_WLSEL\<1631\>_XI2\<1\>\/XI2\<1\>\/XI2\<0\>\/XI2\<0\>\/XI2\<1\>\/XI2\<0\>\/XI2\<1\>\/XI2\<1\>\/RR5_neg \
 ) R_1X_LL w=1e-07 l=1e-07   res=0.149966
XXI2\<1\>\/XI2\<1\>\/XI2\<0\>\/XI2\<0\>\/XI2\<1\>\/XI2\<1\>\/XI2\<0\>\/XI2\<0\>\/RR0 \
 (  \
 N_SEL0\<0\>_XI2\<1\>\/XI2\<1\>\/XI2\<0\>\/XI2\<0\>\/XI2\<1\>\/XI2\<1\>\/XI2\<0\>\/XI2\<0\>\/RR0_pos \
 N_WLSEL\<1632\>_XI2\<1\>\/XI2\<1\>\/XI2\<0\>\/XI2\<0\>\/XI2\<1\>\/XI2\<1\>\/XI2\<0\>\/XI2\<0\>\/RR0_neg \
 ) R_1X_LL w=1e-07 l=1e-07   res=0.149966
XXI2\<1\>\/XI2\<1\>\/XI2\<0\>\/XI2\<0\>\/XI2\<1\>\/XI2\<1\>\/XI2\<0\>\/XI2\<0\>\/RR1 \
 (  \
 N_SEL1\<0\>_XI2\<1\>\/XI2\<1\>\/XI2\<0\>\/XI2\<0\>\/XI2\<1\>\/XI2\<1\>\/XI2\<0\>\/XI2\<0\>\/RR1_pos \
 N_WLSEL\<1633\>_XI2\<1\>\/XI2\<1\>\/XI2\<0\>\/XI2\<0\>\/XI2\<1\>\/XI2\<1\>\/XI2\<0\>\/XI2\<0\>\/RR1_neg \
 ) R_1X_LL w=1e-07 l=1e-07   res=0.149966
XXI2\<1\>\/XI2\<1\>\/XI2\<0\>\/XI2\<0\>\/XI2\<1\>\/XI2\<1\>\/XI2\<0\>\/XI2\<0\>\/RR2 \
 (  \
 N_SEL2\<1\>_XI2\<1\>\/XI2\<1\>\/XI2\<0\>\/XI2\<0\>\/XI2\<1\>\/XI2\<1\>\/XI2\<0\>\/XI2\<0\>\/RR2_pos \
 N_WLSEL\<1634\>_XI2\<1\>\/XI2\<1\>\/XI2\<0\>\/XI2\<0\>\/XI2\<1\>\/XI2\<1\>\/XI2\<0\>\/XI2\<0\>\/RR2_neg \
 ) R_1X_LL w=1e-07 l=1e-07   res=0.149966
XXI2\<1\>\/XI2\<1\>\/XI2\<0\>\/XI2\<0\>\/XI2\<1\>\/XI2\<1\>\/XI2\<0\>\/XI2\<0\>\/RR3 \
 (  \
 N_SEL3\<1\>_XI2\<1\>\/XI2\<1\>\/XI2\<0\>\/XI2\<0\>\/XI2\<1\>\/XI2\<1\>\/XI2\<0\>\/XI2\<0\>\/RR3_pos \
 N_WLSEL\<1635\>_XI2\<1\>\/XI2\<1\>\/XI2\<0\>\/XI2\<0\>\/XI2\<1\>\/XI2\<1\>\/XI2\<0\>\/XI2\<0\>\/RR3_neg \
 ) R_1X_LL w=1e-07 l=1e-07   res=0.149966
XXI2\<1\>\/XI2\<1\>\/XI2\<0\>\/XI2\<0\>\/XI2\<1\>\/XI2\<1\>\/XI2\<0\>\/XI2\<0\>\/RR4 \
 (  \
 N_SEL4\<0\>_XI2\<1\>\/XI2\<1\>\/XI2\<0\>\/XI2\<0\>\/XI2\<1\>\/XI2\<1\>\/XI2\<0\>\/XI2\<0\>\/RR4_pos \
 N_WLSEL\<1636\>_XI2\<1\>\/XI2\<1\>\/XI2\<0\>\/XI2\<0\>\/XI2\<1\>\/XI2\<1\>\/XI2\<0\>\/XI2\<0\>\/RR4_neg \
 ) R_1X_LL w=1e-07 l=1e-07   res=0.149966
XXI2\<1\>\/XI2\<1\>\/XI2\<0\>\/XI2\<0\>\/XI2\<1\>\/XI2\<1\>\/XI2\<0\>\/XI2\<0\>\/RR7 \
 (  \
 N_SEL5\<0\>_XI2\<1\>\/XI2\<1\>\/XI2\<0\>\/XI2\<0\>\/XI2\<1\>\/XI2\<1\>\/XI2\<0\>\/XI2\<0\>\/RR7_pos \
 N_WLSEL\<1637\>_XI2\<1\>\/XI2\<1\>\/XI2\<0\>\/XI2\<0\>\/XI2\<1\>\/XI2\<1\>\/XI2\<0\>\/XI2\<0\>\/RR7_neg \
 ) R_1X_LL w=1e-07 l=1e-07   res=0.149966
XXI2\<1\>\/XI2\<1\>\/XI2\<0\>\/XI2\<0\>\/XI2\<1\>\/XI2\<1\>\/XI2\<0\>\/XI2\<0\>\/RR6 \
 (  \
 N_SEL6\<1\>_XI2\<1\>\/XI2\<1\>\/XI2\<0\>\/XI2\<0\>\/XI2\<1\>\/XI2\<1\>\/XI2\<0\>\/XI2\<0\>\/RR6_pos \
 N_WLSEL\<1638\>_XI2\<1\>\/XI2\<1\>\/XI2\<0\>\/XI2\<0\>\/XI2\<1\>\/XI2\<1\>\/XI2\<0\>\/XI2\<0\>\/RR6_neg \
 ) R_1X_LL w=1e-07 l=1e-07   res=0.149966
XXI2\<1\>\/XI2\<1\>\/XI2\<0\>\/XI2\<0\>\/XI2\<1\>\/XI2\<1\>\/XI2\<0\>\/XI2\<0\>\/RR5 \
 (  \
 N_SEL7\<1\>_XI2\<1\>\/XI2\<1\>\/XI2\<0\>\/XI2\<0\>\/XI2\<1\>\/XI2\<1\>\/XI2\<0\>\/XI2\<0\>\/RR5_pos \
 N_WLSEL\<1639\>_XI2\<1\>\/XI2\<1\>\/XI2\<0\>\/XI2\<0\>\/XI2\<1\>\/XI2\<1\>\/XI2\<0\>\/XI2\<0\>\/RR5_neg \
 ) R_1X_LL w=1e-07 l=1e-07   res=0.149966
XXI2\<1\>\/XI2\<1\>\/XI2\<0\>\/XI2\<0\>\/XI2\<1\>\/XI2\<1\>\/XI2\<0\>\/XI2\<1\>\/RR0 \
 (  \
 N_SEL0\<1\>_XI2\<1\>\/XI2\<1\>\/XI2\<0\>\/XI2\<0\>\/XI2\<1\>\/XI2\<1\>\/XI2\<0\>\/XI2\<1\>\/RR0_pos \
 N_WLSEL\<1640\>_XI2\<1\>\/XI2\<1\>\/XI2\<0\>\/XI2\<0\>\/XI2\<1\>\/XI2\<1\>\/XI2\<0\>\/XI2\<1\>\/RR0_neg \
 ) R_1X_LL w=1e-07 l=1e-07   res=0.149966
XXI2\<1\>\/XI2\<1\>\/XI2\<0\>\/XI2\<0\>\/XI2\<1\>\/XI2\<1\>\/XI2\<0\>\/XI2\<1\>\/RR1 \
 (  \
 N_SEL1\<0\>_XI2\<1\>\/XI2\<1\>\/XI2\<0\>\/XI2\<0\>\/XI2\<1\>\/XI2\<1\>\/XI2\<0\>\/XI2\<1\>\/RR1_pos \
 N_WLSEL\<1641\>_XI2\<1\>\/XI2\<1\>\/XI2\<0\>\/XI2\<0\>\/XI2\<1\>\/XI2\<1\>\/XI2\<0\>\/XI2\<1\>\/RR1_neg \
 ) R_1X_LL w=1e-07 l=1e-07   res=0.149966
XXI2\<1\>\/XI2\<1\>\/XI2\<0\>\/XI2\<0\>\/XI2\<1\>\/XI2\<1\>\/XI2\<0\>\/XI2\<1\>\/RR2 \
 (  \
 N_SEL2\<1\>_XI2\<1\>\/XI2\<1\>\/XI2\<0\>\/XI2\<0\>\/XI2\<1\>\/XI2\<1\>\/XI2\<0\>\/XI2\<1\>\/RR2_pos \
 N_WLSEL\<1642\>_XI2\<1\>\/XI2\<1\>\/XI2\<0\>\/XI2\<0\>\/XI2\<1\>\/XI2\<1\>\/XI2\<0\>\/XI2\<1\>\/RR2_neg \
 ) R_1X_LL w=1e-07 l=1e-07   res=0.149966
XXI2\<1\>\/XI2\<1\>\/XI2\<0\>\/XI2\<0\>\/XI2\<1\>\/XI2\<1\>\/XI2\<0\>\/XI2\<1\>\/RR3 \
 (  \
 N_SEL3\<1\>_XI2\<1\>\/XI2\<1\>\/XI2\<0\>\/XI2\<0\>\/XI2\<1\>\/XI2\<1\>\/XI2\<0\>\/XI2\<1\>\/RR3_pos \
 N_WLSEL\<1643\>_XI2\<1\>\/XI2\<1\>\/XI2\<0\>\/XI2\<0\>\/XI2\<1\>\/XI2\<1\>\/XI2\<0\>\/XI2\<1\>\/RR3_neg \
 ) R_1X_LL w=1e-07 l=1e-07   res=0.149966
XXI2\<1\>\/XI2\<1\>\/XI2\<0\>\/XI2\<0\>\/XI2\<1\>\/XI2\<1\>\/XI2\<0\>\/XI2\<1\>\/RR4 \
 (  \
 N_SEL4\<0\>_XI2\<1\>\/XI2\<1\>\/XI2\<0\>\/XI2\<0\>\/XI2\<1\>\/XI2\<1\>\/XI2\<0\>\/XI2\<1\>\/RR4_pos \
 N_WLSEL\<1644\>_XI2\<1\>\/XI2\<1\>\/XI2\<0\>\/XI2\<0\>\/XI2\<1\>\/XI2\<1\>\/XI2\<0\>\/XI2\<1\>\/RR4_neg \
 ) R_1X_LL w=1e-07 l=1e-07   res=0.149966
XXI2\<1\>\/XI2\<0\>\/XI2\<0\>\/XI2\<0\>\/XI2\<0\>\/XI2\<0\>\/XI2\<1\>\/XI2\<1\>\/RR7 \
 (  \
 N_SEL5\<0\>_XI2\<1\>\/XI2\<0\>\/XI2\<0\>\/XI2\<0\>\/XI2\<0\>\/XI2\<0\>\/XI2\<1\>\/XI2\<1\>\/RR7_pos \
 N_WLSEL\<1053\>_XI2\<1\>\/XI2\<0\>\/XI2\<0\>\/XI2\<0\>\/XI2\<0\>\/XI2\<0\>\/XI2\<1\>\/XI2\<1\>\/RR7_neg \
 ) R_1X_LL w=1e-07 l=1e-07   res=0.149966
XXI2\<1\>\/XI2\<0\>\/XI2\<0\>\/XI2\<0\>\/XI2\<0\>\/XI2\<0\>\/XI2\<1\>\/XI2\<1\>\/RR6 \
 (  \
 N_SEL6\<0\>_XI2\<1\>\/XI2\<0\>\/XI2\<0\>\/XI2\<0\>\/XI2\<0\>\/XI2\<0\>\/XI2\<1\>\/XI2\<1\>\/RR6_pos \
 N_WLSEL\<1054\>_XI2\<1\>\/XI2\<0\>\/XI2\<0\>\/XI2\<0\>\/XI2\<0\>\/XI2\<0\>\/XI2\<1\>\/XI2\<1\>\/RR6_neg \
 ) R_1X_LL w=1e-07 l=1e-07   res=0.149966
XXI2\<1\>\/XI2\<0\>\/XI2\<0\>\/XI2\<0\>\/XI2\<0\>\/XI2\<0\>\/XI2\<1\>\/XI2\<1\>\/RR5 \
 (  \
 N_SEL7\<1\>_XI2\<1\>\/XI2\<0\>\/XI2\<0\>\/XI2\<0\>\/XI2\<0\>\/XI2\<0\>\/XI2\<1\>\/XI2\<1\>\/RR5_pos \
 N_WLSEL\<1055\>_XI2\<1\>\/XI2\<0\>\/XI2\<0\>\/XI2\<0\>\/XI2\<0\>\/XI2\<0\>\/XI2\<1\>\/XI2\<1\>\/RR5_neg \
 ) R_1X_LL w=1e-07 l=1e-07   res=0.149966
XXI2\<1\>\/XI2\<0\>\/XI2\<0\>\/XI2\<0\>\/XI2\<0\>\/XI2\<1\>\/XI2\<0\>\/XI2\<0\>\/RR0 \
 (  \
 N_SEL0\<0\>_XI2\<1\>\/XI2\<0\>\/XI2\<0\>\/XI2\<0\>\/XI2\<0\>\/XI2\<1\>\/XI2\<0\>\/XI2\<0\>\/RR0_pos \
 N_WLSEL\<1056\>_XI2\<1\>\/XI2\<0\>\/XI2\<0\>\/XI2\<0\>\/XI2\<0\>\/XI2\<1\>\/XI2\<0\>\/XI2\<0\>\/RR0_neg \
 ) R_1X_LL w=1e-07 l=1e-07   res=0.149966
XXI2\<1\>\/XI2\<0\>\/XI2\<0\>\/XI2\<0\>\/XI2\<0\>\/XI2\<1\>\/XI2\<0\>\/XI2\<0\>\/RR1 \
 (  \
 N_SEL1\<0\>_XI2\<1\>\/XI2\<0\>\/XI2\<0\>\/XI2\<0\>\/XI2\<0\>\/XI2\<1\>\/XI2\<0\>\/XI2\<0\>\/RR1_pos \
 N_WLSEL\<1057\>_XI2\<1\>\/XI2\<0\>\/XI2\<0\>\/XI2\<0\>\/XI2\<0\>\/XI2\<1\>\/XI2\<0\>\/XI2\<0\>\/RR1_neg \
 ) R_1X_LL w=1e-07 l=1e-07   res=0.149966
XXI2\<1\>\/XI2\<0\>\/XI2\<0\>\/XI2\<0\>\/XI2\<0\>\/XI2\<1\>\/XI2\<0\>\/XI2\<0\>\/RR2 \
 (  \
 N_SEL2\<1\>_XI2\<1\>\/XI2\<0\>\/XI2\<0\>\/XI2\<0\>\/XI2\<0\>\/XI2\<1\>\/XI2\<0\>\/XI2\<0\>\/RR2_pos \
 N_WLSEL\<1058\>_XI2\<1\>\/XI2\<0\>\/XI2\<0\>\/XI2\<0\>\/XI2\<0\>\/XI2\<1\>\/XI2\<0\>\/XI2\<0\>\/RR2_neg \
 ) R_1X_LL w=1e-07 l=1e-07   res=0.149966
XXI2\<1\>\/XI2\<0\>\/XI2\<0\>\/XI2\<0\>\/XI2\<0\>\/XI2\<1\>\/XI2\<0\>\/XI2\<0\>\/RR3 \
 (  \
 N_SEL3\<0\>_XI2\<1\>\/XI2\<0\>\/XI2\<0\>\/XI2\<0\>\/XI2\<0\>\/XI2\<1\>\/XI2\<0\>\/XI2\<0\>\/RR3_pos \
 N_WLSEL\<1059\>_XI2\<1\>\/XI2\<0\>\/XI2\<0\>\/XI2\<0\>\/XI2\<0\>\/XI2\<1\>\/XI2\<0\>\/XI2\<0\>\/RR3_neg \
 ) R_1X_LL w=1e-07 l=1e-07   res=0.149966
XXI2\<1\>\/XI2\<0\>\/XI2\<0\>\/XI2\<0\>\/XI2\<0\>\/XI2\<1\>\/XI2\<0\>\/XI2\<0\>\/RR4 \
 (  \
 N_SEL4\<0\>_XI2\<1\>\/XI2\<0\>\/XI2\<0\>\/XI2\<0\>\/XI2\<0\>\/XI2\<1\>\/XI2\<0\>\/XI2\<0\>\/RR4_pos \
 N_WLSEL\<1060\>_XI2\<1\>\/XI2\<0\>\/XI2\<0\>\/XI2\<0\>\/XI2\<0\>\/XI2\<1\>\/XI2\<0\>\/XI2\<0\>\/RR4_neg \
 ) R_1X_LL w=1e-07 l=1e-07   res=0.149966
XXI2\<1\>\/XI2\<0\>\/XI2\<0\>\/XI2\<0\>\/XI2\<0\>\/XI2\<1\>\/XI2\<0\>\/XI2\<0\>\/RR7 \
 (  \
 N_SEL5\<0\>_XI2\<1\>\/XI2\<0\>\/XI2\<0\>\/XI2\<0\>\/XI2\<0\>\/XI2\<1\>\/XI2\<0\>\/XI2\<0\>\/RR7_pos \
 N_WLSEL\<1061\>_XI2\<1\>\/XI2\<0\>\/XI2\<0\>\/XI2\<0\>\/XI2\<0\>\/XI2\<1\>\/XI2\<0\>\/XI2\<0\>\/RR7_neg \
 ) R_1X_LL w=1e-07 l=1e-07   res=0.149966
XXI2\<1\>\/XI2\<0\>\/XI2\<0\>\/XI2\<0\>\/XI2\<0\>\/XI2\<1\>\/XI2\<0\>\/XI2\<0\>\/RR6 \
 (  \
 N_SEL6\<0\>_XI2\<1\>\/XI2\<0\>\/XI2\<0\>\/XI2\<0\>\/XI2\<0\>\/XI2\<1\>\/XI2\<0\>\/XI2\<0\>\/RR6_pos \
 N_WLSEL\<1062\>_XI2\<1\>\/XI2\<0\>\/XI2\<0\>\/XI2\<0\>\/XI2\<0\>\/XI2\<1\>\/XI2\<0\>\/XI2\<0\>\/RR6_neg \
 ) R_1X_LL w=1e-07 l=1e-07   res=0.149966
XXI2\<1\>\/XI2\<0\>\/XI2\<0\>\/XI2\<0\>\/XI2\<0\>\/XI2\<1\>\/XI2\<0\>\/XI2\<0\>\/RR5 \
 (  \
 N_SEL7\<1\>_XI2\<1\>\/XI2\<0\>\/XI2\<0\>\/XI2\<0\>\/XI2\<0\>\/XI2\<1\>\/XI2\<0\>\/XI2\<0\>\/RR5_pos \
 N_WLSEL\<1063\>_XI2\<1\>\/XI2\<0\>\/XI2\<0\>\/XI2\<0\>\/XI2\<0\>\/XI2\<1\>\/XI2\<0\>\/XI2\<0\>\/RR5_neg \
 ) R_1X_LL w=1e-07 l=1e-07   res=0.149966
XXI2\<1\>\/XI2\<0\>\/XI2\<0\>\/XI2\<0\>\/XI2\<0\>\/XI2\<1\>\/XI2\<0\>\/XI2\<1\>\/RR0 \
 (  \
 N_SEL0\<1\>_XI2\<1\>\/XI2\<0\>\/XI2\<0\>\/XI2\<0\>\/XI2\<0\>\/XI2\<1\>\/XI2\<0\>\/XI2\<1\>\/RR0_pos \
 N_WLSEL\<1064\>_XI2\<1\>\/XI2\<0\>\/XI2\<0\>\/XI2\<0\>\/XI2\<0\>\/XI2\<1\>\/XI2\<0\>\/XI2\<1\>\/RR0_neg \
 ) R_1X_LL w=1e-07 l=1e-07   res=0.149966
XXI2\<1\>\/XI2\<0\>\/XI2\<0\>\/XI2\<0\>\/XI2\<0\>\/XI2\<1\>\/XI2\<0\>\/XI2\<1\>\/RR1 \
 (  \
 N_SEL1\<0\>_XI2\<1\>\/XI2\<0\>\/XI2\<0\>\/XI2\<0\>\/XI2\<0\>\/XI2\<1\>\/XI2\<0\>\/XI2\<1\>\/RR1_pos \
 N_WLSEL\<1065\>_XI2\<1\>\/XI2\<0\>\/XI2\<0\>\/XI2\<0\>\/XI2\<0\>\/XI2\<1\>\/XI2\<0\>\/XI2\<1\>\/RR1_neg \
 ) R_1X_LL w=1e-07 l=1e-07   res=0.149966
XXI2\<1\>\/XI2\<0\>\/XI2\<0\>\/XI2\<0\>\/XI2\<0\>\/XI2\<1\>\/XI2\<0\>\/XI2\<1\>\/RR2 \
 (  \
 N_SEL2\<1\>_XI2\<1\>\/XI2\<0\>\/XI2\<0\>\/XI2\<0\>\/XI2\<0\>\/XI2\<1\>\/XI2\<0\>\/XI2\<1\>\/RR2_pos \
 N_WLSEL\<1066\>_XI2\<1\>\/XI2\<0\>\/XI2\<0\>\/XI2\<0\>\/XI2\<0\>\/XI2\<1\>\/XI2\<0\>\/XI2\<1\>\/RR2_neg \
 ) R_1X_LL w=1e-07 l=1e-07   res=0.149966
XXI2\<1\>\/XI2\<0\>\/XI2\<0\>\/XI2\<0\>\/XI2\<0\>\/XI2\<1\>\/XI2\<0\>\/XI2\<1\>\/RR3 \
 (  \
 N_SEL3\<0\>_XI2\<1\>\/XI2\<0\>\/XI2\<0\>\/XI2\<0\>\/XI2\<0\>\/XI2\<1\>\/XI2\<0\>\/XI2\<1\>\/RR3_pos \
 N_WLSEL\<1067\>_XI2\<1\>\/XI2\<0\>\/XI2\<0\>\/XI2\<0\>\/XI2\<0\>\/XI2\<1\>\/XI2\<0\>\/XI2\<1\>\/RR3_neg \
 ) R_1X_LL w=1e-07 l=1e-07   res=0.149966
XXI2\<1\>\/XI2\<0\>\/XI2\<0\>\/XI2\<0\>\/XI2\<0\>\/XI2\<1\>\/XI2\<0\>\/XI2\<1\>\/RR4 \
 (  \
 N_SEL4\<0\>_XI2\<1\>\/XI2\<0\>\/XI2\<0\>\/XI2\<0\>\/XI2\<0\>\/XI2\<1\>\/XI2\<0\>\/XI2\<1\>\/RR4_pos \
 N_WLSEL\<1068\>_XI2\<1\>\/XI2\<0\>\/XI2\<0\>\/XI2\<0\>\/XI2\<0\>\/XI2\<1\>\/XI2\<0\>\/XI2\<1\>\/RR4_neg \
 ) R_1X_LL w=1e-07 l=1e-07   res=0.149966
XXI2\<1\>\/XI2\<0\>\/XI2\<0\>\/XI2\<0\>\/XI2\<0\>\/XI2\<1\>\/XI2\<0\>\/XI2\<1\>\/RR7 \
 (  \
 N_SEL5\<0\>_XI2\<1\>\/XI2\<0\>\/XI2\<0\>\/XI2\<0\>\/XI2\<0\>\/XI2\<1\>\/XI2\<0\>\/XI2\<1\>\/RR7_pos \
 N_WLSEL\<1069\>_XI2\<1\>\/XI2\<0\>\/XI2\<0\>\/XI2\<0\>\/XI2\<0\>\/XI2\<1\>\/XI2\<0\>\/XI2\<1\>\/RR7_neg \
 ) R_1X_LL w=1e-07 l=1e-07   res=0.149966
XXI2\<1\>\/XI2\<0\>\/XI2\<0\>\/XI2\<0\>\/XI2\<0\>\/XI2\<1\>\/XI2\<0\>\/XI2\<1\>\/RR6 \
 (  \
 N_SEL6\<0\>_XI2\<1\>\/XI2\<0\>\/XI2\<0\>\/XI2\<0\>\/XI2\<0\>\/XI2\<1\>\/XI2\<0\>\/XI2\<1\>\/RR6_pos \
 N_WLSEL\<1070\>_XI2\<1\>\/XI2\<0\>\/XI2\<0\>\/XI2\<0\>\/XI2\<0\>\/XI2\<1\>\/XI2\<0\>\/XI2\<1\>\/RR6_neg \
 ) R_1X_LL w=1e-07 l=1e-07   res=0.149966
XXI2\<1\>\/XI2\<0\>\/XI2\<0\>\/XI2\<0\>\/XI2\<0\>\/XI2\<1\>\/XI2\<0\>\/XI2\<1\>\/RR5 \
 (  \
 N_SEL7\<1\>_XI2\<1\>\/XI2\<0\>\/XI2\<0\>\/XI2\<0\>\/XI2\<0\>\/XI2\<1\>\/XI2\<0\>\/XI2\<1\>\/RR5_pos \
 N_WLSEL\<1071\>_XI2\<1\>\/XI2\<0\>\/XI2\<0\>\/XI2\<0\>\/XI2\<0\>\/XI2\<1\>\/XI2\<0\>\/XI2\<1\>\/RR5_neg \
 ) R_1X_LL w=1e-07 l=1e-07   res=0.149966
XXI2\<1\>\/XI2\<0\>\/XI2\<0\>\/XI2\<0\>\/XI2\<0\>\/XI2\<1\>\/XI2\<1\>\/XI2\<0\>\/RR0 \
 (  \
 N_SEL0\<0\>_XI2\<1\>\/XI2\<0\>\/XI2\<0\>\/XI2\<0\>\/XI2\<0\>\/XI2\<1\>\/XI2\<1\>\/XI2\<0\>\/RR0_pos \
 N_WLSEL\<1072\>_XI2\<1\>\/XI2\<0\>\/XI2\<0\>\/XI2\<0\>\/XI2\<0\>\/XI2\<1\>\/XI2\<1\>\/XI2\<0\>\/RR0_neg \
 ) R_1X_LL w=1e-07 l=1e-07   res=0.149966
XXI2\<1\>\/XI2\<0\>\/XI2\<0\>\/XI2\<0\>\/XI2\<0\>\/XI2\<1\>\/XI2\<1\>\/XI2\<0\>\/RR1 \
 (  \
 N_SEL1\<1\>_XI2\<1\>\/XI2\<0\>\/XI2\<0\>\/XI2\<0\>\/XI2\<0\>\/XI2\<1\>\/XI2\<1\>\/XI2\<0\>\/RR1_pos \
 N_WLSEL\<1073\>_XI2\<1\>\/XI2\<0\>\/XI2\<0\>\/XI2\<0\>\/XI2\<0\>\/XI2\<1\>\/XI2\<1\>\/XI2\<0\>\/RR1_neg \
 ) R_1X_LL w=1e-07 l=1e-07   res=0.149966
XXI2\<1\>\/XI2\<0\>\/XI2\<0\>\/XI2\<0\>\/XI2\<0\>\/XI2\<1\>\/XI2\<1\>\/XI2\<0\>\/RR2 \
 (  \
 N_SEL2\<1\>_XI2\<1\>\/XI2\<0\>\/XI2\<0\>\/XI2\<0\>\/XI2\<0\>\/XI2\<1\>\/XI2\<1\>\/XI2\<0\>\/RR2_pos \
 N_WLSEL\<1074\>_XI2\<1\>\/XI2\<0\>\/XI2\<0\>\/XI2\<0\>\/XI2\<0\>\/XI2\<1\>\/XI2\<1\>\/XI2\<0\>\/RR2_neg \
 ) R_1X_LL w=1e-07 l=1e-07   res=0.149966
XXI2\<1\>\/XI2\<0\>\/XI2\<0\>\/XI2\<0\>\/XI2\<0\>\/XI2\<1\>\/XI2\<1\>\/XI2\<0\>\/RR3 \
 (  \
 N_SEL3\<0\>_XI2\<1\>\/XI2\<0\>\/XI2\<0\>\/XI2\<0\>\/XI2\<0\>\/XI2\<1\>\/XI2\<1\>\/XI2\<0\>\/RR3_pos \
 N_WLSEL\<1075\>_XI2\<1\>\/XI2\<0\>\/XI2\<0\>\/XI2\<0\>\/XI2\<0\>\/XI2\<1\>\/XI2\<1\>\/XI2\<0\>\/RR3_neg \
 ) R_1X_LL w=1e-07 l=1e-07   res=0.149966
XXI2\<1\>\/XI2\<0\>\/XI2\<0\>\/XI2\<0\>\/XI2\<0\>\/XI2\<1\>\/XI2\<1\>\/XI2\<0\>\/RR4 \
 (  \
 N_SEL4\<0\>_XI2\<1\>\/XI2\<0\>\/XI2\<0\>\/XI2\<0\>\/XI2\<0\>\/XI2\<1\>\/XI2\<1\>\/XI2\<0\>\/RR4_pos \
 N_WLSEL\<1076\>_XI2\<1\>\/XI2\<0\>\/XI2\<0\>\/XI2\<0\>\/XI2\<0\>\/XI2\<1\>\/XI2\<1\>\/XI2\<0\>\/RR4_neg \
 ) R_1X_LL w=1e-07 l=1e-07   res=0.149966
XXI2\<1\>\/XI2\<0\>\/XI2\<0\>\/XI2\<0\>\/XI2\<0\>\/XI2\<1\>\/XI2\<1\>\/XI2\<0\>\/RR7 \
 (  \
 N_SEL5\<0\>_XI2\<1\>\/XI2\<0\>\/XI2\<0\>\/XI2\<0\>\/XI2\<0\>\/XI2\<1\>\/XI2\<1\>\/XI2\<0\>\/RR7_pos \
 N_WLSEL\<1077\>_XI2\<1\>\/XI2\<0\>\/XI2\<0\>\/XI2\<0\>\/XI2\<0\>\/XI2\<1\>\/XI2\<1\>\/XI2\<0\>\/RR7_neg \
 ) R_1X_LL w=1e-07 l=1e-07   res=0.149966
XXI2\<1\>\/XI2\<0\>\/XI2\<0\>\/XI2\<0\>\/XI2\<0\>\/XI2\<1\>\/XI2\<1\>\/XI2\<0\>\/RR6 \
 (  \
 N_SEL6\<0\>_XI2\<1\>\/XI2\<0\>\/XI2\<0\>\/XI2\<0\>\/XI2\<0\>\/XI2\<1\>\/XI2\<1\>\/XI2\<0\>\/RR6_pos \
 N_WLSEL\<1078\>_XI2\<1\>\/XI2\<0\>\/XI2\<0\>\/XI2\<0\>\/XI2\<0\>\/XI2\<1\>\/XI2\<1\>\/XI2\<0\>\/RR6_neg \
 ) R_1X_LL w=1e-07 l=1e-07   res=0.149966
XXI2\<1\>\/XI2\<0\>\/XI2\<0\>\/XI2\<0\>\/XI2\<0\>\/XI2\<1\>\/XI2\<1\>\/XI2\<0\>\/RR5 \
 (  \
 N_SEL7\<1\>_XI2\<1\>\/XI2\<0\>\/XI2\<0\>\/XI2\<0\>\/XI2\<0\>\/XI2\<1\>\/XI2\<1\>\/XI2\<0\>\/RR5_pos \
 N_WLSEL\<1079\>_XI2\<1\>\/XI2\<0\>\/XI2\<0\>\/XI2\<0\>\/XI2\<0\>\/XI2\<1\>\/XI2\<1\>\/XI2\<0\>\/RR5_neg \
 ) R_1X_LL w=1e-07 l=1e-07   res=0.149966
XXI2\<1\>\/XI2\<0\>\/XI2\<0\>\/XI2\<0\>\/XI2\<0\>\/XI2\<1\>\/XI2\<1\>\/XI2\<1\>\/RR0 \
 (  \
 N_SEL0\<1\>_XI2\<1\>\/XI2\<0\>\/XI2\<0\>\/XI2\<0\>\/XI2\<0\>\/XI2\<1\>\/XI2\<1\>\/XI2\<1\>\/RR0_pos \
 N_WLSEL\<1080\>_XI2\<1\>\/XI2\<0\>\/XI2\<0\>\/XI2\<0\>\/XI2\<0\>\/XI2\<1\>\/XI2\<1\>\/XI2\<1\>\/RR0_neg \
 ) R_1X_LL w=1e-07 l=1e-07   res=0.149966
XXI2\<1\>\/XI2\<0\>\/XI2\<0\>\/XI2\<0\>\/XI2\<0\>\/XI2\<1\>\/XI2\<1\>\/XI2\<1\>\/RR1 \
 (  \
 N_SEL1\<1\>_XI2\<1\>\/XI2\<0\>\/XI2\<0\>\/XI2\<0\>\/XI2\<0\>\/XI2\<1\>\/XI2\<1\>\/XI2\<1\>\/RR1_pos \
 N_WLSEL\<1081\>_XI2\<1\>\/XI2\<0\>\/XI2\<0\>\/XI2\<0\>\/XI2\<0\>\/XI2\<1\>\/XI2\<1\>\/XI2\<1\>\/RR1_neg \
 ) R_1X_LL w=1e-07 l=1e-07   res=0.149966
XXI2\<1\>\/XI2\<0\>\/XI2\<0\>\/XI2\<0\>\/XI2\<0\>\/XI2\<1\>\/XI2\<1\>\/XI2\<1\>\/RR2 \
 (  \
 N_SEL2\<1\>_XI2\<1\>\/XI2\<0\>\/XI2\<0\>\/XI2\<0\>\/XI2\<0\>\/XI2\<1\>\/XI2\<1\>\/XI2\<1\>\/RR2_pos \
 N_WLSEL\<1082\>_XI2\<1\>\/XI2\<0\>\/XI2\<0\>\/XI2\<0\>\/XI2\<0\>\/XI2\<1\>\/XI2\<1\>\/XI2\<1\>\/RR2_neg \
 ) R_1X_LL w=1e-07 l=1e-07   res=0.149966
XXI2\<1\>\/XI2\<0\>\/XI2\<0\>\/XI2\<0\>\/XI2\<0\>\/XI2\<1\>\/XI2\<1\>\/XI2\<1\>\/RR3 \
 (  \
 N_SEL3\<0\>_XI2\<1\>\/XI2\<0\>\/XI2\<0\>\/XI2\<0\>\/XI2\<0\>\/XI2\<1\>\/XI2\<1\>\/XI2\<1\>\/RR3_pos \
 N_WLSEL\<1083\>_XI2\<1\>\/XI2\<0\>\/XI2\<0\>\/XI2\<0\>\/XI2\<0\>\/XI2\<1\>\/XI2\<1\>\/XI2\<1\>\/RR3_neg \
 ) R_1X_LL w=1e-07 l=1e-07   res=0.149966
XXI2\<1\>\/XI2\<0\>\/XI2\<0\>\/XI2\<0\>\/XI2\<0\>\/XI2\<1\>\/XI2\<1\>\/XI2\<1\>\/RR4 \
 (  \
 N_SEL4\<0\>_XI2\<1\>\/XI2\<0\>\/XI2\<0\>\/XI2\<0\>\/XI2\<0\>\/XI2\<1\>\/XI2\<1\>\/XI2\<1\>\/RR4_pos \
 N_WLSEL\<1084\>_XI2\<1\>\/XI2\<0\>\/XI2\<0\>\/XI2\<0\>\/XI2\<0\>\/XI2\<1\>\/XI2\<1\>\/XI2\<1\>\/RR4_neg \
 ) R_1X_LL w=1e-07 l=1e-07   res=0.149966
XXI2\<1\>\/XI2\<0\>\/XI2\<0\>\/XI2\<0\>\/XI2\<0\>\/XI2\<1\>\/XI2\<1\>\/XI2\<1\>\/RR7 \
 (  \
 N_SEL5\<0\>_XI2\<1\>\/XI2\<0\>\/XI2\<0\>\/XI2\<0\>\/XI2\<0\>\/XI2\<1\>\/XI2\<1\>\/XI2\<1\>\/RR7_pos \
 N_WLSEL\<1085\>_XI2\<1\>\/XI2\<0\>\/XI2\<0\>\/XI2\<0\>\/XI2\<0\>\/XI2\<1\>\/XI2\<1\>\/XI2\<1\>\/RR7_neg \
 ) R_1X_LL w=1e-07 l=1e-07   res=0.149966
XXI2\<1\>\/XI2\<0\>\/XI2\<0\>\/XI2\<0\>\/XI2\<0\>\/XI2\<1\>\/XI2\<1\>\/XI2\<1\>\/RR6 \
 (  \
 N_SEL6\<0\>_XI2\<1\>\/XI2\<0\>\/XI2\<0\>\/XI2\<0\>\/XI2\<0\>\/XI2\<1\>\/XI2\<1\>\/XI2\<1\>\/RR6_pos \
 N_WLSEL\<1086\>_XI2\<1\>\/XI2\<0\>\/XI2\<0\>\/XI2\<0\>\/XI2\<0\>\/XI2\<1\>\/XI2\<1\>\/XI2\<1\>\/RR6_neg \
 ) R_1X_LL w=1e-07 l=1e-07   res=0.149966
XXI2\<1\>\/XI2\<0\>\/XI2\<0\>\/XI2\<0\>\/XI2\<0\>\/XI2\<1\>\/XI2\<1\>\/XI2\<1\>\/RR5 \
 (  \
 N_SEL7\<1\>_XI2\<1\>\/XI2\<0\>\/XI2\<0\>\/XI2\<0\>\/XI2\<0\>\/XI2\<1\>\/XI2\<1\>\/XI2\<1\>\/RR5_pos \
 N_WLSEL\<1087\>_XI2\<1\>\/XI2\<0\>\/XI2\<0\>\/XI2\<0\>\/XI2\<0\>\/XI2\<1\>\/XI2\<1\>\/XI2\<1\>\/RR5_neg \
 ) R_1X_LL w=1e-07 l=1e-07   res=0.149966
XXI2\<1\>\/XI2\<0\>\/XI2\<0\>\/XI2\<0\>\/XI2\<1\>\/XI2\<0\>\/XI2\<0\>\/XI2\<0\>\/RR0 \
 (  \
 N_SEL0\<0\>_XI2\<1\>\/XI2\<0\>\/XI2\<0\>\/XI2\<0\>\/XI2\<1\>\/XI2\<0\>\/XI2\<0\>\/XI2\<0\>\/RR0_pos \
 N_WLSEL\<1088\>_XI2\<1\>\/XI2\<0\>\/XI2\<0\>\/XI2\<0\>\/XI2\<1\>\/XI2\<0\>\/XI2\<0\>\/XI2\<0\>\/RR0_neg \
 ) R_1X_LL w=1e-07 l=1e-07   res=0.149966
XXI2\<1\>\/XI2\<0\>\/XI2\<0\>\/XI2\<0\>\/XI2\<1\>\/XI2\<0\>\/XI2\<0\>\/XI2\<0\>\/RR1 \
 (  \
 N_SEL1\<0\>_XI2\<1\>\/XI2\<0\>\/XI2\<0\>\/XI2\<0\>\/XI2\<1\>\/XI2\<0\>\/XI2\<0\>\/XI2\<0\>\/RR1_pos \
 N_WLSEL\<1089\>_XI2\<1\>\/XI2\<0\>\/XI2\<0\>\/XI2\<0\>\/XI2\<1\>\/XI2\<0\>\/XI2\<0\>\/XI2\<0\>\/RR1_neg \
 ) R_1X_LL w=1e-07 l=1e-07   res=0.149966
XXI2\<1\>\/XI2\<0\>\/XI2\<0\>\/XI2\<0\>\/XI2\<1\>\/XI2\<0\>\/XI2\<0\>\/XI2\<0\>\/RR2 \
 (  \
 N_SEL2\<0\>_XI2\<1\>\/XI2\<0\>\/XI2\<0\>\/XI2\<0\>\/XI2\<1\>\/XI2\<0\>\/XI2\<0\>\/XI2\<0\>\/RR2_pos \
 N_WLSEL\<1090\>_XI2\<1\>\/XI2\<0\>\/XI2\<0\>\/XI2\<0\>\/XI2\<1\>\/XI2\<0\>\/XI2\<0\>\/XI2\<0\>\/RR2_neg \
 ) R_1X_LL w=1e-07 l=1e-07   res=0.149966
XXI2\<1\>\/XI2\<0\>\/XI2\<0\>\/XI2\<0\>\/XI2\<1\>\/XI2\<0\>\/XI2\<0\>\/XI2\<0\>\/RR3 \
 (  \
 N_SEL3\<1\>_XI2\<1\>\/XI2\<0\>\/XI2\<0\>\/XI2\<0\>\/XI2\<1\>\/XI2\<0\>\/XI2\<0\>\/XI2\<0\>\/RR3_pos \
 N_WLSEL\<1091\>_XI2\<1\>\/XI2\<0\>\/XI2\<0\>\/XI2\<0\>\/XI2\<1\>\/XI2\<0\>\/XI2\<0\>\/XI2\<0\>\/RR3_neg \
 ) R_1X_LL w=1e-07 l=1e-07   res=0.149966
XXI2\<1\>\/XI2\<0\>\/XI2\<0\>\/XI2\<0\>\/XI2\<1\>\/XI2\<0\>\/XI2\<0\>\/XI2\<0\>\/RR4 \
 (  \
 N_SEL4\<0\>_XI2\<1\>\/XI2\<0\>\/XI2\<0\>\/XI2\<0\>\/XI2\<1\>\/XI2\<0\>\/XI2\<0\>\/XI2\<0\>\/RR4_pos \
 N_WLSEL\<1092\>_XI2\<1\>\/XI2\<0\>\/XI2\<0\>\/XI2\<0\>\/XI2\<1\>\/XI2\<0\>\/XI2\<0\>\/XI2\<0\>\/RR4_neg \
 ) R_1X_LL w=1e-07 l=1e-07   res=0.149966
XXI2\<1\>\/XI2\<0\>\/XI2\<0\>\/XI2\<0\>\/XI2\<1\>\/XI2\<0\>\/XI2\<0\>\/XI2\<0\>\/RR7 \
 (  \
 N_SEL5\<0\>_XI2\<1\>\/XI2\<0\>\/XI2\<0\>\/XI2\<0\>\/XI2\<1\>\/XI2\<0\>\/XI2\<0\>\/XI2\<0\>\/RR7_pos \
 N_WLSEL\<1093\>_XI2\<1\>\/XI2\<0\>\/XI2\<0\>\/XI2\<0\>\/XI2\<1\>\/XI2\<0\>\/XI2\<0\>\/XI2\<0\>\/RR7_neg \
 ) R_1X_LL w=1e-07 l=1e-07   res=0.149966
XXI2\<1\>\/XI2\<0\>\/XI2\<0\>\/XI2\<0\>\/XI2\<1\>\/XI2\<0\>\/XI2\<0\>\/XI2\<0\>\/RR6 \
 (  \
 N_SEL6\<0\>_XI2\<1\>\/XI2\<0\>\/XI2\<0\>\/XI2\<0\>\/XI2\<1\>\/XI2\<0\>\/XI2\<0\>\/XI2\<0\>\/RR6_pos \
 N_WLSEL\<1094\>_XI2\<1\>\/XI2\<0\>\/XI2\<0\>\/XI2\<0\>\/XI2\<1\>\/XI2\<0\>\/XI2\<0\>\/XI2\<0\>\/RR6_neg \
 ) R_1X_LL w=1e-07 l=1e-07   res=0.149966
XXI2\<1\>\/XI2\<0\>\/XI2\<0\>\/XI2\<0\>\/XI2\<1\>\/XI2\<0\>\/XI2\<0\>\/XI2\<0\>\/RR5 \
 (  \
 N_SEL7\<1\>_XI2\<1\>\/XI2\<0\>\/XI2\<0\>\/XI2\<0\>\/XI2\<1\>\/XI2\<0\>\/XI2\<0\>\/XI2\<0\>\/RR5_pos \
 N_WLSEL\<1095\>_XI2\<1\>\/XI2\<0\>\/XI2\<0\>\/XI2\<0\>\/XI2\<1\>\/XI2\<0\>\/XI2\<0\>\/XI2\<0\>\/RR5_neg \
 ) R_1X_LL w=1e-07 l=1e-07   res=0.149966
XXI2\<1\>\/XI2\<0\>\/XI2\<0\>\/XI2\<0\>\/XI2\<1\>\/XI2\<0\>\/XI2\<0\>\/XI2\<1\>\/RR0 \
 (  \
 N_SEL0\<1\>_XI2\<1\>\/XI2\<0\>\/XI2\<0\>\/XI2\<0\>\/XI2\<1\>\/XI2\<0\>\/XI2\<0\>\/XI2\<1\>\/RR0_pos \
 N_WLSEL\<1096\>_XI2\<1\>\/XI2\<0\>\/XI2\<0\>\/XI2\<0\>\/XI2\<1\>\/XI2\<0\>\/XI2\<0\>\/XI2\<1\>\/RR0_neg \
 ) R_1X_LL w=1e-07 l=1e-07   res=0.149966
XXI2\<1\>\/XI2\<0\>\/XI2\<0\>\/XI2\<0\>\/XI2\<1\>\/XI2\<0\>\/XI2\<0\>\/XI2\<1\>\/RR1 \
 (  \
 N_SEL1\<0\>_XI2\<1\>\/XI2\<0\>\/XI2\<0\>\/XI2\<0\>\/XI2\<1\>\/XI2\<0\>\/XI2\<0\>\/XI2\<1\>\/RR1_pos \
 N_WLSEL\<1097\>_XI2\<1\>\/XI2\<0\>\/XI2\<0\>\/XI2\<0\>\/XI2\<1\>\/XI2\<0\>\/XI2\<0\>\/XI2\<1\>\/RR1_neg \
 ) R_1X_LL w=1e-07 l=1e-07   res=0.149966
XXI2\<1\>\/XI2\<0\>\/XI2\<0\>\/XI2\<0\>\/XI2\<1\>\/XI2\<0\>\/XI2\<0\>\/XI2\<1\>\/RR2 \
 (  \
 N_SEL2\<0\>_XI2\<1\>\/XI2\<0\>\/XI2\<0\>\/XI2\<0\>\/XI2\<1\>\/XI2\<0\>\/XI2\<0\>\/XI2\<1\>\/RR2_pos \
 N_WLSEL\<1098\>_XI2\<1\>\/XI2\<0\>\/XI2\<0\>\/XI2\<0\>\/XI2\<1\>\/XI2\<0\>\/XI2\<0\>\/XI2\<1\>\/RR2_neg \
 ) R_1X_LL w=1e-07 l=1e-07   res=0.149966
XXI2\<1\>\/XI2\<0\>\/XI2\<0\>\/XI2\<0\>\/XI2\<1\>\/XI2\<0\>\/XI2\<0\>\/XI2\<1\>\/RR3 \
 (  \
 N_SEL3\<1\>_XI2\<1\>\/XI2\<0\>\/XI2\<0\>\/XI2\<0\>\/XI2\<1\>\/XI2\<0\>\/XI2\<0\>\/XI2\<1\>\/RR3_pos \
 N_WLSEL\<1099\>_XI2\<1\>\/XI2\<0\>\/XI2\<0\>\/XI2\<0\>\/XI2\<1\>\/XI2\<0\>\/XI2\<0\>\/XI2\<1\>\/RR3_neg \
 ) R_1X_LL w=1e-07 l=1e-07   res=0.149966
XXI2\<1\>\/XI2\<0\>\/XI2\<0\>\/XI2\<0\>\/XI2\<1\>\/XI2\<0\>\/XI2\<0\>\/XI2\<1\>\/RR4 \
 (  \
 N_SEL4\<0\>_XI2\<1\>\/XI2\<0\>\/XI2\<0\>\/XI2\<0\>\/XI2\<1\>\/XI2\<0\>\/XI2\<0\>\/XI2\<1\>\/RR4_pos \
 N_WLSEL\<1100\>_XI2\<1\>\/XI2\<0\>\/XI2\<0\>\/XI2\<0\>\/XI2\<1\>\/XI2\<0\>\/XI2\<0\>\/XI2\<1\>\/RR4_neg \
 ) R_1X_LL w=1e-07 l=1e-07   res=0.149966
XXI2\<1\>\/XI2\<0\>\/XI2\<0\>\/XI2\<0\>\/XI2\<1\>\/XI2\<0\>\/XI2\<0\>\/XI2\<1\>\/RR7 \
 (  \
 N_SEL5\<0\>_XI2\<1\>\/XI2\<0\>\/XI2\<0\>\/XI2\<0\>\/XI2\<1\>\/XI2\<0\>\/XI2\<0\>\/XI2\<1\>\/RR7_pos \
 N_WLSEL\<1101\>_XI2\<1\>\/XI2\<0\>\/XI2\<0\>\/XI2\<0\>\/XI2\<1\>\/XI2\<0\>\/XI2\<0\>\/XI2\<1\>\/RR7_neg \
 ) R_1X_LL w=1e-07 l=1e-07   res=0.149966
XXI2\<1\>\/XI2\<0\>\/XI2\<0\>\/XI2\<0\>\/XI2\<1\>\/XI2\<0\>\/XI2\<0\>\/XI2\<1\>\/RR6 \
 (  \
 N_SEL6\<0\>_XI2\<1\>\/XI2\<0\>\/XI2\<0\>\/XI2\<0\>\/XI2\<1\>\/XI2\<0\>\/XI2\<0\>\/XI2\<1\>\/RR6_pos \
 N_WLSEL\<1102\>_XI2\<1\>\/XI2\<0\>\/XI2\<0\>\/XI2\<0\>\/XI2\<1\>\/XI2\<0\>\/XI2\<0\>\/XI2\<1\>\/RR6_neg \
 ) R_1X_LL w=1e-07 l=1e-07   res=0.149966
XXI2\<1\>\/XI2\<0\>\/XI2\<0\>\/XI2\<0\>\/XI2\<1\>\/XI2\<0\>\/XI2\<0\>\/XI2\<1\>\/RR5 \
 (  \
 N_SEL7\<1\>_XI2\<1\>\/XI2\<0\>\/XI2\<0\>\/XI2\<0\>\/XI2\<1\>\/XI2\<0\>\/XI2\<0\>\/XI2\<1\>\/RR5_pos \
 N_WLSEL\<1103\>_XI2\<1\>\/XI2\<0\>\/XI2\<0\>\/XI2\<0\>\/XI2\<1\>\/XI2\<0\>\/XI2\<0\>\/XI2\<1\>\/RR5_neg \
 ) R_1X_LL w=1e-07 l=1e-07   res=0.149966
XXI2\<1\>\/XI2\<0\>\/XI2\<0\>\/XI2\<0\>\/XI2\<1\>\/XI2\<0\>\/XI2\<1\>\/XI2\<0\>\/RR0 \
 (  \
 N_SEL0\<0\>_XI2\<1\>\/XI2\<0\>\/XI2\<0\>\/XI2\<0\>\/XI2\<1\>\/XI2\<0\>\/XI2\<1\>\/XI2\<0\>\/RR0_pos \
 N_WLSEL\<1104\>_XI2\<1\>\/XI2\<0\>\/XI2\<0\>\/XI2\<0\>\/XI2\<1\>\/XI2\<0\>\/XI2\<1\>\/XI2\<0\>\/RR0_neg \
 ) R_1X_LL w=1e-07 l=1e-07   res=0.149966
XXI2\<1\>\/XI2\<0\>\/XI2\<0\>\/XI2\<0\>\/XI2\<1\>\/XI2\<0\>\/XI2\<1\>\/XI2\<0\>\/RR1 \
 (  \
 N_SEL1\<1\>_XI2\<1\>\/XI2\<0\>\/XI2\<0\>\/XI2\<0\>\/XI2\<1\>\/XI2\<0\>\/XI2\<1\>\/XI2\<0\>\/RR1_pos \
 N_WLSEL\<1105\>_XI2\<1\>\/XI2\<0\>\/XI2\<0\>\/XI2\<0\>\/XI2\<1\>\/XI2\<0\>\/XI2\<1\>\/XI2\<0\>\/RR1_neg \
 ) R_1X_LL w=1e-07 l=1e-07   res=0.149966
XXI2\<1\>\/XI2\<0\>\/XI2\<0\>\/XI2\<0\>\/XI2\<1\>\/XI2\<0\>\/XI2\<1\>\/XI2\<0\>\/RR2 \
 (  \
 N_SEL2\<0\>_XI2\<1\>\/XI2\<0\>\/XI2\<0\>\/XI2\<0\>\/XI2\<1\>\/XI2\<0\>\/XI2\<1\>\/XI2\<0\>\/RR2_pos \
 N_WLSEL\<1106\>_XI2\<1\>\/XI2\<0\>\/XI2\<0\>\/XI2\<0\>\/XI2\<1\>\/XI2\<0\>\/XI2\<1\>\/XI2\<0\>\/RR2_neg \
 ) R_1X_LL w=1e-07 l=1e-07   res=0.149966
XXI2\<1\>\/XI2\<0\>\/XI2\<0\>\/XI2\<0\>\/XI2\<1\>\/XI2\<0\>\/XI2\<1\>\/XI2\<0\>\/RR3 \
 (  \
 N_SEL3\<1\>_XI2\<1\>\/XI2\<0\>\/XI2\<0\>\/XI2\<0\>\/XI2\<1\>\/XI2\<0\>\/XI2\<1\>\/XI2\<0\>\/RR3_pos \
 N_WLSEL\<1107\>_XI2\<1\>\/XI2\<0\>\/XI2\<0\>\/XI2\<0\>\/XI2\<1\>\/XI2\<0\>\/XI2\<1\>\/XI2\<0\>\/RR3_neg \
 ) R_1X_LL w=1e-07 l=1e-07   res=0.149966
XXI2\<1\>\/XI2\<0\>\/XI2\<0\>\/XI2\<0\>\/XI2\<1\>\/XI2\<0\>\/XI2\<1\>\/XI2\<0\>\/RR4 \
 (  \
 N_SEL4\<0\>_XI2\<1\>\/XI2\<0\>\/XI2\<0\>\/XI2\<0\>\/XI2\<1\>\/XI2\<0\>\/XI2\<1\>\/XI2\<0\>\/RR4_pos \
 N_WLSEL\<1108\>_XI2\<1\>\/XI2\<0\>\/XI2\<0\>\/XI2\<0\>\/XI2\<1\>\/XI2\<0\>\/XI2\<1\>\/XI2\<0\>\/RR4_neg \
 ) R_1X_LL w=1e-07 l=1e-07   res=0.149966
XXI2\<1\>\/XI2\<0\>\/XI2\<0\>\/XI2\<0\>\/XI2\<1\>\/XI2\<0\>\/XI2\<1\>\/XI2\<0\>\/RR7 \
 (  \
 N_SEL5\<0\>_XI2\<1\>\/XI2\<0\>\/XI2\<0\>\/XI2\<0\>\/XI2\<1\>\/XI2\<0\>\/XI2\<1\>\/XI2\<0\>\/RR7_pos \
 N_WLSEL\<1109\>_XI2\<1\>\/XI2\<0\>\/XI2\<0\>\/XI2\<0\>\/XI2\<1\>\/XI2\<0\>\/XI2\<1\>\/XI2\<0\>\/RR7_neg \
 ) R_1X_LL w=1e-07 l=1e-07   res=0.149966
XXI2\<1\>\/XI2\<0\>\/XI2\<0\>\/XI2\<0\>\/XI2\<1\>\/XI2\<0\>\/XI2\<1\>\/XI2\<0\>\/RR6 \
 (  \
 N_SEL6\<0\>_XI2\<1\>\/XI2\<0\>\/XI2\<0\>\/XI2\<0\>\/XI2\<1\>\/XI2\<0\>\/XI2\<1\>\/XI2\<0\>\/RR6_pos \
 N_WLSEL\<1110\>_XI2\<1\>\/XI2\<0\>\/XI2\<0\>\/XI2\<0\>\/XI2\<1\>\/XI2\<0\>\/XI2\<1\>\/XI2\<0\>\/RR6_neg \
 ) R_1X_LL w=1e-07 l=1e-07   res=0.149966
XXI2\<1\>\/XI2\<0\>\/XI2\<0\>\/XI2\<0\>\/XI2\<1\>\/XI2\<0\>\/XI2\<1\>\/XI2\<0\>\/RR5 \
 (  \
 N_SEL7\<1\>_XI2\<1\>\/XI2\<0\>\/XI2\<0\>\/XI2\<0\>\/XI2\<1\>\/XI2\<0\>\/XI2\<1\>\/XI2\<0\>\/RR5_pos \
 N_WLSEL\<1111\>_XI2\<1\>\/XI2\<0\>\/XI2\<0\>\/XI2\<0\>\/XI2\<1\>\/XI2\<0\>\/XI2\<1\>\/XI2\<0\>\/RR5_neg \
 ) R_1X_LL w=1e-07 l=1e-07   res=0.149966
XXI2\<1\>\/XI2\<0\>\/XI2\<0\>\/XI2\<0\>\/XI2\<1\>\/XI2\<0\>\/XI2\<1\>\/XI2\<1\>\/RR0 \
 (  \
 N_SEL0\<1\>_XI2\<1\>\/XI2\<0\>\/XI2\<0\>\/XI2\<0\>\/XI2\<1\>\/XI2\<0\>\/XI2\<1\>\/XI2\<1\>\/RR0_pos \
 N_WLSEL\<1112\>_XI2\<1\>\/XI2\<0\>\/XI2\<0\>\/XI2\<0\>\/XI2\<1\>\/XI2\<0\>\/XI2\<1\>\/XI2\<1\>\/RR0_neg \
 ) R_1X_LL w=1e-07 l=1e-07   res=0.149966
XXI2\<1\>\/XI2\<0\>\/XI2\<0\>\/XI2\<0\>\/XI2\<1\>\/XI2\<0\>\/XI2\<1\>\/XI2\<1\>\/RR1 \
 (  \
 N_SEL1\<1\>_XI2\<1\>\/XI2\<0\>\/XI2\<0\>\/XI2\<0\>\/XI2\<1\>\/XI2\<0\>\/XI2\<1\>\/XI2\<1\>\/RR1_pos \
 N_WLSEL\<1113\>_XI2\<1\>\/XI2\<0\>\/XI2\<0\>\/XI2\<0\>\/XI2\<1\>\/XI2\<0\>\/XI2\<1\>\/XI2\<1\>\/RR1_neg \
 ) R_1X_LL w=1e-07 l=1e-07   res=0.149966
XXI2\<1\>\/XI2\<0\>\/XI2\<0\>\/XI2\<0\>\/XI2\<1\>\/XI2\<0\>\/XI2\<1\>\/XI2\<1\>\/RR2 \
 (  \
 N_SEL2\<0\>_XI2\<1\>\/XI2\<0\>\/XI2\<0\>\/XI2\<0\>\/XI2\<1\>\/XI2\<0\>\/XI2\<1\>\/XI2\<1\>\/RR2_pos \
 N_WLSEL\<1114\>_XI2\<1\>\/XI2\<0\>\/XI2\<0\>\/XI2\<0\>\/XI2\<1\>\/XI2\<0\>\/XI2\<1\>\/XI2\<1\>\/RR2_neg \
 ) R_1X_LL w=1e-07 l=1e-07   res=0.149966
XXI2\<1\>\/XI2\<0\>\/XI2\<0\>\/XI2\<0\>\/XI2\<1\>\/XI2\<0\>\/XI2\<1\>\/XI2\<1\>\/RR3 \
 (  \
 N_SEL3\<1\>_XI2\<1\>\/XI2\<0\>\/XI2\<0\>\/XI2\<0\>\/XI2\<1\>\/XI2\<0\>\/XI2\<1\>\/XI2\<1\>\/RR3_pos \
 N_WLSEL\<1115\>_XI2\<1\>\/XI2\<0\>\/XI2\<0\>\/XI2\<0\>\/XI2\<1\>\/XI2\<0\>\/XI2\<1\>\/XI2\<1\>\/RR3_neg \
 ) R_1X_LL w=1e-07 l=1e-07   res=0.149966
XXI2\<1\>\/XI2\<0\>\/XI2\<0\>\/XI2\<0\>\/XI2\<1\>\/XI2\<0\>\/XI2\<1\>\/XI2\<1\>\/RR4 \
 (  \
 N_SEL4\<0\>_XI2\<1\>\/XI2\<0\>\/XI2\<0\>\/XI2\<0\>\/XI2\<1\>\/XI2\<0\>\/XI2\<1\>\/XI2\<1\>\/RR4_pos \
 N_WLSEL\<1116\>_XI2\<1\>\/XI2\<0\>\/XI2\<0\>\/XI2\<0\>\/XI2\<1\>\/XI2\<0\>\/XI2\<1\>\/XI2\<1\>\/RR4_neg \
 ) R_1X_LL w=1e-07 l=1e-07   res=0.149966
XXI2\<1\>\/XI2\<0\>\/XI2\<0\>\/XI2\<0\>\/XI2\<1\>\/XI2\<0\>\/XI2\<1\>\/XI2\<1\>\/RR7 \
 (  \
 N_SEL5\<0\>_XI2\<1\>\/XI2\<0\>\/XI2\<0\>\/XI2\<0\>\/XI2\<1\>\/XI2\<0\>\/XI2\<1\>\/XI2\<1\>\/RR7_pos \
 N_WLSEL\<1117\>_XI2\<1\>\/XI2\<0\>\/XI2\<0\>\/XI2\<0\>\/XI2\<1\>\/XI2\<0\>\/XI2\<1\>\/XI2\<1\>\/RR7_neg \
 ) R_1X_LL w=1e-07 l=1e-07   res=0.149966
XXI2\<1\>\/XI2\<0\>\/XI2\<0\>\/XI2\<0\>\/XI2\<1\>\/XI2\<0\>\/XI2\<1\>\/XI2\<1\>\/RR6 \
 (  \
 N_SEL6\<0\>_XI2\<1\>\/XI2\<0\>\/XI2\<0\>\/XI2\<0\>\/XI2\<1\>\/XI2\<0\>\/XI2\<1\>\/XI2\<1\>\/RR6_pos \
 N_WLSEL\<1118\>_XI2\<1\>\/XI2\<0\>\/XI2\<0\>\/XI2\<0\>\/XI2\<1\>\/XI2\<0\>\/XI2\<1\>\/XI2\<1\>\/RR6_neg \
 ) R_1X_LL w=1e-07 l=1e-07   res=0.149966
XXI2\<1\>\/XI2\<0\>\/XI2\<0\>\/XI2\<0\>\/XI2\<1\>\/XI2\<0\>\/XI2\<1\>\/XI2\<1\>\/RR5 \
 (  \
 N_SEL7\<1\>_XI2\<1\>\/XI2\<0\>\/XI2\<0\>\/XI2\<0\>\/XI2\<1\>\/XI2\<0\>\/XI2\<1\>\/XI2\<1\>\/RR5_pos \
 N_WLSEL\<1119\>_XI2\<1\>\/XI2\<0\>\/XI2\<0\>\/XI2\<0\>\/XI2\<1\>\/XI2\<0\>\/XI2\<1\>\/XI2\<1\>\/RR5_neg \
 ) R_1X_LL w=1e-07 l=1e-07   res=0.149966
XXI2\<1\>\/XI2\<0\>\/XI2\<0\>\/XI2\<0\>\/XI2\<1\>\/XI2\<1\>\/XI2\<0\>\/XI2\<0\>\/RR0 \
 (  \
 N_SEL0\<0\>_XI2\<1\>\/XI2\<0\>\/XI2\<0\>\/XI2\<0\>\/XI2\<1\>\/XI2\<1\>\/XI2\<0\>\/XI2\<0\>\/RR0_pos \
 N_WLSEL\<1120\>_XI2\<1\>\/XI2\<0\>\/XI2\<0\>\/XI2\<0\>\/XI2\<1\>\/XI2\<1\>\/XI2\<0\>\/XI2\<0\>\/RR0_neg \
 ) R_1X_LL w=1e-07 l=1e-07   res=0.149966
XXI2\<1\>\/XI2\<0\>\/XI2\<0\>\/XI2\<0\>\/XI2\<1\>\/XI2\<1\>\/XI2\<0\>\/XI2\<0\>\/RR1 \
 (  \
 N_SEL1\<0\>_XI2\<1\>\/XI2\<0\>\/XI2\<0\>\/XI2\<0\>\/XI2\<1\>\/XI2\<1\>\/XI2\<0\>\/XI2\<0\>\/RR1_pos \
 N_WLSEL\<1121\>_XI2\<1\>\/XI2\<0\>\/XI2\<0\>\/XI2\<0\>\/XI2\<1\>\/XI2\<1\>\/XI2\<0\>\/XI2\<0\>\/RR1_neg \
 ) R_1X_LL w=1e-07 l=1e-07   res=0.149966
XXI2\<1\>\/XI2\<0\>\/XI2\<0\>\/XI2\<0\>\/XI2\<1\>\/XI2\<1\>\/XI2\<0\>\/XI2\<0\>\/RR2 \
 (  \
 N_SEL2\<1\>_XI2\<1\>\/XI2\<0\>\/XI2\<0\>\/XI2\<0\>\/XI2\<1\>\/XI2\<1\>\/XI2\<0\>\/XI2\<0\>\/RR2_pos \
 N_WLSEL\<1122\>_XI2\<1\>\/XI2\<0\>\/XI2\<0\>\/XI2\<0\>\/XI2\<1\>\/XI2\<1\>\/XI2\<0\>\/XI2\<0\>\/RR2_neg \
 ) R_1X_LL w=1e-07 l=1e-07   res=0.149966
XXI2\<1\>\/XI2\<0\>\/XI2\<0\>\/XI2\<0\>\/XI2\<1\>\/XI2\<1\>\/XI2\<0\>\/XI2\<0\>\/RR3 \
 (  \
 N_SEL3\<1\>_XI2\<1\>\/XI2\<0\>\/XI2\<0\>\/XI2\<0\>\/XI2\<1\>\/XI2\<1\>\/XI2\<0\>\/XI2\<0\>\/RR3_pos \
 N_WLSEL\<1123\>_XI2\<1\>\/XI2\<0\>\/XI2\<0\>\/XI2\<0\>\/XI2\<1\>\/XI2\<1\>\/XI2\<0\>\/XI2\<0\>\/RR3_neg \
 ) R_1X_LL w=1e-07 l=1e-07   res=0.149966
XXI2\<1\>\/XI2\<0\>\/XI2\<0\>\/XI2\<0\>\/XI2\<1\>\/XI2\<1\>\/XI2\<0\>\/XI2\<0\>\/RR4 \
 (  \
 N_SEL4\<0\>_XI2\<1\>\/XI2\<0\>\/XI2\<0\>\/XI2\<0\>\/XI2\<1\>\/XI2\<1\>\/XI2\<0\>\/XI2\<0\>\/RR4_pos \
 N_WLSEL\<1124\>_XI2\<1\>\/XI2\<0\>\/XI2\<0\>\/XI2\<0\>\/XI2\<1\>\/XI2\<1\>\/XI2\<0\>\/XI2\<0\>\/RR4_neg \
 ) R_1X_LL w=1e-07 l=1e-07   res=0.149966
XXI2\<1\>\/XI2\<0\>\/XI2\<0\>\/XI2\<0\>\/XI2\<1\>\/XI2\<1\>\/XI2\<0\>\/XI2\<0\>\/RR7 \
 (  \
 N_SEL5\<0\>_XI2\<1\>\/XI2\<0\>\/XI2\<0\>\/XI2\<0\>\/XI2\<1\>\/XI2\<1\>\/XI2\<0\>\/XI2\<0\>\/RR7_pos \
 N_WLSEL\<1125\>_XI2\<1\>\/XI2\<0\>\/XI2\<0\>\/XI2\<0\>\/XI2\<1\>\/XI2\<1\>\/XI2\<0\>\/XI2\<0\>\/RR7_neg \
 ) R_1X_LL w=1e-07 l=1e-07   res=0.149966
XXI2\<1\>\/XI2\<0\>\/XI2\<0\>\/XI2\<0\>\/XI2\<1\>\/XI2\<1\>\/XI2\<0\>\/XI2\<0\>\/RR6 \
 (  \
 N_SEL6\<0\>_XI2\<1\>\/XI2\<0\>\/XI2\<0\>\/XI2\<0\>\/XI2\<1\>\/XI2\<1\>\/XI2\<0\>\/XI2\<0\>\/RR6_pos \
 N_WLSEL\<1126\>_XI2\<1\>\/XI2\<0\>\/XI2\<0\>\/XI2\<0\>\/XI2\<1\>\/XI2\<1\>\/XI2\<0\>\/XI2\<0\>\/RR6_neg \
 ) R_1X_LL w=1e-07 l=1e-07   res=0.149966
XXI2\<1\>\/XI2\<0\>\/XI2\<0\>\/XI2\<0\>\/XI2\<1\>\/XI2\<1\>\/XI2\<0\>\/XI2\<0\>\/RR5 \
 (  \
 N_SEL7\<1\>_XI2\<1\>\/XI2\<0\>\/XI2\<0\>\/XI2\<0\>\/XI2\<1\>\/XI2\<1\>\/XI2\<0\>\/XI2\<0\>\/RR5_pos \
 N_WLSEL\<1127\>_XI2\<1\>\/XI2\<0\>\/XI2\<0\>\/XI2\<0\>\/XI2\<1\>\/XI2\<1\>\/XI2\<0\>\/XI2\<0\>\/RR5_neg \
 ) R_1X_LL w=1e-07 l=1e-07   res=0.149966
XXI2\<1\>\/XI2\<0\>\/XI2\<0\>\/XI2\<0\>\/XI2\<1\>\/XI2\<1\>\/XI2\<0\>\/XI2\<1\>\/RR0 \
 (  \
 N_SEL0\<1\>_XI2\<1\>\/XI2\<0\>\/XI2\<0\>\/XI2\<0\>\/XI2\<1\>\/XI2\<1\>\/XI2\<0\>\/XI2\<1\>\/RR0_pos \
 N_WLSEL\<1128\>_XI2\<1\>\/XI2\<0\>\/XI2\<0\>\/XI2\<0\>\/XI2\<1\>\/XI2\<1\>\/XI2\<0\>\/XI2\<1\>\/RR0_neg \
 ) R_1X_LL w=1e-07 l=1e-07   res=0.149966
XXI2\<1\>\/XI2\<0\>\/XI2\<0\>\/XI2\<0\>\/XI2\<1\>\/XI2\<1\>\/XI2\<0\>\/XI2\<1\>\/RR1 \
 (  \
 N_SEL1\<0\>_XI2\<1\>\/XI2\<0\>\/XI2\<0\>\/XI2\<0\>\/XI2\<1\>\/XI2\<1\>\/XI2\<0\>\/XI2\<1\>\/RR1_pos \
 N_WLSEL\<1129\>_XI2\<1\>\/XI2\<0\>\/XI2\<0\>\/XI2\<0\>\/XI2\<1\>\/XI2\<1\>\/XI2\<0\>\/XI2\<1\>\/RR1_neg \
 ) R_1X_LL w=1e-07 l=1e-07   res=0.149966
XXI2\<1\>\/XI2\<0\>\/XI2\<0\>\/XI2\<0\>\/XI2\<1\>\/XI2\<1\>\/XI2\<0\>\/XI2\<1\>\/RR2 \
 (  \
 N_SEL2\<1\>_XI2\<1\>\/XI2\<0\>\/XI2\<0\>\/XI2\<0\>\/XI2\<1\>\/XI2\<1\>\/XI2\<0\>\/XI2\<1\>\/RR2_pos \
 N_WLSEL\<1130\>_XI2\<1\>\/XI2\<0\>\/XI2\<0\>\/XI2\<0\>\/XI2\<1\>\/XI2\<1\>\/XI2\<0\>\/XI2\<1\>\/RR2_neg \
 ) R_1X_LL w=1e-07 l=1e-07   res=0.149966
XXI2\<1\>\/XI2\<0\>\/XI2\<0\>\/XI2\<0\>\/XI2\<1\>\/XI2\<1\>\/XI2\<0\>\/XI2\<1\>\/RR3 \
 (  \
 N_SEL3\<1\>_XI2\<1\>\/XI2\<0\>\/XI2\<0\>\/XI2\<0\>\/XI2\<1\>\/XI2\<1\>\/XI2\<0\>\/XI2\<1\>\/RR3_pos \
 N_WLSEL\<1131\>_XI2\<1\>\/XI2\<0\>\/XI2\<0\>\/XI2\<0\>\/XI2\<1\>\/XI2\<1\>\/XI2\<0\>\/XI2\<1\>\/RR3_neg \
 ) R_1X_LL w=1e-07 l=1e-07   res=0.149966
XXI2\<1\>\/XI2\<0\>\/XI2\<0\>\/XI2\<0\>\/XI2\<1\>\/XI2\<1\>\/XI2\<0\>\/XI2\<1\>\/RR4 \
 (  \
 N_SEL4\<0\>_XI2\<1\>\/XI2\<0\>\/XI2\<0\>\/XI2\<0\>\/XI2\<1\>\/XI2\<1\>\/XI2\<0\>\/XI2\<1\>\/RR4_pos \
 N_WLSEL\<1132\>_XI2\<1\>\/XI2\<0\>\/XI2\<0\>\/XI2\<0\>\/XI2\<1\>\/XI2\<1\>\/XI2\<0\>\/XI2\<1\>\/RR4_neg \
 ) R_1X_LL w=1e-07 l=1e-07   res=0.149966
XXI2\<0\>\/XI2\<1\>\/XI2\<0\>\/XI2\<0\>\/XI2\<0\>\/XI2\<0\>\/XI2\<1\>\/XI2\<1\>\/RR7 \
 (  \
 N_SEL5\<0\>_XI2\<0\>\/XI2\<1\>\/XI2\<0\>\/XI2\<0\>\/XI2\<0\>\/XI2\<0\>\/XI2\<1\>\/XI2\<1\>\/RR7_pos \
 N_WLSEL\<541\>_XI2\<0\>\/XI2\<1\>\/XI2\<0\>\/XI2\<0\>\/XI2\<0\>\/XI2\<0\>\/XI2\<1\>\/XI2\<1\>\/RR7_neg \
 ) R_1X_LL w=1e-07 l=1e-07   res=0.149966
XXI2\<0\>\/XI2\<1\>\/XI2\<0\>\/XI2\<0\>\/XI2\<0\>\/XI2\<0\>\/XI2\<1\>\/XI2\<1\>\/RR6 \
 (  \
 N_SEL6\<1\>_XI2\<0\>\/XI2\<1\>\/XI2\<0\>\/XI2\<0\>\/XI2\<0\>\/XI2\<0\>\/XI2\<1\>\/XI2\<1\>\/RR6_pos \
 N_WLSEL\<542\>_XI2\<0\>\/XI2\<1\>\/XI2\<0\>\/XI2\<0\>\/XI2\<0\>\/XI2\<0\>\/XI2\<1\>\/XI2\<1\>\/RR6_neg \
 ) R_1X_LL w=1e-07 l=1e-07   res=0.149966
XXI2\<0\>\/XI2\<1\>\/XI2\<0\>\/XI2\<0\>\/XI2\<0\>\/XI2\<0\>\/XI2\<1\>\/XI2\<1\>\/RR5 \
 (  \
 N_SEL7\<0\>_XI2\<0\>\/XI2\<1\>\/XI2\<0\>\/XI2\<0\>\/XI2\<0\>\/XI2\<0\>\/XI2\<1\>\/XI2\<1\>\/RR5_pos \
 N_WLSEL\<543\>_XI2\<0\>\/XI2\<1\>\/XI2\<0\>\/XI2\<0\>\/XI2\<0\>\/XI2\<0\>\/XI2\<1\>\/XI2\<1\>\/RR5_neg \
 ) R_1X_LL w=1e-07 l=1e-07   res=0.149966
XXI2\<0\>\/XI2\<1\>\/XI2\<0\>\/XI2\<0\>\/XI2\<0\>\/XI2\<1\>\/XI2\<0\>\/XI2\<0\>\/RR0 \
 (  \
 N_SEL0\<0\>_XI2\<0\>\/XI2\<1\>\/XI2\<0\>\/XI2\<0\>\/XI2\<0\>\/XI2\<1\>\/XI2\<0\>\/XI2\<0\>\/RR0_pos \
 N_WLSEL\<544\>_XI2\<0\>\/XI2\<1\>\/XI2\<0\>\/XI2\<0\>\/XI2\<0\>\/XI2\<1\>\/XI2\<0\>\/XI2\<0\>\/RR0_neg \
 ) R_1X_LL w=1e-07 l=1e-07   res=0.149966
XXI2\<0\>\/XI2\<1\>\/XI2\<0\>\/XI2\<0\>\/XI2\<0\>\/XI2\<1\>\/XI2\<0\>\/XI2\<0\>\/RR1 \
 (  \
 N_SEL1\<0\>_XI2\<0\>\/XI2\<1\>\/XI2\<0\>\/XI2\<0\>\/XI2\<0\>\/XI2\<1\>\/XI2\<0\>\/XI2\<0\>\/RR1_pos \
 N_WLSEL\<545\>_XI2\<0\>\/XI2\<1\>\/XI2\<0\>\/XI2\<0\>\/XI2\<0\>\/XI2\<1\>\/XI2\<0\>\/XI2\<0\>\/RR1_neg \
 ) R_1X_LL w=1e-07 l=1e-07   res=0.149966
XXI2\<0\>\/XI2\<1\>\/XI2\<0\>\/XI2\<0\>\/XI2\<0\>\/XI2\<1\>\/XI2\<0\>\/XI2\<0\>\/RR2 \
 (  \
 N_SEL2\<1\>_XI2\<0\>\/XI2\<1\>\/XI2\<0\>\/XI2\<0\>\/XI2\<0\>\/XI2\<1\>\/XI2\<0\>\/XI2\<0\>\/RR2_pos \
 N_WLSEL\<546\>_XI2\<0\>\/XI2\<1\>\/XI2\<0\>\/XI2\<0\>\/XI2\<0\>\/XI2\<1\>\/XI2\<0\>\/XI2\<0\>\/RR2_neg \
 ) R_1X_LL w=1e-07 l=1e-07   res=0.149966
XXI2\<0\>\/XI2\<1\>\/XI2\<0\>\/XI2\<0\>\/XI2\<0\>\/XI2\<1\>\/XI2\<0\>\/XI2\<0\>\/RR3 \
 (  \
 N_SEL3\<0\>_XI2\<0\>\/XI2\<1\>\/XI2\<0\>\/XI2\<0\>\/XI2\<0\>\/XI2\<1\>\/XI2\<0\>\/XI2\<0\>\/RR3_pos \
 N_WLSEL\<547\>_XI2\<0\>\/XI2\<1\>\/XI2\<0\>\/XI2\<0\>\/XI2\<0\>\/XI2\<1\>\/XI2\<0\>\/XI2\<0\>\/RR3_neg \
 ) R_1X_LL w=1e-07 l=1e-07   res=0.149966
XXI2\<0\>\/XI2\<1\>\/XI2\<0\>\/XI2\<0\>\/XI2\<0\>\/XI2\<1\>\/XI2\<0\>\/XI2\<0\>\/RR4 \
 (  \
 N_SEL4\<0\>_XI2\<0\>\/XI2\<1\>\/XI2\<0\>\/XI2\<0\>\/XI2\<0\>\/XI2\<1\>\/XI2\<0\>\/XI2\<0\>\/RR4_pos \
 N_WLSEL\<548\>_XI2\<0\>\/XI2\<1\>\/XI2\<0\>\/XI2\<0\>\/XI2\<0\>\/XI2\<1\>\/XI2\<0\>\/XI2\<0\>\/RR4_neg \
 ) R_1X_LL w=1e-07 l=1e-07   res=0.149966
XXI2\<0\>\/XI2\<1\>\/XI2\<0\>\/XI2\<0\>\/XI2\<0\>\/XI2\<1\>\/XI2\<0\>\/XI2\<0\>\/RR7 \
 (  \
 N_SEL5\<0\>_XI2\<0\>\/XI2\<1\>\/XI2\<0\>\/XI2\<0\>\/XI2\<0\>\/XI2\<1\>\/XI2\<0\>\/XI2\<0\>\/RR7_pos \
 N_WLSEL\<549\>_XI2\<0\>\/XI2\<1\>\/XI2\<0\>\/XI2\<0\>\/XI2\<0\>\/XI2\<1\>\/XI2\<0\>\/XI2\<0\>\/RR7_neg \
 ) R_1X_LL w=1e-07 l=1e-07   res=0.149966
XXI2\<0\>\/XI2\<1\>\/XI2\<0\>\/XI2\<0\>\/XI2\<0\>\/XI2\<1\>\/XI2\<0\>\/XI2\<0\>\/RR6 \
 (  \
 N_SEL6\<1\>_XI2\<0\>\/XI2\<1\>\/XI2\<0\>\/XI2\<0\>\/XI2\<0\>\/XI2\<1\>\/XI2\<0\>\/XI2\<0\>\/RR6_pos \
 N_WLSEL\<550\>_XI2\<0\>\/XI2\<1\>\/XI2\<0\>\/XI2\<0\>\/XI2\<0\>\/XI2\<1\>\/XI2\<0\>\/XI2\<0\>\/RR6_neg \
 ) R_1X_LL w=1e-07 l=1e-07   res=0.149966
XXI2\<0\>\/XI2\<1\>\/XI2\<0\>\/XI2\<0\>\/XI2\<0\>\/XI2\<1\>\/XI2\<0\>\/XI2\<0\>\/RR5 \
 (  \
 N_SEL7\<0\>_XI2\<0\>\/XI2\<1\>\/XI2\<0\>\/XI2\<0\>\/XI2\<0\>\/XI2\<1\>\/XI2\<0\>\/XI2\<0\>\/RR5_pos \
 N_WLSEL\<551\>_XI2\<0\>\/XI2\<1\>\/XI2\<0\>\/XI2\<0\>\/XI2\<0\>\/XI2\<1\>\/XI2\<0\>\/XI2\<0\>\/RR5_neg \
 ) R_1X_LL w=1e-07 l=1e-07   res=0.149966
XXI2\<0\>\/XI2\<1\>\/XI2\<0\>\/XI2\<0\>\/XI2\<0\>\/XI2\<1\>\/XI2\<0\>\/XI2\<1\>\/RR0 \
 (  \
 N_SEL0\<1\>_XI2\<0\>\/XI2\<1\>\/XI2\<0\>\/XI2\<0\>\/XI2\<0\>\/XI2\<1\>\/XI2\<0\>\/XI2\<1\>\/RR0_pos \
 N_WLSEL\<552\>_XI2\<0\>\/XI2\<1\>\/XI2\<0\>\/XI2\<0\>\/XI2\<0\>\/XI2\<1\>\/XI2\<0\>\/XI2\<1\>\/RR0_neg \
 ) R_1X_LL w=1e-07 l=1e-07   res=0.149966
XXI2\<0\>\/XI2\<1\>\/XI2\<0\>\/XI2\<0\>\/XI2\<0\>\/XI2\<1\>\/XI2\<0\>\/XI2\<1\>\/RR1 \
 (  \
 N_SEL1\<0\>_XI2\<0\>\/XI2\<1\>\/XI2\<0\>\/XI2\<0\>\/XI2\<0\>\/XI2\<1\>\/XI2\<0\>\/XI2\<1\>\/RR1_pos \
 N_WLSEL\<553\>_XI2\<0\>\/XI2\<1\>\/XI2\<0\>\/XI2\<0\>\/XI2\<0\>\/XI2\<1\>\/XI2\<0\>\/XI2\<1\>\/RR1_neg \
 ) R_1X_LL w=1e-07 l=1e-07   res=0.149966
XXI2\<0\>\/XI2\<1\>\/XI2\<0\>\/XI2\<0\>\/XI2\<0\>\/XI2\<1\>\/XI2\<0\>\/XI2\<1\>\/RR2 \
 (  \
 N_SEL2\<1\>_XI2\<0\>\/XI2\<1\>\/XI2\<0\>\/XI2\<0\>\/XI2\<0\>\/XI2\<1\>\/XI2\<0\>\/XI2\<1\>\/RR2_pos \
 N_WLSEL\<554\>_XI2\<0\>\/XI2\<1\>\/XI2\<0\>\/XI2\<0\>\/XI2\<0\>\/XI2\<1\>\/XI2\<0\>\/XI2\<1\>\/RR2_neg \
 ) R_1X_LL w=1e-07 l=1e-07   res=0.149966
XXI2\<0\>\/XI2\<1\>\/XI2\<0\>\/XI2\<0\>\/XI2\<0\>\/XI2\<1\>\/XI2\<0\>\/XI2\<1\>\/RR3 \
 (  \
 N_SEL3\<0\>_XI2\<0\>\/XI2\<1\>\/XI2\<0\>\/XI2\<0\>\/XI2\<0\>\/XI2\<1\>\/XI2\<0\>\/XI2\<1\>\/RR3_pos \
 N_WLSEL\<555\>_XI2\<0\>\/XI2\<1\>\/XI2\<0\>\/XI2\<0\>\/XI2\<0\>\/XI2\<1\>\/XI2\<0\>\/XI2\<1\>\/RR3_neg \
 ) R_1X_LL w=1e-07 l=1e-07   res=0.149966
XXI2\<0\>\/XI2\<1\>\/XI2\<0\>\/XI2\<0\>\/XI2\<0\>\/XI2\<1\>\/XI2\<0\>\/XI2\<1\>\/RR4 \
 (  \
 N_SEL4\<0\>_XI2\<0\>\/XI2\<1\>\/XI2\<0\>\/XI2\<0\>\/XI2\<0\>\/XI2\<1\>\/XI2\<0\>\/XI2\<1\>\/RR4_pos \
 N_WLSEL\<556\>_XI2\<0\>\/XI2\<1\>\/XI2\<0\>\/XI2\<0\>\/XI2\<0\>\/XI2\<1\>\/XI2\<0\>\/XI2\<1\>\/RR4_neg \
 ) R_1X_LL w=1e-07 l=1e-07   res=0.149966
XXI2\<0\>\/XI2\<1\>\/XI2\<0\>\/XI2\<0\>\/XI2\<0\>\/XI2\<1\>\/XI2\<0\>\/XI2\<1\>\/RR7 \
 (  \
 N_SEL5\<0\>_XI2\<0\>\/XI2\<1\>\/XI2\<0\>\/XI2\<0\>\/XI2\<0\>\/XI2\<1\>\/XI2\<0\>\/XI2\<1\>\/RR7_pos \
 N_WLSEL\<557\>_XI2\<0\>\/XI2\<1\>\/XI2\<0\>\/XI2\<0\>\/XI2\<0\>\/XI2\<1\>\/XI2\<0\>\/XI2\<1\>\/RR7_neg \
 ) R_1X_LL w=1e-07 l=1e-07   res=0.149966
XXI2\<0\>\/XI2\<1\>\/XI2\<0\>\/XI2\<0\>\/XI2\<0\>\/XI2\<1\>\/XI2\<0\>\/XI2\<1\>\/RR6 \
 (  \
 N_SEL6\<1\>_XI2\<0\>\/XI2\<1\>\/XI2\<0\>\/XI2\<0\>\/XI2\<0\>\/XI2\<1\>\/XI2\<0\>\/XI2\<1\>\/RR6_pos \
 N_WLSEL\<558\>_XI2\<0\>\/XI2\<1\>\/XI2\<0\>\/XI2\<0\>\/XI2\<0\>\/XI2\<1\>\/XI2\<0\>\/XI2\<1\>\/RR6_neg \
 ) R_1X_LL w=1e-07 l=1e-07   res=0.149966
XXI2\<0\>\/XI2\<1\>\/XI2\<0\>\/XI2\<0\>\/XI2\<0\>\/XI2\<1\>\/XI2\<0\>\/XI2\<1\>\/RR5 \
 (  \
 N_SEL7\<0\>_XI2\<0\>\/XI2\<1\>\/XI2\<0\>\/XI2\<0\>\/XI2\<0\>\/XI2\<1\>\/XI2\<0\>\/XI2\<1\>\/RR5_pos \
 N_WLSEL\<559\>_XI2\<0\>\/XI2\<1\>\/XI2\<0\>\/XI2\<0\>\/XI2\<0\>\/XI2\<1\>\/XI2\<0\>\/XI2\<1\>\/RR5_neg \
 ) R_1X_LL w=1e-07 l=1e-07   res=0.149966
XXI2\<0\>\/XI2\<1\>\/XI2\<0\>\/XI2\<0\>\/XI2\<0\>\/XI2\<1\>\/XI2\<1\>\/XI2\<0\>\/RR0 \
 (  \
 N_SEL0\<0\>_XI2\<0\>\/XI2\<1\>\/XI2\<0\>\/XI2\<0\>\/XI2\<0\>\/XI2\<1\>\/XI2\<1\>\/XI2\<0\>\/RR0_pos \
 N_WLSEL\<560\>_XI2\<0\>\/XI2\<1\>\/XI2\<0\>\/XI2\<0\>\/XI2\<0\>\/XI2\<1\>\/XI2\<1\>\/XI2\<0\>\/RR0_neg \
 ) R_1X_LL w=1e-07 l=1e-07   res=0.149966
XXI2\<0\>\/XI2\<1\>\/XI2\<0\>\/XI2\<0\>\/XI2\<0\>\/XI2\<1\>\/XI2\<1\>\/XI2\<0\>\/RR1 \
 (  \
 N_SEL1\<1\>_XI2\<0\>\/XI2\<1\>\/XI2\<0\>\/XI2\<0\>\/XI2\<0\>\/XI2\<1\>\/XI2\<1\>\/XI2\<0\>\/RR1_pos \
 N_WLSEL\<561\>_XI2\<0\>\/XI2\<1\>\/XI2\<0\>\/XI2\<0\>\/XI2\<0\>\/XI2\<1\>\/XI2\<1\>\/XI2\<0\>\/RR1_neg \
 ) R_1X_LL w=1e-07 l=1e-07   res=0.149966
XXI2\<0\>\/XI2\<1\>\/XI2\<0\>\/XI2\<0\>\/XI2\<0\>\/XI2\<1\>\/XI2\<1\>\/XI2\<0\>\/RR2 \
 (  \
 N_SEL2\<1\>_XI2\<0\>\/XI2\<1\>\/XI2\<0\>\/XI2\<0\>\/XI2\<0\>\/XI2\<1\>\/XI2\<1\>\/XI2\<0\>\/RR2_pos \
 N_WLSEL\<562\>_XI2\<0\>\/XI2\<1\>\/XI2\<0\>\/XI2\<0\>\/XI2\<0\>\/XI2\<1\>\/XI2\<1\>\/XI2\<0\>\/RR2_neg \
 ) R_1X_LL w=1e-07 l=1e-07   res=0.149966
XXI2\<0\>\/XI2\<1\>\/XI2\<0\>\/XI2\<0\>\/XI2\<0\>\/XI2\<1\>\/XI2\<1\>\/XI2\<0\>\/RR3 \
 (  \
 N_SEL3\<0\>_XI2\<0\>\/XI2\<1\>\/XI2\<0\>\/XI2\<0\>\/XI2\<0\>\/XI2\<1\>\/XI2\<1\>\/XI2\<0\>\/RR3_pos \
 N_WLSEL\<563\>_XI2\<0\>\/XI2\<1\>\/XI2\<0\>\/XI2\<0\>\/XI2\<0\>\/XI2\<1\>\/XI2\<1\>\/XI2\<0\>\/RR3_neg \
 ) R_1X_LL w=1e-07 l=1e-07   res=0.149966
XXI2\<0\>\/XI2\<1\>\/XI2\<0\>\/XI2\<0\>\/XI2\<0\>\/XI2\<1\>\/XI2\<1\>\/XI2\<0\>\/RR4 \
 (  \
 N_SEL4\<0\>_XI2\<0\>\/XI2\<1\>\/XI2\<0\>\/XI2\<0\>\/XI2\<0\>\/XI2\<1\>\/XI2\<1\>\/XI2\<0\>\/RR4_pos \
 N_WLSEL\<564\>_XI2\<0\>\/XI2\<1\>\/XI2\<0\>\/XI2\<0\>\/XI2\<0\>\/XI2\<1\>\/XI2\<1\>\/XI2\<0\>\/RR4_neg \
 ) R_1X_LL w=1e-07 l=1e-07   res=0.149966
XXI2\<0\>\/XI2\<1\>\/XI2\<0\>\/XI2\<0\>\/XI2\<0\>\/XI2\<1\>\/XI2\<1\>\/XI2\<0\>\/RR7 \
 (  \
 N_SEL5\<0\>_XI2\<0\>\/XI2\<1\>\/XI2\<0\>\/XI2\<0\>\/XI2\<0\>\/XI2\<1\>\/XI2\<1\>\/XI2\<0\>\/RR7_pos \
 N_WLSEL\<565\>_XI2\<0\>\/XI2\<1\>\/XI2\<0\>\/XI2\<0\>\/XI2\<0\>\/XI2\<1\>\/XI2\<1\>\/XI2\<0\>\/RR7_neg \
 ) R_1X_LL w=1e-07 l=1e-07   res=0.149966
XXI2\<0\>\/XI2\<1\>\/XI2\<0\>\/XI2\<0\>\/XI2\<0\>\/XI2\<1\>\/XI2\<1\>\/XI2\<0\>\/RR6 \
 (  \
 N_SEL6\<1\>_XI2\<0\>\/XI2\<1\>\/XI2\<0\>\/XI2\<0\>\/XI2\<0\>\/XI2\<1\>\/XI2\<1\>\/XI2\<0\>\/RR6_pos \
 N_WLSEL\<566\>_XI2\<0\>\/XI2\<1\>\/XI2\<0\>\/XI2\<0\>\/XI2\<0\>\/XI2\<1\>\/XI2\<1\>\/XI2\<0\>\/RR6_neg \
 ) R_1X_LL w=1e-07 l=1e-07   res=0.149966
XXI2\<0\>\/XI2\<1\>\/XI2\<0\>\/XI2\<0\>\/XI2\<0\>\/XI2\<1\>\/XI2\<1\>\/XI2\<0\>\/RR5 \
 (  \
 N_SEL7\<0\>_XI2\<0\>\/XI2\<1\>\/XI2\<0\>\/XI2\<0\>\/XI2\<0\>\/XI2\<1\>\/XI2\<1\>\/XI2\<0\>\/RR5_pos \
 N_WLSEL\<567\>_XI2\<0\>\/XI2\<1\>\/XI2\<0\>\/XI2\<0\>\/XI2\<0\>\/XI2\<1\>\/XI2\<1\>\/XI2\<0\>\/RR5_neg \
 ) R_1X_LL w=1e-07 l=1e-07   res=0.149966
XXI2\<0\>\/XI2\<1\>\/XI2\<0\>\/XI2\<0\>\/XI2\<0\>\/XI2\<1\>\/XI2\<1\>\/XI2\<1\>\/RR0 \
 (  \
 N_SEL0\<1\>_XI2\<0\>\/XI2\<1\>\/XI2\<0\>\/XI2\<0\>\/XI2\<0\>\/XI2\<1\>\/XI2\<1\>\/XI2\<1\>\/RR0_pos \
 N_WLSEL\<568\>_XI2\<0\>\/XI2\<1\>\/XI2\<0\>\/XI2\<0\>\/XI2\<0\>\/XI2\<1\>\/XI2\<1\>\/XI2\<1\>\/RR0_neg \
 ) R_1X_LL w=1e-07 l=1e-07   res=0.149966
XXI2\<0\>\/XI2\<1\>\/XI2\<0\>\/XI2\<0\>\/XI2\<0\>\/XI2\<1\>\/XI2\<1\>\/XI2\<1\>\/RR1 \
 (  \
 N_SEL1\<1\>_XI2\<0\>\/XI2\<1\>\/XI2\<0\>\/XI2\<0\>\/XI2\<0\>\/XI2\<1\>\/XI2\<1\>\/XI2\<1\>\/RR1_pos \
 N_WLSEL\<569\>_XI2\<0\>\/XI2\<1\>\/XI2\<0\>\/XI2\<0\>\/XI2\<0\>\/XI2\<1\>\/XI2\<1\>\/XI2\<1\>\/RR1_neg \
 ) R_1X_LL w=1e-07 l=1e-07   res=0.149966
XXI2\<0\>\/XI2\<1\>\/XI2\<0\>\/XI2\<0\>\/XI2\<0\>\/XI2\<1\>\/XI2\<1\>\/XI2\<1\>\/RR2 \
 (  \
 N_SEL2\<1\>_XI2\<0\>\/XI2\<1\>\/XI2\<0\>\/XI2\<0\>\/XI2\<0\>\/XI2\<1\>\/XI2\<1\>\/XI2\<1\>\/RR2_pos \
 N_WLSEL\<570\>_XI2\<0\>\/XI2\<1\>\/XI2\<0\>\/XI2\<0\>\/XI2\<0\>\/XI2\<1\>\/XI2\<1\>\/XI2\<1\>\/RR2_neg \
 ) R_1X_LL w=1e-07 l=1e-07   res=0.149966
XXI2\<0\>\/XI2\<1\>\/XI2\<0\>\/XI2\<0\>\/XI2\<0\>\/XI2\<1\>\/XI2\<1\>\/XI2\<1\>\/RR3 \
 (  \
 N_SEL3\<0\>_XI2\<0\>\/XI2\<1\>\/XI2\<0\>\/XI2\<0\>\/XI2\<0\>\/XI2\<1\>\/XI2\<1\>\/XI2\<1\>\/RR3_pos \
 N_WLSEL\<571\>_XI2\<0\>\/XI2\<1\>\/XI2\<0\>\/XI2\<0\>\/XI2\<0\>\/XI2\<1\>\/XI2\<1\>\/XI2\<1\>\/RR3_neg \
 ) R_1X_LL w=1e-07 l=1e-07   res=0.149966
XXI2\<0\>\/XI2\<1\>\/XI2\<0\>\/XI2\<0\>\/XI2\<0\>\/XI2\<1\>\/XI2\<1\>\/XI2\<1\>\/RR4 \
 (  \
 N_SEL4\<0\>_XI2\<0\>\/XI2\<1\>\/XI2\<0\>\/XI2\<0\>\/XI2\<0\>\/XI2\<1\>\/XI2\<1\>\/XI2\<1\>\/RR4_pos \
 N_WLSEL\<572\>_XI2\<0\>\/XI2\<1\>\/XI2\<0\>\/XI2\<0\>\/XI2\<0\>\/XI2\<1\>\/XI2\<1\>\/XI2\<1\>\/RR4_neg \
 ) R_1X_LL w=1e-07 l=1e-07   res=0.149966
XXI2\<0\>\/XI2\<1\>\/XI2\<0\>\/XI2\<0\>\/XI2\<0\>\/XI2\<1\>\/XI2\<1\>\/XI2\<1\>\/RR7 \
 (  \
 N_SEL5\<0\>_XI2\<0\>\/XI2\<1\>\/XI2\<0\>\/XI2\<0\>\/XI2\<0\>\/XI2\<1\>\/XI2\<1\>\/XI2\<1\>\/RR7_pos \
 N_WLSEL\<573\>_XI2\<0\>\/XI2\<1\>\/XI2\<0\>\/XI2\<0\>\/XI2\<0\>\/XI2\<1\>\/XI2\<1\>\/XI2\<1\>\/RR7_neg \
 ) R_1X_LL w=1e-07 l=1e-07   res=0.149966
XXI2\<0\>\/XI2\<1\>\/XI2\<0\>\/XI2\<0\>\/XI2\<0\>\/XI2\<1\>\/XI2\<1\>\/XI2\<1\>\/RR6 \
 (  \
 N_SEL6\<1\>_XI2\<0\>\/XI2\<1\>\/XI2\<0\>\/XI2\<0\>\/XI2\<0\>\/XI2\<1\>\/XI2\<1\>\/XI2\<1\>\/RR6_pos \
 N_WLSEL\<574\>_XI2\<0\>\/XI2\<1\>\/XI2\<0\>\/XI2\<0\>\/XI2\<0\>\/XI2\<1\>\/XI2\<1\>\/XI2\<1\>\/RR6_neg \
 ) R_1X_LL w=1e-07 l=1e-07   res=0.149966
XXI2\<0\>\/XI2\<1\>\/XI2\<0\>\/XI2\<0\>\/XI2\<0\>\/XI2\<1\>\/XI2\<1\>\/XI2\<1\>\/RR5 \
 (  \
 N_SEL7\<0\>_XI2\<0\>\/XI2\<1\>\/XI2\<0\>\/XI2\<0\>\/XI2\<0\>\/XI2\<1\>\/XI2\<1\>\/XI2\<1\>\/RR5_pos \
 N_WLSEL\<575\>_XI2\<0\>\/XI2\<1\>\/XI2\<0\>\/XI2\<0\>\/XI2\<0\>\/XI2\<1\>\/XI2\<1\>\/XI2\<1\>\/RR5_neg \
 ) R_1X_LL w=1e-07 l=1e-07   res=0.149966
XXI2\<0\>\/XI2\<1\>\/XI2\<0\>\/XI2\<0\>\/XI2\<1\>\/XI2\<0\>\/XI2\<0\>\/XI2\<0\>\/RR0 \
 (  \
 N_SEL0\<0\>_XI2\<0\>\/XI2\<1\>\/XI2\<0\>\/XI2\<0\>\/XI2\<1\>\/XI2\<0\>\/XI2\<0\>\/XI2\<0\>\/RR0_pos \
 N_WLSEL\<576\>_XI2\<0\>\/XI2\<1\>\/XI2\<0\>\/XI2\<0\>\/XI2\<1\>\/XI2\<0\>\/XI2\<0\>\/XI2\<0\>\/RR0_neg \
 ) R_1X_LL w=1e-07 l=1e-07   res=0.149966
XXI2\<0\>\/XI2\<1\>\/XI2\<0\>\/XI2\<0\>\/XI2\<1\>\/XI2\<0\>\/XI2\<0\>\/XI2\<0\>\/RR1 \
 (  \
 N_SEL1\<0\>_XI2\<0\>\/XI2\<1\>\/XI2\<0\>\/XI2\<0\>\/XI2\<1\>\/XI2\<0\>\/XI2\<0\>\/XI2\<0\>\/RR1_pos \
 N_WLSEL\<577\>_XI2\<0\>\/XI2\<1\>\/XI2\<0\>\/XI2\<0\>\/XI2\<1\>\/XI2\<0\>\/XI2\<0\>\/XI2\<0\>\/RR1_neg \
 ) R_1X_LL w=1e-07 l=1e-07   res=0.149966
XXI2\<0\>\/XI2\<1\>\/XI2\<0\>\/XI2\<0\>\/XI2\<1\>\/XI2\<0\>\/XI2\<0\>\/XI2\<0\>\/RR2 \
 (  \
 N_SEL2\<0\>_XI2\<0\>\/XI2\<1\>\/XI2\<0\>\/XI2\<0\>\/XI2\<1\>\/XI2\<0\>\/XI2\<0\>\/XI2\<0\>\/RR2_pos \
 N_WLSEL\<578\>_XI2\<0\>\/XI2\<1\>\/XI2\<0\>\/XI2\<0\>\/XI2\<1\>\/XI2\<0\>\/XI2\<0\>\/XI2\<0\>\/RR2_neg \
 ) R_1X_LL w=1e-07 l=1e-07   res=0.149966
XXI2\<0\>\/XI2\<1\>\/XI2\<0\>\/XI2\<0\>\/XI2\<1\>\/XI2\<0\>\/XI2\<0\>\/XI2\<0\>\/RR3 \
 (  \
 N_SEL3\<1\>_XI2\<0\>\/XI2\<1\>\/XI2\<0\>\/XI2\<0\>\/XI2\<1\>\/XI2\<0\>\/XI2\<0\>\/XI2\<0\>\/RR3_pos \
 N_WLSEL\<579\>_XI2\<0\>\/XI2\<1\>\/XI2\<0\>\/XI2\<0\>\/XI2\<1\>\/XI2\<0\>\/XI2\<0\>\/XI2\<0\>\/RR3_neg \
 ) R_1X_LL w=1e-07 l=1e-07   res=0.149966
XXI2\<0\>\/XI2\<1\>\/XI2\<0\>\/XI2\<0\>\/XI2\<1\>\/XI2\<0\>\/XI2\<0\>\/XI2\<0\>\/RR4 \
 (  \
 N_SEL4\<0\>_XI2\<0\>\/XI2\<1\>\/XI2\<0\>\/XI2\<0\>\/XI2\<1\>\/XI2\<0\>\/XI2\<0\>\/XI2\<0\>\/RR4_pos \
 N_WLSEL\<580\>_XI2\<0\>\/XI2\<1\>\/XI2\<0\>\/XI2\<0\>\/XI2\<1\>\/XI2\<0\>\/XI2\<0\>\/XI2\<0\>\/RR4_neg \
 ) R_1X_LL w=1e-07 l=1e-07   res=0.149966
XXI2\<0\>\/XI2\<1\>\/XI2\<0\>\/XI2\<0\>\/XI2\<1\>\/XI2\<0\>\/XI2\<0\>\/XI2\<0\>\/RR7 \
 (  \
 N_SEL5\<0\>_XI2\<0\>\/XI2\<1\>\/XI2\<0\>\/XI2\<0\>\/XI2\<1\>\/XI2\<0\>\/XI2\<0\>\/XI2\<0\>\/RR7_pos \
 N_WLSEL\<581\>_XI2\<0\>\/XI2\<1\>\/XI2\<0\>\/XI2\<0\>\/XI2\<1\>\/XI2\<0\>\/XI2\<0\>\/XI2\<0\>\/RR7_neg \
 ) R_1X_LL w=1e-07 l=1e-07   res=0.149966
XXI2\<0\>\/XI2\<1\>\/XI2\<0\>\/XI2\<0\>\/XI2\<1\>\/XI2\<0\>\/XI2\<0\>\/XI2\<0\>\/RR6 \
 (  \
 N_SEL6\<1\>_XI2\<0\>\/XI2\<1\>\/XI2\<0\>\/XI2\<0\>\/XI2\<1\>\/XI2\<0\>\/XI2\<0\>\/XI2\<0\>\/RR6_pos \
 N_WLSEL\<582\>_XI2\<0\>\/XI2\<1\>\/XI2\<0\>\/XI2\<0\>\/XI2\<1\>\/XI2\<0\>\/XI2\<0\>\/XI2\<0\>\/RR6_neg \
 ) R_1X_LL w=1e-07 l=1e-07   res=0.149966
XXI2\<0\>\/XI2\<1\>\/XI2\<0\>\/XI2\<0\>\/XI2\<1\>\/XI2\<0\>\/XI2\<0\>\/XI2\<0\>\/RR5 \
 (  \
 N_SEL7\<0\>_XI2\<0\>\/XI2\<1\>\/XI2\<0\>\/XI2\<0\>\/XI2\<1\>\/XI2\<0\>\/XI2\<0\>\/XI2\<0\>\/RR5_pos \
 N_WLSEL\<583\>_XI2\<0\>\/XI2\<1\>\/XI2\<0\>\/XI2\<0\>\/XI2\<1\>\/XI2\<0\>\/XI2\<0\>\/XI2\<0\>\/RR5_neg \
 ) R_1X_LL w=1e-07 l=1e-07   res=0.149966
XXI2\<0\>\/XI2\<1\>\/XI2\<0\>\/XI2\<0\>\/XI2\<1\>\/XI2\<0\>\/XI2\<0\>\/XI2\<1\>\/RR0 \
 (  \
 N_SEL0\<1\>_XI2\<0\>\/XI2\<1\>\/XI2\<0\>\/XI2\<0\>\/XI2\<1\>\/XI2\<0\>\/XI2\<0\>\/XI2\<1\>\/RR0_pos \
 N_WLSEL\<584\>_XI2\<0\>\/XI2\<1\>\/XI2\<0\>\/XI2\<0\>\/XI2\<1\>\/XI2\<0\>\/XI2\<0\>\/XI2\<1\>\/RR0_neg \
 ) R_1X_LL w=1e-07 l=1e-07   res=0.149966
XXI2\<0\>\/XI2\<1\>\/XI2\<0\>\/XI2\<0\>\/XI2\<1\>\/XI2\<0\>\/XI2\<0\>\/XI2\<1\>\/RR1 \
 (  \
 N_SEL1\<0\>_XI2\<0\>\/XI2\<1\>\/XI2\<0\>\/XI2\<0\>\/XI2\<1\>\/XI2\<0\>\/XI2\<0\>\/XI2\<1\>\/RR1_pos \
 N_WLSEL\<585\>_XI2\<0\>\/XI2\<1\>\/XI2\<0\>\/XI2\<0\>\/XI2\<1\>\/XI2\<0\>\/XI2\<0\>\/XI2\<1\>\/RR1_neg \
 ) R_1X_LL w=1e-07 l=1e-07   res=0.149966
XXI2\<0\>\/XI2\<1\>\/XI2\<0\>\/XI2\<0\>\/XI2\<1\>\/XI2\<0\>\/XI2\<0\>\/XI2\<1\>\/RR2 \
 (  \
 N_SEL2\<0\>_XI2\<0\>\/XI2\<1\>\/XI2\<0\>\/XI2\<0\>\/XI2\<1\>\/XI2\<0\>\/XI2\<0\>\/XI2\<1\>\/RR2_pos \
 N_WLSEL\<586\>_XI2\<0\>\/XI2\<1\>\/XI2\<0\>\/XI2\<0\>\/XI2\<1\>\/XI2\<0\>\/XI2\<0\>\/XI2\<1\>\/RR2_neg \
 ) R_1X_LL w=1e-07 l=1e-07   res=0.149966
XXI2\<0\>\/XI2\<1\>\/XI2\<0\>\/XI2\<0\>\/XI2\<1\>\/XI2\<0\>\/XI2\<0\>\/XI2\<1\>\/RR3 \
 (  \
 N_SEL3\<1\>_XI2\<0\>\/XI2\<1\>\/XI2\<0\>\/XI2\<0\>\/XI2\<1\>\/XI2\<0\>\/XI2\<0\>\/XI2\<1\>\/RR3_pos \
 N_WLSEL\<587\>_XI2\<0\>\/XI2\<1\>\/XI2\<0\>\/XI2\<0\>\/XI2\<1\>\/XI2\<0\>\/XI2\<0\>\/XI2\<1\>\/RR3_neg \
 ) R_1X_LL w=1e-07 l=1e-07   res=0.149966
XXI2\<0\>\/XI2\<1\>\/XI2\<0\>\/XI2\<0\>\/XI2\<1\>\/XI2\<0\>\/XI2\<0\>\/XI2\<1\>\/RR4 \
 (  \
 N_SEL4\<0\>_XI2\<0\>\/XI2\<1\>\/XI2\<0\>\/XI2\<0\>\/XI2\<1\>\/XI2\<0\>\/XI2\<0\>\/XI2\<1\>\/RR4_pos \
 N_WLSEL\<588\>_XI2\<0\>\/XI2\<1\>\/XI2\<0\>\/XI2\<0\>\/XI2\<1\>\/XI2\<0\>\/XI2\<0\>\/XI2\<1\>\/RR4_neg \
 ) R_1X_LL w=1e-07 l=1e-07   res=0.149966
XXI2\<0\>\/XI2\<1\>\/XI2\<0\>\/XI2\<0\>\/XI2\<1\>\/XI2\<0\>\/XI2\<0\>\/XI2\<1\>\/RR7 \
 (  \
 N_SEL5\<0\>_XI2\<0\>\/XI2\<1\>\/XI2\<0\>\/XI2\<0\>\/XI2\<1\>\/XI2\<0\>\/XI2\<0\>\/XI2\<1\>\/RR7_pos \
 N_WLSEL\<589\>_XI2\<0\>\/XI2\<1\>\/XI2\<0\>\/XI2\<0\>\/XI2\<1\>\/XI2\<0\>\/XI2\<0\>\/XI2\<1\>\/RR7_neg \
 ) R_1X_LL w=1e-07 l=1e-07   res=0.149966
XXI2\<0\>\/XI2\<1\>\/XI2\<0\>\/XI2\<0\>\/XI2\<1\>\/XI2\<0\>\/XI2\<0\>\/XI2\<1\>\/RR6 \
 (  \
 N_SEL6\<1\>_XI2\<0\>\/XI2\<1\>\/XI2\<0\>\/XI2\<0\>\/XI2\<1\>\/XI2\<0\>\/XI2\<0\>\/XI2\<1\>\/RR6_pos \
 N_WLSEL\<590\>_XI2\<0\>\/XI2\<1\>\/XI2\<0\>\/XI2\<0\>\/XI2\<1\>\/XI2\<0\>\/XI2\<0\>\/XI2\<1\>\/RR6_neg \
 ) R_1X_LL w=1e-07 l=1e-07   res=0.149966
XXI2\<0\>\/XI2\<1\>\/XI2\<0\>\/XI2\<0\>\/XI2\<1\>\/XI2\<0\>\/XI2\<0\>\/XI2\<1\>\/RR5 \
 (  \
 N_SEL7\<0\>_XI2\<0\>\/XI2\<1\>\/XI2\<0\>\/XI2\<0\>\/XI2\<1\>\/XI2\<0\>\/XI2\<0\>\/XI2\<1\>\/RR5_pos \
 N_WLSEL\<591\>_XI2\<0\>\/XI2\<1\>\/XI2\<0\>\/XI2\<0\>\/XI2\<1\>\/XI2\<0\>\/XI2\<0\>\/XI2\<1\>\/RR5_neg \
 ) R_1X_LL w=1e-07 l=1e-07   res=0.149966
XXI2\<0\>\/XI2\<1\>\/XI2\<0\>\/XI2\<0\>\/XI2\<1\>\/XI2\<0\>\/XI2\<1\>\/XI2\<0\>\/RR0 \
 (  \
 N_SEL0\<0\>_XI2\<0\>\/XI2\<1\>\/XI2\<0\>\/XI2\<0\>\/XI2\<1\>\/XI2\<0\>\/XI2\<1\>\/XI2\<0\>\/RR0_pos \
 N_WLSEL\<592\>_XI2\<0\>\/XI2\<1\>\/XI2\<0\>\/XI2\<0\>\/XI2\<1\>\/XI2\<0\>\/XI2\<1\>\/XI2\<0\>\/RR0_neg \
 ) R_1X_LL w=1e-07 l=1e-07   res=0.149966
XXI2\<0\>\/XI2\<1\>\/XI2\<0\>\/XI2\<0\>\/XI2\<1\>\/XI2\<0\>\/XI2\<1\>\/XI2\<0\>\/RR1 \
 (  \
 N_SEL1\<1\>_XI2\<0\>\/XI2\<1\>\/XI2\<0\>\/XI2\<0\>\/XI2\<1\>\/XI2\<0\>\/XI2\<1\>\/XI2\<0\>\/RR1_pos \
 N_WLSEL\<593\>_XI2\<0\>\/XI2\<1\>\/XI2\<0\>\/XI2\<0\>\/XI2\<1\>\/XI2\<0\>\/XI2\<1\>\/XI2\<0\>\/RR1_neg \
 ) R_1X_LL w=1e-07 l=1e-07   res=0.149966
XXI2\<0\>\/XI2\<1\>\/XI2\<0\>\/XI2\<0\>\/XI2\<1\>\/XI2\<0\>\/XI2\<1\>\/XI2\<0\>\/RR2 \
 (  \
 N_SEL2\<0\>_XI2\<0\>\/XI2\<1\>\/XI2\<0\>\/XI2\<0\>\/XI2\<1\>\/XI2\<0\>\/XI2\<1\>\/XI2\<0\>\/RR2_pos \
 N_WLSEL\<594\>_XI2\<0\>\/XI2\<1\>\/XI2\<0\>\/XI2\<0\>\/XI2\<1\>\/XI2\<0\>\/XI2\<1\>\/XI2\<0\>\/RR2_neg \
 ) R_1X_LL w=1e-07 l=1e-07   res=0.149966
XXI2\<0\>\/XI2\<1\>\/XI2\<0\>\/XI2\<0\>\/XI2\<1\>\/XI2\<0\>\/XI2\<1\>\/XI2\<0\>\/RR3 \
 (  \
 N_SEL3\<1\>_XI2\<0\>\/XI2\<1\>\/XI2\<0\>\/XI2\<0\>\/XI2\<1\>\/XI2\<0\>\/XI2\<1\>\/XI2\<0\>\/RR3_pos \
 N_WLSEL\<595\>_XI2\<0\>\/XI2\<1\>\/XI2\<0\>\/XI2\<0\>\/XI2\<1\>\/XI2\<0\>\/XI2\<1\>\/XI2\<0\>\/RR3_neg \
 ) R_1X_LL w=1e-07 l=1e-07   res=0.149966
XXI2\<0\>\/XI2\<1\>\/XI2\<0\>\/XI2\<0\>\/XI2\<1\>\/XI2\<0\>\/XI2\<1\>\/XI2\<0\>\/RR4 \
 (  \
 N_SEL4\<0\>_XI2\<0\>\/XI2\<1\>\/XI2\<0\>\/XI2\<0\>\/XI2\<1\>\/XI2\<0\>\/XI2\<1\>\/XI2\<0\>\/RR4_pos \
 N_WLSEL\<596\>_XI2\<0\>\/XI2\<1\>\/XI2\<0\>\/XI2\<0\>\/XI2\<1\>\/XI2\<0\>\/XI2\<1\>\/XI2\<0\>\/RR4_neg \
 ) R_1X_LL w=1e-07 l=1e-07   res=0.149966
XXI2\<0\>\/XI2\<1\>\/XI2\<0\>\/XI2\<0\>\/XI2\<1\>\/XI2\<0\>\/XI2\<1\>\/XI2\<0\>\/RR7 \
 (  \
 N_SEL5\<0\>_XI2\<0\>\/XI2\<1\>\/XI2\<0\>\/XI2\<0\>\/XI2\<1\>\/XI2\<0\>\/XI2\<1\>\/XI2\<0\>\/RR7_pos \
 N_WLSEL\<597\>_XI2\<0\>\/XI2\<1\>\/XI2\<0\>\/XI2\<0\>\/XI2\<1\>\/XI2\<0\>\/XI2\<1\>\/XI2\<0\>\/RR7_neg \
 ) R_1X_LL w=1e-07 l=1e-07   res=0.149966
XXI2\<0\>\/XI2\<1\>\/XI2\<0\>\/XI2\<0\>\/XI2\<1\>\/XI2\<0\>\/XI2\<1\>\/XI2\<0\>\/RR6 \
 (  \
 N_SEL6\<1\>_XI2\<0\>\/XI2\<1\>\/XI2\<0\>\/XI2\<0\>\/XI2\<1\>\/XI2\<0\>\/XI2\<1\>\/XI2\<0\>\/RR6_pos \
 N_WLSEL\<598\>_XI2\<0\>\/XI2\<1\>\/XI2\<0\>\/XI2\<0\>\/XI2\<1\>\/XI2\<0\>\/XI2\<1\>\/XI2\<0\>\/RR6_neg \
 ) R_1X_LL w=1e-07 l=1e-07   res=0.149966
XXI2\<0\>\/XI2\<1\>\/XI2\<0\>\/XI2\<0\>\/XI2\<1\>\/XI2\<0\>\/XI2\<1\>\/XI2\<0\>\/RR5 \
 (  \
 N_SEL7\<0\>_XI2\<0\>\/XI2\<1\>\/XI2\<0\>\/XI2\<0\>\/XI2\<1\>\/XI2\<0\>\/XI2\<1\>\/XI2\<0\>\/RR5_pos \
 N_WLSEL\<599\>_XI2\<0\>\/XI2\<1\>\/XI2\<0\>\/XI2\<0\>\/XI2\<1\>\/XI2\<0\>\/XI2\<1\>\/XI2\<0\>\/RR5_neg \
 ) R_1X_LL w=1e-07 l=1e-07   res=0.149966
XXI2\<0\>\/XI2\<1\>\/XI2\<0\>\/XI2\<0\>\/XI2\<1\>\/XI2\<0\>\/XI2\<1\>\/XI2\<1\>\/RR0 \
 (  \
 N_SEL0\<1\>_XI2\<0\>\/XI2\<1\>\/XI2\<0\>\/XI2\<0\>\/XI2\<1\>\/XI2\<0\>\/XI2\<1\>\/XI2\<1\>\/RR0_pos \
 N_WLSEL\<600\>_XI2\<0\>\/XI2\<1\>\/XI2\<0\>\/XI2\<0\>\/XI2\<1\>\/XI2\<0\>\/XI2\<1\>\/XI2\<1\>\/RR0_neg \
 ) R_1X_LL w=1e-07 l=1e-07   res=0.149966
XXI2\<0\>\/XI2\<1\>\/XI2\<0\>\/XI2\<0\>\/XI2\<1\>\/XI2\<0\>\/XI2\<1\>\/XI2\<1\>\/RR1 \
 (  \
 N_SEL1\<1\>_XI2\<0\>\/XI2\<1\>\/XI2\<0\>\/XI2\<0\>\/XI2\<1\>\/XI2\<0\>\/XI2\<1\>\/XI2\<1\>\/RR1_pos \
 N_WLSEL\<601\>_XI2\<0\>\/XI2\<1\>\/XI2\<0\>\/XI2\<0\>\/XI2\<1\>\/XI2\<0\>\/XI2\<1\>\/XI2\<1\>\/RR1_neg \
 ) R_1X_LL w=1e-07 l=1e-07   res=0.149966
XXI2\<0\>\/XI2\<1\>\/XI2\<0\>\/XI2\<0\>\/XI2\<1\>\/XI2\<0\>\/XI2\<1\>\/XI2\<1\>\/RR2 \
 (  \
 N_SEL2\<0\>_XI2\<0\>\/XI2\<1\>\/XI2\<0\>\/XI2\<0\>\/XI2\<1\>\/XI2\<0\>\/XI2\<1\>\/XI2\<1\>\/RR2_pos \
 N_WLSEL\<602\>_XI2\<0\>\/XI2\<1\>\/XI2\<0\>\/XI2\<0\>\/XI2\<1\>\/XI2\<0\>\/XI2\<1\>\/XI2\<1\>\/RR2_neg \
 ) R_1X_LL w=1e-07 l=1e-07   res=0.149966
XXI2\<0\>\/XI2\<1\>\/XI2\<0\>\/XI2\<0\>\/XI2\<1\>\/XI2\<0\>\/XI2\<1\>\/XI2\<1\>\/RR3 \
 (  \
 N_SEL3\<1\>_XI2\<0\>\/XI2\<1\>\/XI2\<0\>\/XI2\<0\>\/XI2\<1\>\/XI2\<0\>\/XI2\<1\>\/XI2\<1\>\/RR3_pos \
 N_WLSEL\<603\>_XI2\<0\>\/XI2\<1\>\/XI2\<0\>\/XI2\<0\>\/XI2\<1\>\/XI2\<0\>\/XI2\<1\>\/XI2\<1\>\/RR3_neg \
 ) R_1X_LL w=1e-07 l=1e-07   res=0.149966
XXI2\<0\>\/XI2\<1\>\/XI2\<0\>\/XI2\<0\>\/XI2\<1\>\/XI2\<0\>\/XI2\<1\>\/XI2\<1\>\/RR4 \
 (  \
 N_SEL4\<0\>_XI2\<0\>\/XI2\<1\>\/XI2\<0\>\/XI2\<0\>\/XI2\<1\>\/XI2\<0\>\/XI2\<1\>\/XI2\<1\>\/RR4_pos \
 N_WLSEL\<604\>_XI2\<0\>\/XI2\<1\>\/XI2\<0\>\/XI2\<0\>\/XI2\<1\>\/XI2\<0\>\/XI2\<1\>\/XI2\<1\>\/RR4_neg \
 ) R_1X_LL w=1e-07 l=1e-07   res=0.149966
XXI2\<0\>\/XI2\<1\>\/XI2\<0\>\/XI2\<0\>\/XI2\<1\>\/XI2\<0\>\/XI2\<1\>\/XI2\<1\>\/RR7 \
 (  \
 N_SEL5\<0\>_XI2\<0\>\/XI2\<1\>\/XI2\<0\>\/XI2\<0\>\/XI2\<1\>\/XI2\<0\>\/XI2\<1\>\/XI2\<1\>\/RR7_pos \
 N_WLSEL\<605\>_XI2\<0\>\/XI2\<1\>\/XI2\<0\>\/XI2\<0\>\/XI2\<1\>\/XI2\<0\>\/XI2\<1\>\/XI2\<1\>\/RR7_neg \
 ) R_1X_LL w=1e-07 l=1e-07   res=0.149966
XXI2\<0\>\/XI2\<1\>\/XI2\<0\>\/XI2\<0\>\/XI2\<1\>\/XI2\<0\>\/XI2\<1\>\/XI2\<1\>\/RR6 \
 (  \
 N_SEL6\<1\>_XI2\<0\>\/XI2\<1\>\/XI2\<0\>\/XI2\<0\>\/XI2\<1\>\/XI2\<0\>\/XI2\<1\>\/XI2\<1\>\/RR6_pos \
 N_WLSEL\<606\>_XI2\<0\>\/XI2\<1\>\/XI2\<0\>\/XI2\<0\>\/XI2\<1\>\/XI2\<0\>\/XI2\<1\>\/XI2\<1\>\/RR6_neg \
 ) R_1X_LL w=1e-07 l=1e-07   res=0.149966
XXI2\<0\>\/XI2\<1\>\/XI2\<0\>\/XI2\<0\>\/XI2\<1\>\/XI2\<0\>\/XI2\<1\>\/XI2\<1\>\/RR5 \
 (  \
 N_SEL7\<0\>_XI2\<0\>\/XI2\<1\>\/XI2\<0\>\/XI2\<0\>\/XI2\<1\>\/XI2\<0\>\/XI2\<1\>\/XI2\<1\>\/RR5_pos \
 N_WLSEL\<607\>_XI2\<0\>\/XI2\<1\>\/XI2\<0\>\/XI2\<0\>\/XI2\<1\>\/XI2\<0\>\/XI2\<1\>\/XI2\<1\>\/RR5_neg \
 ) R_1X_LL w=1e-07 l=1e-07   res=0.149966
XXI2\<0\>\/XI2\<1\>\/XI2\<0\>\/XI2\<0\>\/XI2\<1\>\/XI2\<1\>\/XI2\<0\>\/XI2\<0\>\/RR0 \
 (  \
 N_SEL0\<0\>_XI2\<0\>\/XI2\<1\>\/XI2\<0\>\/XI2\<0\>\/XI2\<1\>\/XI2\<1\>\/XI2\<0\>\/XI2\<0\>\/RR0_pos \
 N_WLSEL\<608\>_XI2\<0\>\/XI2\<1\>\/XI2\<0\>\/XI2\<0\>\/XI2\<1\>\/XI2\<1\>\/XI2\<0\>\/XI2\<0\>\/RR0_neg \
 ) R_1X_LL w=1e-07 l=1e-07   res=0.149966
XXI2\<0\>\/XI2\<1\>\/XI2\<0\>\/XI2\<0\>\/XI2\<1\>\/XI2\<1\>\/XI2\<0\>\/XI2\<0\>\/RR1 \
 (  \
 N_SEL1\<0\>_XI2\<0\>\/XI2\<1\>\/XI2\<0\>\/XI2\<0\>\/XI2\<1\>\/XI2\<1\>\/XI2\<0\>\/XI2\<0\>\/RR1_pos \
 N_WLSEL\<609\>_XI2\<0\>\/XI2\<1\>\/XI2\<0\>\/XI2\<0\>\/XI2\<1\>\/XI2\<1\>\/XI2\<0\>\/XI2\<0\>\/RR1_neg \
 ) R_1X_LL w=1e-07 l=1e-07   res=0.149966
XXI2\<0\>\/XI2\<1\>\/XI2\<0\>\/XI2\<0\>\/XI2\<1\>\/XI2\<1\>\/XI2\<0\>\/XI2\<0\>\/RR2 \
 (  \
 N_SEL2\<1\>_XI2\<0\>\/XI2\<1\>\/XI2\<0\>\/XI2\<0\>\/XI2\<1\>\/XI2\<1\>\/XI2\<0\>\/XI2\<0\>\/RR2_pos \
 N_WLSEL\<610\>_XI2\<0\>\/XI2\<1\>\/XI2\<0\>\/XI2\<0\>\/XI2\<1\>\/XI2\<1\>\/XI2\<0\>\/XI2\<0\>\/RR2_neg \
 ) R_1X_LL w=1e-07 l=1e-07   res=0.149966
XXI2\<0\>\/XI2\<1\>\/XI2\<0\>\/XI2\<0\>\/XI2\<1\>\/XI2\<1\>\/XI2\<0\>\/XI2\<0\>\/RR3 \
 (  \
 N_SEL3\<1\>_XI2\<0\>\/XI2\<1\>\/XI2\<0\>\/XI2\<0\>\/XI2\<1\>\/XI2\<1\>\/XI2\<0\>\/XI2\<0\>\/RR3_pos \
 N_WLSEL\<611\>_XI2\<0\>\/XI2\<1\>\/XI2\<0\>\/XI2\<0\>\/XI2\<1\>\/XI2\<1\>\/XI2\<0\>\/XI2\<0\>\/RR3_neg \
 ) R_1X_LL w=1e-07 l=1e-07   res=0.149966
XXI2\<0\>\/XI2\<1\>\/XI2\<0\>\/XI2\<0\>\/XI2\<1\>\/XI2\<1\>\/XI2\<0\>\/XI2\<0\>\/RR4 \
 (  \
 N_SEL4\<0\>_XI2\<0\>\/XI2\<1\>\/XI2\<0\>\/XI2\<0\>\/XI2\<1\>\/XI2\<1\>\/XI2\<0\>\/XI2\<0\>\/RR4_pos \
 N_WLSEL\<612\>_XI2\<0\>\/XI2\<1\>\/XI2\<0\>\/XI2\<0\>\/XI2\<1\>\/XI2\<1\>\/XI2\<0\>\/XI2\<0\>\/RR4_neg \
 ) R_1X_LL w=1e-07 l=1e-07   res=0.149966
XXI2\<0\>\/XI2\<1\>\/XI2\<0\>\/XI2\<0\>\/XI2\<1\>\/XI2\<1\>\/XI2\<0\>\/XI2\<0\>\/RR7 \
 (  \
 N_SEL5\<0\>_XI2\<0\>\/XI2\<1\>\/XI2\<0\>\/XI2\<0\>\/XI2\<1\>\/XI2\<1\>\/XI2\<0\>\/XI2\<0\>\/RR7_pos \
 N_WLSEL\<613\>_XI2\<0\>\/XI2\<1\>\/XI2\<0\>\/XI2\<0\>\/XI2\<1\>\/XI2\<1\>\/XI2\<0\>\/XI2\<0\>\/RR7_neg \
 ) R_1X_LL w=1e-07 l=1e-07   res=0.149966
XXI2\<0\>\/XI2\<1\>\/XI2\<0\>\/XI2\<0\>\/XI2\<1\>\/XI2\<1\>\/XI2\<0\>\/XI2\<0\>\/RR6 \
 (  \
 N_SEL6\<1\>_XI2\<0\>\/XI2\<1\>\/XI2\<0\>\/XI2\<0\>\/XI2\<1\>\/XI2\<1\>\/XI2\<0\>\/XI2\<0\>\/RR6_pos \
 N_WLSEL\<614\>_XI2\<0\>\/XI2\<1\>\/XI2\<0\>\/XI2\<0\>\/XI2\<1\>\/XI2\<1\>\/XI2\<0\>\/XI2\<0\>\/RR6_neg \
 ) R_1X_LL w=1e-07 l=1e-07   res=0.149966
XXI2\<0\>\/XI2\<1\>\/XI2\<0\>\/XI2\<0\>\/XI2\<1\>\/XI2\<1\>\/XI2\<0\>\/XI2\<0\>\/RR5 \
 (  \
 N_SEL7\<0\>_XI2\<0\>\/XI2\<1\>\/XI2\<0\>\/XI2\<0\>\/XI2\<1\>\/XI2\<1\>\/XI2\<0\>\/XI2\<0\>\/RR5_pos \
 N_WLSEL\<615\>_XI2\<0\>\/XI2\<1\>\/XI2\<0\>\/XI2\<0\>\/XI2\<1\>\/XI2\<1\>\/XI2\<0\>\/XI2\<0\>\/RR5_neg \
 ) R_1X_LL w=1e-07 l=1e-07   res=0.149966
XXI2\<0\>\/XI2\<1\>\/XI2\<0\>\/XI2\<0\>\/XI2\<1\>\/XI2\<1\>\/XI2\<0\>\/XI2\<1\>\/RR0 \
 (  \
 N_SEL0\<1\>_XI2\<0\>\/XI2\<1\>\/XI2\<0\>\/XI2\<0\>\/XI2\<1\>\/XI2\<1\>\/XI2\<0\>\/XI2\<1\>\/RR0_pos \
 N_WLSEL\<616\>_XI2\<0\>\/XI2\<1\>\/XI2\<0\>\/XI2\<0\>\/XI2\<1\>\/XI2\<1\>\/XI2\<0\>\/XI2\<1\>\/RR0_neg \
 ) R_1X_LL w=1e-07 l=1e-07   res=0.149966
XXI2\<0\>\/XI2\<1\>\/XI2\<0\>\/XI2\<0\>\/XI2\<1\>\/XI2\<1\>\/XI2\<0\>\/XI2\<1\>\/RR1 \
 (  \
 N_SEL1\<0\>_XI2\<0\>\/XI2\<1\>\/XI2\<0\>\/XI2\<0\>\/XI2\<1\>\/XI2\<1\>\/XI2\<0\>\/XI2\<1\>\/RR1_pos \
 N_WLSEL\<617\>_XI2\<0\>\/XI2\<1\>\/XI2\<0\>\/XI2\<0\>\/XI2\<1\>\/XI2\<1\>\/XI2\<0\>\/XI2\<1\>\/RR1_neg \
 ) R_1X_LL w=1e-07 l=1e-07   res=0.149966
XXI2\<0\>\/XI2\<1\>\/XI2\<0\>\/XI2\<0\>\/XI2\<1\>\/XI2\<1\>\/XI2\<0\>\/XI2\<1\>\/RR2 \
 (  \
 N_SEL2\<1\>_XI2\<0\>\/XI2\<1\>\/XI2\<0\>\/XI2\<0\>\/XI2\<1\>\/XI2\<1\>\/XI2\<0\>\/XI2\<1\>\/RR2_pos \
 N_WLSEL\<618\>_XI2\<0\>\/XI2\<1\>\/XI2\<0\>\/XI2\<0\>\/XI2\<1\>\/XI2\<1\>\/XI2\<0\>\/XI2\<1\>\/RR2_neg \
 ) R_1X_LL w=1e-07 l=1e-07   res=0.149966
XXI2\<0\>\/XI2\<1\>\/XI2\<0\>\/XI2\<0\>\/XI2\<1\>\/XI2\<1\>\/XI2\<0\>\/XI2\<1\>\/RR3 \
 (  \
 N_SEL3\<1\>_XI2\<0\>\/XI2\<1\>\/XI2\<0\>\/XI2\<0\>\/XI2\<1\>\/XI2\<1\>\/XI2\<0\>\/XI2\<1\>\/RR3_pos \
 N_WLSEL\<619\>_XI2\<0\>\/XI2\<1\>\/XI2\<0\>\/XI2\<0\>\/XI2\<1\>\/XI2\<1\>\/XI2\<0\>\/XI2\<1\>\/RR3_neg \
 ) R_1X_LL w=1e-07 l=1e-07   res=0.149966
XXI2\<0\>\/XI2\<1\>\/XI2\<0\>\/XI2\<0\>\/XI2\<1\>\/XI2\<1\>\/XI2\<0\>\/XI2\<1\>\/RR4 \
 (  \
 N_SEL4\<0\>_XI2\<0\>\/XI2\<1\>\/XI2\<0\>\/XI2\<0\>\/XI2\<1\>\/XI2\<1\>\/XI2\<0\>\/XI2\<1\>\/RR4_pos \
 N_WLSEL\<620\>_XI2\<0\>\/XI2\<1\>\/XI2\<0\>\/XI2\<0\>\/XI2\<1\>\/XI2\<1\>\/XI2\<0\>\/XI2\<1\>\/RR4_neg \
 ) R_1X_LL w=1e-07 l=1e-07   res=0.149966
XXI2\<0\>\/XI2\<0\>\/XI2\<0\>\/XI2\<0\>\/XI2\<0\>\/XI2\<0\>\/XI2\<1\>\/XI2\<1\>\/RR7 \
 (  \
 N_SEL5\<0\>_XI2\<0\>\/XI2\<0\>\/XI2\<0\>\/XI2\<0\>\/XI2\<0\>\/XI2\<0\>\/XI2\<1\>\/XI2\<1\>\/RR7_pos \
 N_WLSEL\<29\>_XI2\<0\>\/XI2\<0\>\/XI2\<0\>\/XI2\<0\>\/XI2\<0\>\/XI2\<0\>\/XI2\<1\>\/XI2\<1\>\/RR7_neg \
 ) R_1X_LL w=1e-07 l=1e-07   res=0.149966
XXI2\<0\>\/XI2\<0\>\/XI2\<0\>\/XI2\<0\>\/XI2\<0\>\/XI2\<0\>\/XI2\<1\>\/XI2\<1\>\/RR6 \
 (  \
 N_SEL6\<0\>_XI2\<0\>\/XI2\<0\>\/XI2\<0\>\/XI2\<0\>\/XI2\<0\>\/XI2\<0\>\/XI2\<1\>\/XI2\<1\>\/RR6_pos \
 N_WLSEL\<30\>_XI2\<0\>\/XI2\<0\>\/XI2\<0\>\/XI2\<0\>\/XI2\<0\>\/XI2\<0\>\/XI2\<1\>\/XI2\<1\>\/RR6_neg \
 ) R_1X_LL w=1e-07 l=1e-07   res=0.149966
XXI2\<0\>\/XI2\<0\>\/XI2\<0\>\/XI2\<0\>\/XI2\<0\>\/XI2\<0\>\/XI2\<1\>\/XI2\<1\>\/RR5 \
 (  \
 N_SEL7\<0\>_XI2\<0\>\/XI2\<0\>\/XI2\<0\>\/XI2\<0\>\/XI2\<0\>\/XI2\<0\>\/XI2\<1\>\/XI2\<1\>\/RR5_pos \
 N_WLSEL\<31\>_XI2\<0\>\/XI2\<0\>\/XI2\<0\>\/XI2\<0\>\/XI2\<0\>\/XI2\<0\>\/XI2\<1\>\/XI2\<1\>\/RR5_neg \
 ) R_1X_LL w=1e-07 l=1e-07   res=0.149966
XXI2\<0\>\/XI2\<0\>\/XI2\<0\>\/XI2\<0\>\/XI2\<0\>\/XI2\<1\>\/XI2\<0\>\/XI2\<0\>\/RR0 \
 (  \
 N_SEL0\<0\>_XI2\<0\>\/XI2\<0\>\/XI2\<0\>\/XI2\<0\>\/XI2\<0\>\/XI2\<1\>\/XI2\<0\>\/XI2\<0\>\/RR0_pos \
 N_WLSEL\<32\>_XI2\<0\>\/XI2\<0\>\/XI2\<0\>\/XI2\<0\>\/XI2\<0\>\/XI2\<1\>\/XI2\<0\>\/XI2\<0\>\/RR0_neg \
 ) R_1X_LL w=1e-07 l=1e-07   res=0.149966
XXI2\<0\>\/XI2\<0\>\/XI2\<0\>\/XI2\<0\>\/XI2\<0\>\/XI2\<1\>\/XI2\<0\>\/XI2\<0\>\/RR1 \
 (  \
 N_SEL1\<0\>_XI2\<0\>\/XI2\<0\>\/XI2\<0\>\/XI2\<0\>\/XI2\<0\>\/XI2\<1\>\/XI2\<0\>\/XI2\<0\>\/RR1_pos \
 N_WLSEL\<33\>_XI2\<0\>\/XI2\<0\>\/XI2\<0\>\/XI2\<0\>\/XI2\<0\>\/XI2\<1\>\/XI2\<0\>\/XI2\<0\>\/RR1_neg \
 ) R_1X_LL w=1e-07 l=1e-07   res=0.149966
XXI2\<0\>\/XI2\<0\>\/XI2\<0\>\/XI2\<0\>\/XI2\<0\>\/XI2\<1\>\/XI2\<0\>\/XI2\<0\>\/RR2 \
 (  \
 N_SEL2\<1\>_XI2\<0\>\/XI2\<0\>\/XI2\<0\>\/XI2\<0\>\/XI2\<0\>\/XI2\<1\>\/XI2\<0\>\/XI2\<0\>\/RR2_pos \
 N_WLSEL\<34\>_XI2\<0\>\/XI2\<0\>\/XI2\<0\>\/XI2\<0\>\/XI2\<0\>\/XI2\<1\>\/XI2\<0\>\/XI2\<0\>\/RR2_neg \
 ) R_1X_LL w=1e-07 l=1e-07   res=0.149966
XXI2\<0\>\/XI2\<0\>\/XI2\<0\>\/XI2\<0\>\/XI2\<0\>\/XI2\<1\>\/XI2\<0\>\/XI2\<0\>\/RR3 \
 (  \
 N_SEL3\<0\>_XI2\<0\>\/XI2\<0\>\/XI2\<0\>\/XI2\<0\>\/XI2\<0\>\/XI2\<1\>\/XI2\<0\>\/XI2\<0\>\/RR3_pos \
 N_WLSEL\<35\>_XI2\<0\>\/XI2\<0\>\/XI2\<0\>\/XI2\<0\>\/XI2\<0\>\/XI2\<1\>\/XI2\<0\>\/XI2\<0\>\/RR3_neg \
 ) R_1X_LL w=1e-07 l=1e-07   res=0.149966
XXI2\<0\>\/XI2\<0\>\/XI2\<0\>\/XI2\<0\>\/XI2\<0\>\/XI2\<1\>\/XI2\<0\>\/XI2\<0\>\/RR4 \
 (  \
 N_SEL4\<0\>_XI2\<0\>\/XI2\<0\>\/XI2\<0\>\/XI2\<0\>\/XI2\<0\>\/XI2\<1\>\/XI2\<0\>\/XI2\<0\>\/RR4_pos \
 N_WLSEL\<36\>_XI2\<0\>\/XI2\<0\>\/XI2\<0\>\/XI2\<0\>\/XI2\<0\>\/XI2\<1\>\/XI2\<0\>\/XI2\<0\>\/RR4_neg \
 ) R_1X_LL w=1e-07 l=1e-07   res=0.149966
XXI2\<0\>\/XI2\<0\>\/XI2\<0\>\/XI2\<0\>\/XI2\<0\>\/XI2\<1\>\/XI2\<0\>\/XI2\<0\>\/RR7 \
 (  \
 N_SEL5\<0\>_XI2\<0\>\/XI2\<0\>\/XI2\<0\>\/XI2\<0\>\/XI2\<0\>\/XI2\<1\>\/XI2\<0\>\/XI2\<0\>\/RR7_pos \
 N_WLSEL\<37\>_XI2\<0\>\/XI2\<0\>\/XI2\<0\>\/XI2\<0\>\/XI2\<0\>\/XI2\<1\>\/XI2\<0\>\/XI2\<0\>\/RR7_neg \
 ) R_1X_LL w=1e-07 l=1e-07   res=0.149966
XXI2\<0\>\/XI2\<0\>\/XI2\<0\>\/XI2\<0\>\/XI2\<0\>\/XI2\<1\>\/XI2\<0\>\/XI2\<0\>\/RR6 \
 (  \
 N_SEL6\<0\>_XI2\<0\>\/XI2\<0\>\/XI2\<0\>\/XI2\<0\>\/XI2\<0\>\/XI2\<1\>\/XI2\<0\>\/XI2\<0\>\/RR6_pos \
 N_WLSEL\<38\>_XI2\<0\>\/XI2\<0\>\/XI2\<0\>\/XI2\<0\>\/XI2\<0\>\/XI2\<1\>\/XI2\<0\>\/XI2\<0\>\/RR6_neg \
 ) R_1X_LL w=1e-07 l=1e-07   res=0.149966
XXI2\<0\>\/XI2\<0\>\/XI2\<0\>\/XI2\<0\>\/XI2\<0\>\/XI2\<1\>\/XI2\<0\>\/XI2\<0\>\/RR5 \
 (  \
 N_SEL7\<0\>_XI2\<0\>\/XI2\<0\>\/XI2\<0\>\/XI2\<0\>\/XI2\<0\>\/XI2\<1\>\/XI2\<0\>\/XI2\<0\>\/RR5_pos \
 N_WLSEL\<39\>_XI2\<0\>\/XI2\<0\>\/XI2\<0\>\/XI2\<0\>\/XI2\<0\>\/XI2\<1\>\/XI2\<0\>\/XI2\<0\>\/RR5_neg \
 ) R_1X_LL w=1e-07 l=1e-07   res=0.149966
XXI2\<0\>\/XI2\<0\>\/XI2\<0\>\/XI2\<0\>\/XI2\<0\>\/XI2\<1\>\/XI2\<0\>\/XI2\<1\>\/RR0 \
 (  \
 N_SEL0\<1\>_XI2\<0\>\/XI2\<0\>\/XI2\<0\>\/XI2\<0\>\/XI2\<0\>\/XI2\<1\>\/XI2\<0\>\/XI2\<1\>\/RR0_pos \
 N_WLSEL\<40\>_XI2\<0\>\/XI2\<0\>\/XI2\<0\>\/XI2\<0\>\/XI2\<0\>\/XI2\<1\>\/XI2\<0\>\/XI2\<1\>\/RR0_neg \
 ) R_1X_LL w=1e-07 l=1e-07   res=0.149966
XXI2\<0\>\/XI2\<0\>\/XI2\<0\>\/XI2\<0\>\/XI2\<0\>\/XI2\<1\>\/XI2\<0\>\/XI2\<1\>\/RR1 \
 (  \
 N_SEL1\<0\>_XI2\<0\>\/XI2\<0\>\/XI2\<0\>\/XI2\<0\>\/XI2\<0\>\/XI2\<1\>\/XI2\<0\>\/XI2\<1\>\/RR1_pos \
 N_WLSEL\<41\>_XI2\<0\>\/XI2\<0\>\/XI2\<0\>\/XI2\<0\>\/XI2\<0\>\/XI2\<1\>\/XI2\<0\>\/XI2\<1\>\/RR1_neg \
 ) R_1X_LL w=1e-07 l=1e-07   res=0.149966
XXI2\<0\>\/XI2\<0\>\/XI2\<0\>\/XI2\<0\>\/XI2\<0\>\/XI2\<1\>\/XI2\<0\>\/XI2\<1\>\/RR2 \
 (  \
 N_SEL2\<1\>_XI2\<0\>\/XI2\<0\>\/XI2\<0\>\/XI2\<0\>\/XI2\<0\>\/XI2\<1\>\/XI2\<0\>\/XI2\<1\>\/RR2_pos \
 N_WLSEL\<42\>_XI2\<0\>\/XI2\<0\>\/XI2\<0\>\/XI2\<0\>\/XI2\<0\>\/XI2\<1\>\/XI2\<0\>\/XI2\<1\>\/RR2_neg \
 ) R_1X_LL w=1e-07 l=1e-07   res=0.149966
XXI2\<0\>\/XI2\<0\>\/XI2\<0\>\/XI2\<0\>\/XI2\<0\>\/XI2\<1\>\/XI2\<0\>\/XI2\<1\>\/RR3 \
 (  \
 N_SEL3\<0\>_XI2\<0\>\/XI2\<0\>\/XI2\<0\>\/XI2\<0\>\/XI2\<0\>\/XI2\<1\>\/XI2\<0\>\/XI2\<1\>\/RR3_pos \
 N_WLSEL\<43\>_XI2\<0\>\/XI2\<0\>\/XI2\<0\>\/XI2\<0\>\/XI2\<0\>\/XI2\<1\>\/XI2\<0\>\/XI2\<1\>\/RR3_neg \
 ) R_1X_LL w=1e-07 l=1e-07   res=0.149966
XXI2\<0\>\/XI2\<0\>\/XI2\<0\>\/XI2\<0\>\/XI2\<0\>\/XI2\<1\>\/XI2\<0\>\/XI2\<1\>\/RR4 \
 (  \
 N_SEL4\<0\>_XI2\<0\>\/XI2\<0\>\/XI2\<0\>\/XI2\<0\>\/XI2\<0\>\/XI2\<1\>\/XI2\<0\>\/XI2\<1\>\/RR4_pos \
 N_WLSEL\<44\>_XI2\<0\>\/XI2\<0\>\/XI2\<0\>\/XI2\<0\>\/XI2\<0\>\/XI2\<1\>\/XI2\<0\>\/XI2\<1\>\/RR4_neg \
 ) R_1X_LL w=1e-07 l=1e-07   res=0.149966
XXI2\<0\>\/XI2\<0\>\/XI2\<0\>\/XI2\<0\>\/XI2\<0\>\/XI2\<1\>\/XI2\<0\>\/XI2\<1\>\/RR7 \
 (  \
 N_SEL5\<0\>_XI2\<0\>\/XI2\<0\>\/XI2\<0\>\/XI2\<0\>\/XI2\<0\>\/XI2\<1\>\/XI2\<0\>\/XI2\<1\>\/RR7_pos \
 N_WLSEL\<45\>_XI2\<0\>\/XI2\<0\>\/XI2\<0\>\/XI2\<0\>\/XI2\<0\>\/XI2\<1\>\/XI2\<0\>\/XI2\<1\>\/RR7_neg \
 ) R_1X_LL w=1e-07 l=1e-07   res=0.149966
XXI2\<0\>\/XI2\<0\>\/XI2\<0\>\/XI2\<0\>\/XI2\<0\>\/XI2\<1\>\/XI2\<0\>\/XI2\<1\>\/RR6 \
 (  \
 N_SEL6\<0\>_XI2\<0\>\/XI2\<0\>\/XI2\<0\>\/XI2\<0\>\/XI2\<0\>\/XI2\<1\>\/XI2\<0\>\/XI2\<1\>\/RR6_pos \
 N_WLSEL\<46\>_XI2\<0\>\/XI2\<0\>\/XI2\<0\>\/XI2\<0\>\/XI2\<0\>\/XI2\<1\>\/XI2\<0\>\/XI2\<1\>\/RR6_neg \
 ) R_1X_LL w=1e-07 l=1e-07   res=0.149966
XXI2\<0\>\/XI2\<0\>\/XI2\<0\>\/XI2\<0\>\/XI2\<0\>\/XI2\<1\>\/XI2\<0\>\/XI2\<1\>\/RR5 \
 (  \
 N_SEL7\<0\>_XI2\<0\>\/XI2\<0\>\/XI2\<0\>\/XI2\<0\>\/XI2\<0\>\/XI2\<1\>\/XI2\<0\>\/XI2\<1\>\/RR5_pos \
 N_WLSEL\<47\>_XI2\<0\>\/XI2\<0\>\/XI2\<0\>\/XI2\<0\>\/XI2\<0\>\/XI2\<1\>\/XI2\<0\>\/XI2\<1\>\/RR5_neg \
 ) R_1X_LL w=1e-07 l=1e-07   res=0.149966
XXI2\<0\>\/XI2\<0\>\/XI2\<0\>\/XI2\<0\>\/XI2\<0\>\/XI2\<1\>\/XI2\<1\>\/XI2\<0\>\/RR0 \
 (  \
 N_SEL0\<0\>_XI2\<0\>\/XI2\<0\>\/XI2\<0\>\/XI2\<0\>\/XI2\<0\>\/XI2\<1\>\/XI2\<1\>\/XI2\<0\>\/RR0_pos \
 N_WLSEL\<48\>_XI2\<0\>\/XI2\<0\>\/XI2\<0\>\/XI2\<0\>\/XI2\<0\>\/XI2\<1\>\/XI2\<1\>\/XI2\<0\>\/RR0_neg \
 ) R_1X_LL w=1e-07 l=1e-07   res=0.149966
XXI2\<0\>\/XI2\<0\>\/XI2\<0\>\/XI2\<0\>\/XI2\<0\>\/XI2\<1\>\/XI2\<1\>\/XI2\<0\>\/RR1 \
 (  \
 N_SEL1\<1\>_XI2\<0\>\/XI2\<0\>\/XI2\<0\>\/XI2\<0\>\/XI2\<0\>\/XI2\<1\>\/XI2\<1\>\/XI2\<0\>\/RR1_pos \
 N_WLSEL\<49\>_XI2\<0\>\/XI2\<0\>\/XI2\<0\>\/XI2\<0\>\/XI2\<0\>\/XI2\<1\>\/XI2\<1\>\/XI2\<0\>\/RR1_neg \
 ) R_1X_LL w=1e-07 l=1e-07   res=0.149966
XXI2\<0\>\/XI2\<0\>\/XI2\<0\>\/XI2\<0\>\/XI2\<0\>\/XI2\<1\>\/XI2\<1\>\/XI2\<0\>\/RR2 \
 (  \
 N_SEL2\<1\>_XI2\<0\>\/XI2\<0\>\/XI2\<0\>\/XI2\<0\>\/XI2\<0\>\/XI2\<1\>\/XI2\<1\>\/XI2\<0\>\/RR2_pos \
 N_WLSEL\<50\>_XI2\<0\>\/XI2\<0\>\/XI2\<0\>\/XI2\<0\>\/XI2\<0\>\/XI2\<1\>\/XI2\<1\>\/XI2\<0\>\/RR2_neg \
 ) R_1X_LL w=1e-07 l=1e-07   res=0.149966
XXI2\<0\>\/XI2\<0\>\/XI2\<0\>\/XI2\<0\>\/XI2\<0\>\/XI2\<1\>\/XI2\<1\>\/XI2\<0\>\/RR3 \
 (  \
 N_SEL3\<0\>_XI2\<0\>\/XI2\<0\>\/XI2\<0\>\/XI2\<0\>\/XI2\<0\>\/XI2\<1\>\/XI2\<1\>\/XI2\<0\>\/RR3_pos \
 N_WLSEL\<51\>_XI2\<0\>\/XI2\<0\>\/XI2\<0\>\/XI2\<0\>\/XI2\<0\>\/XI2\<1\>\/XI2\<1\>\/XI2\<0\>\/RR3_neg \
 ) R_1X_LL w=1e-07 l=1e-07   res=0.149966
XXI2\<0\>\/XI2\<0\>\/XI2\<0\>\/XI2\<0\>\/XI2\<0\>\/XI2\<1\>\/XI2\<1\>\/XI2\<0\>\/RR4 \
 (  \
 N_SEL4\<0\>_XI2\<0\>\/XI2\<0\>\/XI2\<0\>\/XI2\<0\>\/XI2\<0\>\/XI2\<1\>\/XI2\<1\>\/XI2\<0\>\/RR4_pos \
 N_WLSEL\<52\>_XI2\<0\>\/XI2\<0\>\/XI2\<0\>\/XI2\<0\>\/XI2\<0\>\/XI2\<1\>\/XI2\<1\>\/XI2\<0\>\/RR4_neg \
 ) R_1X_LL w=1e-07 l=1e-07   res=0.149966
XXI2\<0\>\/XI2\<0\>\/XI2\<0\>\/XI2\<0\>\/XI2\<0\>\/XI2\<1\>\/XI2\<1\>\/XI2\<0\>\/RR7 \
 (  \
 N_SEL5\<0\>_XI2\<0\>\/XI2\<0\>\/XI2\<0\>\/XI2\<0\>\/XI2\<0\>\/XI2\<1\>\/XI2\<1\>\/XI2\<0\>\/RR7_pos \
 N_WLSEL\<53\>_XI2\<0\>\/XI2\<0\>\/XI2\<0\>\/XI2\<0\>\/XI2\<0\>\/XI2\<1\>\/XI2\<1\>\/XI2\<0\>\/RR7_neg \
 ) R_1X_LL w=1e-07 l=1e-07   res=0.149966
XXI2\<0\>\/XI2\<0\>\/XI2\<0\>\/XI2\<0\>\/XI2\<0\>\/XI2\<1\>\/XI2\<1\>\/XI2\<0\>\/RR6 \
 (  \
 N_SEL6\<0\>_XI2\<0\>\/XI2\<0\>\/XI2\<0\>\/XI2\<0\>\/XI2\<0\>\/XI2\<1\>\/XI2\<1\>\/XI2\<0\>\/RR6_pos \
 N_WLSEL\<54\>_XI2\<0\>\/XI2\<0\>\/XI2\<0\>\/XI2\<0\>\/XI2\<0\>\/XI2\<1\>\/XI2\<1\>\/XI2\<0\>\/RR6_neg \
 ) R_1X_LL w=1e-07 l=1e-07   res=0.149966
XXI2\<0\>\/XI2\<0\>\/XI2\<0\>\/XI2\<0\>\/XI2\<0\>\/XI2\<1\>\/XI2\<1\>\/XI2\<0\>\/RR5 \
 (  \
 N_SEL7\<0\>_XI2\<0\>\/XI2\<0\>\/XI2\<0\>\/XI2\<0\>\/XI2\<0\>\/XI2\<1\>\/XI2\<1\>\/XI2\<0\>\/RR5_pos \
 N_WLSEL\<55\>_XI2\<0\>\/XI2\<0\>\/XI2\<0\>\/XI2\<0\>\/XI2\<0\>\/XI2\<1\>\/XI2\<1\>\/XI2\<0\>\/RR5_neg \
 ) R_1X_LL w=1e-07 l=1e-07   res=0.149966
XXI2\<0\>\/XI2\<0\>\/XI2\<0\>\/XI2\<0\>\/XI2\<0\>\/XI2\<1\>\/XI2\<1\>\/XI2\<1\>\/RR0 \
 (  \
 N_SEL0\<1\>_XI2\<0\>\/XI2\<0\>\/XI2\<0\>\/XI2\<0\>\/XI2\<0\>\/XI2\<1\>\/XI2\<1\>\/XI2\<1\>\/RR0_pos \
 N_WLSEL\<56\>_XI2\<0\>\/XI2\<0\>\/XI2\<0\>\/XI2\<0\>\/XI2\<0\>\/XI2\<1\>\/XI2\<1\>\/XI2\<1\>\/RR0_neg \
 ) R_1X_LL w=1e-07 l=1e-07   res=0.149966
XXI2\<0\>\/XI2\<0\>\/XI2\<0\>\/XI2\<0\>\/XI2\<0\>\/XI2\<1\>\/XI2\<1\>\/XI2\<1\>\/RR1 \
 (  \
 N_SEL1\<1\>_XI2\<0\>\/XI2\<0\>\/XI2\<0\>\/XI2\<0\>\/XI2\<0\>\/XI2\<1\>\/XI2\<1\>\/XI2\<1\>\/RR1_pos \
 N_WLSEL\<57\>_XI2\<0\>\/XI2\<0\>\/XI2\<0\>\/XI2\<0\>\/XI2\<0\>\/XI2\<1\>\/XI2\<1\>\/XI2\<1\>\/RR1_neg \
 ) R_1X_LL w=1e-07 l=1e-07   res=0.149966
XXI2\<0\>\/XI2\<0\>\/XI2\<0\>\/XI2\<0\>\/XI2\<0\>\/XI2\<1\>\/XI2\<1\>\/XI2\<1\>\/RR2 \
 (  \
 N_SEL2\<1\>_XI2\<0\>\/XI2\<0\>\/XI2\<0\>\/XI2\<0\>\/XI2\<0\>\/XI2\<1\>\/XI2\<1\>\/XI2\<1\>\/RR2_pos \
 N_WLSEL\<58\>_XI2\<0\>\/XI2\<0\>\/XI2\<0\>\/XI2\<0\>\/XI2\<0\>\/XI2\<1\>\/XI2\<1\>\/XI2\<1\>\/RR2_neg \
 ) R_1X_LL w=1e-07 l=1e-07   res=0.149966
XXI2\<0\>\/XI2\<0\>\/XI2\<0\>\/XI2\<0\>\/XI2\<0\>\/XI2\<1\>\/XI2\<1\>\/XI2\<1\>\/RR3 \
 (  \
 N_SEL3\<0\>_XI2\<0\>\/XI2\<0\>\/XI2\<0\>\/XI2\<0\>\/XI2\<0\>\/XI2\<1\>\/XI2\<1\>\/XI2\<1\>\/RR3_pos \
 N_WLSEL\<59\>_XI2\<0\>\/XI2\<0\>\/XI2\<0\>\/XI2\<0\>\/XI2\<0\>\/XI2\<1\>\/XI2\<1\>\/XI2\<1\>\/RR3_neg \
 ) R_1X_LL w=1e-07 l=1e-07   res=0.149966
XXI2\<0\>\/XI2\<0\>\/XI2\<0\>\/XI2\<0\>\/XI2\<0\>\/XI2\<1\>\/XI2\<1\>\/XI2\<1\>\/RR4 \
 (  \
 N_SEL4\<0\>_XI2\<0\>\/XI2\<0\>\/XI2\<0\>\/XI2\<0\>\/XI2\<0\>\/XI2\<1\>\/XI2\<1\>\/XI2\<1\>\/RR4_pos \
 N_WLSEL\<60\>_XI2\<0\>\/XI2\<0\>\/XI2\<0\>\/XI2\<0\>\/XI2\<0\>\/XI2\<1\>\/XI2\<1\>\/XI2\<1\>\/RR4_neg \
 ) R_1X_LL w=1e-07 l=1e-07   res=0.149966
XXI2\<0\>\/XI2\<0\>\/XI2\<0\>\/XI2\<0\>\/XI2\<0\>\/XI2\<1\>\/XI2\<1\>\/XI2\<1\>\/RR7 \
 (  \
 N_SEL5\<0\>_XI2\<0\>\/XI2\<0\>\/XI2\<0\>\/XI2\<0\>\/XI2\<0\>\/XI2\<1\>\/XI2\<1\>\/XI2\<1\>\/RR7_pos \
 N_WLSEL\<61\>_XI2\<0\>\/XI2\<0\>\/XI2\<0\>\/XI2\<0\>\/XI2\<0\>\/XI2\<1\>\/XI2\<1\>\/XI2\<1\>\/RR7_neg \
 ) R_1X_LL w=1e-07 l=1e-07   res=0.149966
XXI2\<0\>\/XI2\<0\>\/XI2\<0\>\/XI2\<0\>\/XI2\<0\>\/XI2\<1\>\/XI2\<1\>\/XI2\<1\>\/RR6 \
 (  \
 N_SEL6\<0\>_XI2\<0\>\/XI2\<0\>\/XI2\<0\>\/XI2\<0\>\/XI2\<0\>\/XI2\<1\>\/XI2\<1\>\/XI2\<1\>\/RR6_pos \
 N_WLSEL\<62\>_XI2\<0\>\/XI2\<0\>\/XI2\<0\>\/XI2\<0\>\/XI2\<0\>\/XI2\<1\>\/XI2\<1\>\/XI2\<1\>\/RR6_neg \
 ) R_1X_LL w=1e-07 l=1e-07   res=0.149966
XXI2\<0\>\/XI2\<0\>\/XI2\<0\>\/XI2\<0\>\/XI2\<0\>\/XI2\<1\>\/XI2\<1\>\/XI2\<1\>\/RR5 \
 (  \
 N_SEL7\<0\>_XI2\<0\>\/XI2\<0\>\/XI2\<0\>\/XI2\<0\>\/XI2\<0\>\/XI2\<1\>\/XI2\<1\>\/XI2\<1\>\/RR5_pos \
 N_WLSEL\<63\>_XI2\<0\>\/XI2\<0\>\/XI2\<0\>\/XI2\<0\>\/XI2\<0\>\/XI2\<1\>\/XI2\<1\>\/XI2\<1\>\/RR5_neg \
 ) R_1X_LL w=1e-07 l=1e-07   res=0.149966
XXI2\<0\>\/XI2\<0\>\/XI2\<0\>\/XI2\<0\>\/XI2\<1\>\/XI2\<0\>\/XI2\<0\>\/XI2\<0\>\/RR0 \
 (  \
 N_SEL0\<0\>_XI2\<0\>\/XI2\<0\>\/XI2\<0\>\/XI2\<0\>\/XI2\<1\>\/XI2\<0\>\/XI2\<0\>\/XI2\<0\>\/RR0_pos \
 N_WLSEL\<64\>_XI2\<0\>\/XI2\<0\>\/XI2\<0\>\/XI2\<0\>\/XI2\<1\>\/XI2\<0\>\/XI2\<0\>\/XI2\<0\>\/RR0_neg \
 ) R_1X_LL w=1e-07 l=1e-07   res=0.149966
XXI2\<0\>\/XI2\<0\>\/XI2\<0\>\/XI2\<0\>\/XI2\<1\>\/XI2\<0\>\/XI2\<0\>\/XI2\<0\>\/RR1 \
 (  \
 N_SEL1\<0\>_XI2\<0\>\/XI2\<0\>\/XI2\<0\>\/XI2\<0\>\/XI2\<1\>\/XI2\<0\>\/XI2\<0\>\/XI2\<0\>\/RR1_pos \
 N_WLSEL\<65\>_XI2\<0\>\/XI2\<0\>\/XI2\<0\>\/XI2\<0\>\/XI2\<1\>\/XI2\<0\>\/XI2\<0\>\/XI2\<0\>\/RR1_neg \
 ) R_1X_LL w=1e-07 l=1e-07   res=0.149966
XXI2\<0\>\/XI2\<0\>\/XI2\<0\>\/XI2\<0\>\/XI2\<1\>\/XI2\<0\>\/XI2\<0\>\/XI2\<0\>\/RR2 \
 (  \
 N_SEL2\<0\>_XI2\<0\>\/XI2\<0\>\/XI2\<0\>\/XI2\<0\>\/XI2\<1\>\/XI2\<0\>\/XI2\<0\>\/XI2\<0\>\/RR2_pos \
 N_WLSEL\<66\>_XI2\<0\>\/XI2\<0\>\/XI2\<0\>\/XI2\<0\>\/XI2\<1\>\/XI2\<0\>\/XI2\<0\>\/XI2\<0\>\/RR2_neg \
 ) R_1X_LL w=1e-07 l=1e-07   res=0.149966
XXI2\<0\>\/XI2\<0\>\/XI2\<0\>\/XI2\<0\>\/XI2\<1\>\/XI2\<0\>\/XI2\<0\>\/XI2\<0\>\/RR3 \
 (  \
 N_SEL3\<1\>_XI2\<0\>\/XI2\<0\>\/XI2\<0\>\/XI2\<0\>\/XI2\<1\>\/XI2\<0\>\/XI2\<0\>\/XI2\<0\>\/RR3_pos \
 N_WLSEL\<67\>_XI2\<0\>\/XI2\<0\>\/XI2\<0\>\/XI2\<0\>\/XI2\<1\>\/XI2\<0\>\/XI2\<0\>\/XI2\<0\>\/RR3_neg \
 ) R_1X_LL w=1e-07 l=1e-07   res=0.149966
XXI2\<0\>\/XI2\<0\>\/XI2\<0\>\/XI2\<0\>\/XI2\<1\>\/XI2\<0\>\/XI2\<0\>\/XI2\<0\>\/RR4 \
 (  \
 N_SEL4\<0\>_XI2\<0\>\/XI2\<0\>\/XI2\<0\>\/XI2\<0\>\/XI2\<1\>\/XI2\<0\>\/XI2\<0\>\/XI2\<0\>\/RR4_pos \
 N_WLSEL\<68\>_XI2\<0\>\/XI2\<0\>\/XI2\<0\>\/XI2\<0\>\/XI2\<1\>\/XI2\<0\>\/XI2\<0\>\/XI2\<0\>\/RR4_neg \
 ) R_1X_LL w=1e-07 l=1e-07   res=0.149966
XXI2\<0\>\/XI2\<0\>\/XI2\<0\>\/XI2\<0\>\/XI2\<1\>\/XI2\<0\>\/XI2\<0\>\/XI2\<0\>\/RR7 \
 (  \
 N_SEL5\<0\>_XI2\<0\>\/XI2\<0\>\/XI2\<0\>\/XI2\<0\>\/XI2\<1\>\/XI2\<0\>\/XI2\<0\>\/XI2\<0\>\/RR7_pos \
 N_WLSEL\<69\>_XI2\<0\>\/XI2\<0\>\/XI2\<0\>\/XI2\<0\>\/XI2\<1\>\/XI2\<0\>\/XI2\<0\>\/XI2\<0\>\/RR7_neg \
 ) R_1X_LL w=1e-07 l=1e-07   res=0.149966
XXI2\<0\>\/XI2\<0\>\/XI2\<0\>\/XI2\<0\>\/XI2\<1\>\/XI2\<0\>\/XI2\<0\>\/XI2\<0\>\/RR6 \
 (  \
 N_SEL6\<0\>_XI2\<0\>\/XI2\<0\>\/XI2\<0\>\/XI2\<0\>\/XI2\<1\>\/XI2\<0\>\/XI2\<0\>\/XI2\<0\>\/RR6_pos \
 N_WLSEL\<70\>_XI2\<0\>\/XI2\<0\>\/XI2\<0\>\/XI2\<0\>\/XI2\<1\>\/XI2\<0\>\/XI2\<0\>\/XI2\<0\>\/RR6_neg \
 ) R_1X_LL w=1e-07 l=1e-07   res=0.149966
XXI2\<0\>\/XI2\<0\>\/XI2\<0\>\/XI2\<0\>\/XI2\<1\>\/XI2\<0\>\/XI2\<0\>\/XI2\<0\>\/RR5 \
 (  \
 N_SEL7\<0\>_XI2\<0\>\/XI2\<0\>\/XI2\<0\>\/XI2\<0\>\/XI2\<1\>\/XI2\<0\>\/XI2\<0\>\/XI2\<0\>\/RR5_pos \
 N_WLSEL\<71\>_XI2\<0\>\/XI2\<0\>\/XI2\<0\>\/XI2\<0\>\/XI2\<1\>\/XI2\<0\>\/XI2\<0\>\/XI2\<0\>\/RR5_neg \
 ) R_1X_LL w=1e-07 l=1e-07   res=0.149966
XXI2\<0\>\/XI2\<0\>\/XI2\<0\>\/XI2\<0\>\/XI2\<1\>\/XI2\<0\>\/XI2\<0\>\/XI2\<1\>\/RR0 \
 (  \
 N_SEL0\<1\>_XI2\<0\>\/XI2\<0\>\/XI2\<0\>\/XI2\<0\>\/XI2\<1\>\/XI2\<0\>\/XI2\<0\>\/XI2\<1\>\/RR0_pos \
 N_WLSEL\<72\>_XI2\<0\>\/XI2\<0\>\/XI2\<0\>\/XI2\<0\>\/XI2\<1\>\/XI2\<0\>\/XI2\<0\>\/XI2\<1\>\/RR0_neg \
 ) R_1X_LL w=1e-07 l=1e-07   res=0.149966
XXI2\<0\>\/XI2\<0\>\/XI2\<0\>\/XI2\<0\>\/XI2\<1\>\/XI2\<0\>\/XI2\<0\>\/XI2\<1\>\/RR1 \
 (  \
 N_SEL1\<0\>_XI2\<0\>\/XI2\<0\>\/XI2\<0\>\/XI2\<0\>\/XI2\<1\>\/XI2\<0\>\/XI2\<0\>\/XI2\<1\>\/RR1_pos \
 N_WLSEL\<73\>_XI2\<0\>\/XI2\<0\>\/XI2\<0\>\/XI2\<0\>\/XI2\<1\>\/XI2\<0\>\/XI2\<0\>\/XI2\<1\>\/RR1_neg \
 ) R_1X_LL w=1e-07 l=1e-07   res=0.149966
XXI2\<0\>\/XI2\<0\>\/XI2\<0\>\/XI2\<0\>\/XI2\<1\>\/XI2\<0\>\/XI2\<0\>\/XI2\<1\>\/RR2 \
 (  \
 N_SEL2\<0\>_XI2\<0\>\/XI2\<0\>\/XI2\<0\>\/XI2\<0\>\/XI2\<1\>\/XI2\<0\>\/XI2\<0\>\/XI2\<1\>\/RR2_pos \
 N_WLSEL\<74\>_XI2\<0\>\/XI2\<0\>\/XI2\<0\>\/XI2\<0\>\/XI2\<1\>\/XI2\<0\>\/XI2\<0\>\/XI2\<1\>\/RR2_neg \
 ) R_1X_LL w=1e-07 l=1e-07   res=0.149966
XXI2\<0\>\/XI2\<0\>\/XI2\<0\>\/XI2\<0\>\/XI2\<1\>\/XI2\<0\>\/XI2\<0\>\/XI2\<1\>\/RR3 \
 (  \
 N_SEL3\<1\>_XI2\<0\>\/XI2\<0\>\/XI2\<0\>\/XI2\<0\>\/XI2\<1\>\/XI2\<0\>\/XI2\<0\>\/XI2\<1\>\/RR3_pos \
 N_WLSEL\<75\>_XI2\<0\>\/XI2\<0\>\/XI2\<0\>\/XI2\<0\>\/XI2\<1\>\/XI2\<0\>\/XI2\<0\>\/XI2\<1\>\/RR3_neg \
 ) R_1X_LL w=1e-07 l=1e-07   res=0.149966
XXI2\<0\>\/XI2\<0\>\/XI2\<0\>\/XI2\<0\>\/XI2\<1\>\/XI2\<0\>\/XI2\<0\>\/XI2\<1\>\/RR4 \
 (  \
 N_SEL4\<0\>_XI2\<0\>\/XI2\<0\>\/XI2\<0\>\/XI2\<0\>\/XI2\<1\>\/XI2\<0\>\/XI2\<0\>\/XI2\<1\>\/RR4_pos \
 N_WLSEL\<76\>_XI2\<0\>\/XI2\<0\>\/XI2\<0\>\/XI2\<0\>\/XI2\<1\>\/XI2\<0\>\/XI2\<0\>\/XI2\<1\>\/RR4_neg \
 ) R_1X_LL w=1e-07 l=1e-07   res=0.149966
XXI2\<0\>\/XI2\<0\>\/XI2\<0\>\/XI2\<0\>\/XI2\<1\>\/XI2\<0\>\/XI2\<0\>\/XI2\<1\>\/RR7 \
 (  \
 N_SEL5\<0\>_XI2\<0\>\/XI2\<0\>\/XI2\<0\>\/XI2\<0\>\/XI2\<1\>\/XI2\<0\>\/XI2\<0\>\/XI2\<1\>\/RR7_pos \
 N_WLSEL\<77\>_XI2\<0\>\/XI2\<0\>\/XI2\<0\>\/XI2\<0\>\/XI2\<1\>\/XI2\<0\>\/XI2\<0\>\/XI2\<1\>\/RR7_neg \
 ) R_1X_LL w=1e-07 l=1e-07   res=0.149966
XXI2\<0\>\/XI2\<0\>\/XI2\<0\>\/XI2\<0\>\/XI2\<1\>\/XI2\<0\>\/XI2\<0\>\/XI2\<1\>\/RR6 \
 (  \
 N_SEL6\<0\>_XI2\<0\>\/XI2\<0\>\/XI2\<0\>\/XI2\<0\>\/XI2\<1\>\/XI2\<0\>\/XI2\<0\>\/XI2\<1\>\/RR6_pos \
 N_WLSEL\<78\>_XI2\<0\>\/XI2\<0\>\/XI2\<0\>\/XI2\<0\>\/XI2\<1\>\/XI2\<0\>\/XI2\<0\>\/XI2\<1\>\/RR6_neg \
 ) R_1X_LL w=1e-07 l=1e-07   res=0.149966
XXI2\<0\>\/XI2\<0\>\/XI2\<0\>\/XI2\<0\>\/XI2\<1\>\/XI2\<0\>\/XI2\<0\>\/XI2\<1\>\/RR5 \
 (  \
 N_SEL7\<0\>_XI2\<0\>\/XI2\<0\>\/XI2\<0\>\/XI2\<0\>\/XI2\<1\>\/XI2\<0\>\/XI2\<0\>\/XI2\<1\>\/RR5_pos \
 N_WLSEL\<79\>_XI2\<0\>\/XI2\<0\>\/XI2\<0\>\/XI2\<0\>\/XI2\<1\>\/XI2\<0\>\/XI2\<0\>\/XI2\<1\>\/RR5_neg \
 ) R_1X_LL w=1e-07 l=1e-07   res=0.149966
XXI2\<0\>\/XI2\<0\>\/XI2\<0\>\/XI2\<0\>\/XI2\<1\>\/XI2\<0\>\/XI2\<1\>\/XI2\<0\>\/RR0 \
 (  \
 N_SEL0\<0\>_XI2\<0\>\/XI2\<0\>\/XI2\<0\>\/XI2\<0\>\/XI2\<1\>\/XI2\<0\>\/XI2\<1\>\/XI2\<0\>\/RR0_pos \
 N_WLSEL\<80\>_XI2\<0\>\/XI2\<0\>\/XI2\<0\>\/XI2\<0\>\/XI2\<1\>\/XI2\<0\>\/XI2\<1\>\/XI2\<0\>\/RR0_neg \
 ) R_1X_LL w=1e-07 l=1e-07   res=0.149966
XXI2\<0\>\/XI2\<0\>\/XI2\<0\>\/XI2\<0\>\/XI2\<1\>\/XI2\<0\>\/XI2\<1\>\/XI2\<0\>\/RR1 \
 (  \
 N_SEL1\<1\>_XI2\<0\>\/XI2\<0\>\/XI2\<0\>\/XI2\<0\>\/XI2\<1\>\/XI2\<0\>\/XI2\<1\>\/XI2\<0\>\/RR1_pos \
 N_WLSEL\<81\>_XI2\<0\>\/XI2\<0\>\/XI2\<0\>\/XI2\<0\>\/XI2\<1\>\/XI2\<0\>\/XI2\<1\>\/XI2\<0\>\/RR1_neg \
 ) R_1X_LL w=1e-07 l=1e-07   res=0.149966
XXI2\<0\>\/XI2\<0\>\/XI2\<0\>\/XI2\<0\>\/XI2\<1\>\/XI2\<0\>\/XI2\<1\>\/XI2\<0\>\/RR2 \
 (  \
 N_SEL2\<0\>_XI2\<0\>\/XI2\<0\>\/XI2\<0\>\/XI2\<0\>\/XI2\<1\>\/XI2\<0\>\/XI2\<1\>\/XI2\<0\>\/RR2_pos \
 N_WLSEL\<82\>_XI2\<0\>\/XI2\<0\>\/XI2\<0\>\/XI2\<0\>\/XI2\<1\>\/XI2\<0\>\/XI2\<1\>\/XI2\<0\>\/RR2_neg \
 ) R_1X_LL w=1e-07 l=1e-07   res=0.149966
XXI2\<0\>\/XI2\<0\>\/XI2\<0\>\/XI2\<0\>\/XI2\<1\>\/XI2\<0\>\/XI2\<1\>\/XI2\<0\>\/RR3 \
 (  \
 N_SEL3\<1\>_XI2\<0\>\/XI2\<0\>\/XI2\<0\>\/XI2\<0\>\/XI2\<1\>\/XI2\<0\>\/XI2\<1\>\/XI2\<0\>\/RR3_pos \
 N_WLSEL\<83\>_XI2\<0\>\/XI2\<0\>\/XI2\<0\>\/XI2\<0\>\/XI2\<1\>\/XI2\<0\>\/XI2\<1\>\/XI2\<0\>\/RR3_neg \
 ) R_1X_LL w=1e-07 l=1e-07   res=0.149966
XXI2\<0\>\/XI2\<0\>\/XI2\<0\>\/XI2\<0\>\/XI2\<1\>\/XI2\<0\>\/XI2\<1\>\/XI2\<0\>\/RR4 \
 (  \
 N_SEL4\<0\>_XI2\<0\>\/XI2\<0\>\/XI2\<0\>\/XI2\<0\>\/XI2\<1\>\/XI2\<0\>\/XI2\<1\>\/XI2\<0\>\/RR4_pos \
 N_WLSEL\<84\>_XI2\<0\>\/XI2\<0\>\/XI2\<0\>\/XI2\<0\>\/XI2\<1\>\/XI2\<0\>\/XI2\<1\>\/XI2\<0\>\/RR4_neg \
 ) R_1X_LL w=1e-07 l=1e-07   res=0.149966
XXI2\<0\>\/XI2\<0\>\/XI2\<0\>\/XI2\<0\>\/XI2\<1\>\/XI2\<0\>\/XI2\<1\>\/XI2\<0\>\/RR7 \
 (  \
 N_SEL5\<0\>_XI2\<0\>\/XI2\<0\>\/XI2\<0\>\/XI2\<0\>\/XI2\<1\>\/XI2\<0\>\/XI2\<1\>\/XI2\<0\>\/RR7_pos \
 N_WLSEL\<85\>_XI2\<0\>\/XI2\<0\>\/XI2\<0\>\/XI2\<0\>\/XI2\<1\>\/XI2\<0\>\/XI2\<1\>\/XI2\<0\>\/RR7_neg \
 ) R_1X_LL w=1e-07 l=1e-07   res=0.149966
XXI2\<0\>\/XI2\<0\>\/XI2\<0\>\/XI2\<0\>\/XI2\<1\>\/XI2\<0\>\/XI2\<1\>\/XI2\<0\>\/RR6 \
 (  \
 N_SEL6\<0\>_XI2\<0\>\/XI2\<0\>\/XI2\<0\>\/XI2\<0\>\/XI2\<1\>\/XI2\<0\>\/XI2\<1\>\/XI2\<0\>\/RR6_pos \
 N_WLSEL\<86\>_XI2\<0\>\/XI2\<0\>\/XI2\<0\>\/XI2\<0\>\/XI2\<1\>\/XI2\<0\>\/XI2\<1\>\/XI2\<0\>\/RR6_neg \
 ) R_1X_LL w=1e-07 l=1e-07   res=0.149966
XXI2\<0\>\/XI2\<0\>\/XI2\<0\>\/XI2\<0\>\/XI2\<1\>\/XI2\<0\>\/XI2\<1\>\/XI2\<0\>\/RR5 \
 (  \
 N_SEL7\<0\>_XI2\<0\>\/XI2\<0\>\/XI2\<0\>\/XI2\<0\>\/XI2\<1\>\/XI2\<0\>\/XI2\<1\>\/XI2\<0\>\/RR5_pos \
 N_WLSEL\<87\>_XI2\<0\>\/XI2\<0\>\/XI2\<0\>\/XI2\<0\>\/XI2\<1\>\/XI2\<0\>\/XI2\<1\>\/XI2\<0\>\/RR5_neg \
 ) R_1X_LL w=1e-07 l=1e-07   res=0.149966
XXI2\<0\>\/XI2\<0\>\/XI2\<0\>\/XI2\<0\>\/XI2\<1\>\/XI2\<0\>\/XI2\<1\>\/XI2\<1\>\/RR0 \
 (  \
 N_SEL0\<1\>_XI2\<0\>\/XI2\<0\>\/XI2\<0\>\/XI2\<0\>\/XI2\<1\>\/XI2\<0\>\/XI2\<1\>\/XI2\<1\>\/RR0_pos \
 N_WLSEL\<88\>_XI2\<0\>\/XI2\<0\>\/XI2\<0\>\/XI2\<0\>\/XI2\<1\>\/XI2\<0\>\/XI2\<1\>\/XI2\<1\>\/RR0_neg \
 ) R_1X_LL w=1e-07 l=1e-07   res=0.149966
XXI2\<0\>\/XI2\<0\>\/XI2\<0\>\/XI2\<0\>\/XI2\<1\>\/XI2\<0\>\/XI2\<1\>\/XI2\<1\>\/RR1 \
 (  \
 N_SEL1\<1\>_XI2\<0\>\/XI2\<0\>\/XI2\<0\>\/XI2\<0\>\/XI2\<1\>\/XI2\<0\>\/XI2\<1\>\/XI2\<1\>\/RR1_pos \
 N_WLSEL\<89\>_XI2\<0\>\/XI2\<0\>\/XI2\<0\>\/XI2\<0\>\/XI2\<1\>\/XI2\<0\>\/XI2\<1\>\/XI2\<1\>\/RR1_neg \
 ) R_1X_LL w=1e-07 l=1e-07   res=0.149966
XXI2\<0\>\/XI2\<0\>\/XI2\<0\>\/XI2\<0\>\/XI2\<1\>\/XI2\<0\>\/XI2\<1\>\/XI2\<1\>\/RR2 \
 (  \
 N_SEL2\<0\>_XI2\<0\>\/XI2\<0\>\/XI2\<0\>\/XI2\<0\>\/XI2\<1\>\/XI2\<0\>\/XI2\<1\>\/XI2\<1\>\/RR2_pos \
 N_WLSEL\<90\>_XI2\<0\>\/XI2\<0\>\/XI2\<0\>\/XI2\<0\>\/XI2\<1\>\/XI2\<0\>\/XI2\<1\>\/XI2\<1\>\/RR2_neg \
 ) R_1X_LL w=1e-07 l=1e-07   res=0.149966
XXI2\<0\>\/XI2\<0\>\/XI2\<0\>\/XI2\<0\>\/XI2\<1\>\/XI2\<0\>\/XI2\<1\>\/XI2\<1\>\/RR3 \
 (  \
 N_SEL3\<1\>_XI2\<0\>\/XI2\<0\>\/XI2\<0\>\/XI2\<0\>\/XI2\<1\>\/XI2\<0\>\/XI2\<1\>\/XI2\<1\>\/RR3_pos \
 N_WLSEL\<91\>_XI2\<0\>\/XI2\<0\>\/XI2\<0\>\/XI2\<0\>\/XI2\<1\>\/XI2\<0\>\/XI2\<1\>\/XI2\<1\>\/RR3_neg \
 ) R_1X_LL w=1e-07 l=1e-07   res=0.149966
XXI2\<0\>\/XI2\<0\>\/XI2\<0\>\/XI2\<0\>\/XI2\<1\>\/XI2\<0\>\/XI2\<1\>\/XI2\<1\>\/RR4 \
 (  \
 N_SEL4\<0\>_XI2\<0\>\/XI2\<0\>\/XI2\<0\>\/XI2\<0\>\/XI2\<1\>\/XI2\<0\>\/XI2\<1\>\/XI2\<1\>\/RR4_pos \
 N_WLSEL\<92\>_XI2\<0\>\/XI2\<0\>\/XI2\<0\>\/XI2\<0\>\/XI2\<1\>\/XI2\<0\>\/XI2\<1\>\/XI2\<1\>\/RR4_neg \
 ) R_1X_LL w=1e-07 l=1e-07   res=0.149966
XXI2\<0\>\/XI2\<0\>\/XI2\<0\>\/XI2\<0\>\/XI2\<1\>\/XI2\<0\>\/XI2\<1\>\/XI2\<1\>\/RR7 \
 (  \
 N_SEL5\<0\>_XI2\<0\>\/XI2\<0\>\/XI2\<0\>\/XI2\<0\>\/XI2\<1\>\/XI2\<0\>\/XI2\<1\>\/XI2\<1\>\/RR7_pos \
 N_WLSEL\<93\>_XI2\<0\>\/XI2\<0\>\/XI2\<0\>\/XI2\<0\>\/XI2\<1\>\/XI2\<0\>\/XI2\<1\>\/XI2\<1\>\/RR7_neg \
 ) R_1X_LL w=1e-07 l=1e-07   res=0.149966
XXI2\<0\>\/XI2\<0\>\/XI2\<0\>\/XI2\<0\>\/XI2\<1\>\/XI2\<0\>\/XI2\<1\>\/XI2\<1\>\/RR6 \
 (  \
 N_SEL6\<0\>_XI2\<0\>\/XI2\<0\>\/XI2\<0\>\/XI2\<0\>\/XI2\<1\>\/XI2\<0\>\/XI2\<1\>\/XI2\<1\>\/RR6_pos \
 N_WLSEL\<94\>_XI2\<0\>\/XI2\<0\>\/XI2\<0\>\/XI2\<0\>\/XI2\<1\>\/XI2\<0\>\/XI2\<1\>\/XI2\<1\>\/RR6_neg \
 ) R_1X_LL w=1e-07 l=1e-07   res=0.149966
XXI2\<0\>\/XI2\<0\>\/XI2\<0\>\/XI2\<0\>\/XI2\<1\>\/XI2\<0\>\/XI2\<1\>\/XI2\<1\>\/RR5 \
 (  \
 N_SEL7\<0\>_XI2\<0\>\/XI2\<0\>\/XI2\<0\>\/XI2\<0\>\/XI2\<1\>\/XI2\<0\>\/XI2\<1\>\/XI2\<1\>\/RR5_pos \
 N_WLSEL\<95\>_XI2\<0\>\/XI2\<0\>\/XI2\<0\>\/XI2\<0\>\/XI2\<1\>\/XI2\<0\>\/XI2\<1\>\/XI2\<1\>\/RR5_neg \
 ) R_1X_LL w=1e-07 l=1e-07   res=0.149966
XXI2\<0\>\/XI2\<0\>\/XI2\<0\>\/XI2\<0\>\/XI2\<1\>\/XI2\<1\>\/XI2\<0\>\/XI2\<0\>\/RR0 \
 (  \
 N_SEL0\<0\>_XI2\<0\>\/XI2\<0\>\/XI2\<0\>\/XI2\<0\>\/XI2\<1\>\/XI2\<1\>\/XI2\<0\>\/XI2\<0\>\/RR0_pos \
 N_WLSEL\<96\>_XI2\<0\>\/XI2\<0\>\/XI2\<0\>\/XI2\<0\>\/XI2\<1\>\/XI2\<1\>\/XI2\<0\>\/XI2\<0\>\/RR0_neg \
 ) R_1X_LL w=1e-07 l=1e-07   res=0.149966
XXI2\<0\>\/XI2\<0\>\/XI2\<0\>\/XI2\<0\>\/XI2\<1\>\/XI2\<1\>\/XI2\<0\>\/XI2\<0\>\/RR1 \
 (  \
 N_SEL1\<0\>_XI2\<0\>\/XI2\<0\>\/XI2\<0\>\/XI2\<0\>\/XI2\<1\>\/XI2\<1\>\/XI2\<0\>\/XI2\<0\>\/RR1_pos \
 N_WLSEL\<97\>_XI2\<0\>\/XI2\<0\>\/XI2\<0\>\/XI2\<0\>\/XI2\<1\>\/XI2\<1\>\/XI2\<0\>\/XI2\<0\>\/RR1_neg \
 ) R_1X_LL w=1e-07 l=1e-07   res=0.149966
XXI2\<0\>\/XI2\<0\>\/XI2\<0\>\/XI2\<0\>\/XI2\<1\>\/XI2\<1\>\/XI2\<0\>\/XI2\<0\>\/RR2 \
 (  \
 N_SEL2\<1\>_XI2\<0\>\/XI2\<0\>\/XI2\<0\>\/XI2\<0\>\/XI2\<1\>\/XI2\<1\>\/XI2\<0\>\/XI2\<0\>\/RR2_pos \
 N_WLSEL\<98\>_XI2\<0\>\/XI2\<0\>\/XI2\<0\>\/XI2\<0\>\/XI2\<1\>\/XI2\<1\>\/XI2\<0\>\/XI2\<0\>\/RR2_neg \
 ) R_1X_LL w=1e-07 l=1e-07   res=0.149966
XXI2\<0\>\/XI2\<0\>\/XI2\<0\>\/XI2\<0\>\/XI2\<1\>\/XI2\<1\>\/XI2\<0\>\/XI2\<0\>\/RR3 \
 (  \
 N_SEL3\<1\>_XI2\<0\>\/XI2\<0\>\/XI2\<0\>\/XI2\<0\>\/XI2\<1\>\/XI2\<1\>\/XI2\<0\>\/XI2\<0\>\/RR3_pos \
 N_WLSEL\<99\>_XI2\<0\>\/XI2\<0\>\/XI2\<0\>\/XI2\<0\>\/XI2\<1\>\/XI2\<1\>\/XI2\<0\>\/XI2\<0\>\/RR3_neg \
 ) R_1X_LL w=1e-07 l=1e-07   res=0.149966
XXI2\<0\>\/XI2\<0\>\/XI2\<0\>\/XI2\<0\>\/XI2\<1\>\/XI2\<1\>\/XI2\<0\>\/XI2\<0\>\/RR4 \
 (  \
 N_SEL4\<0\>_XI2\<0\>\/XI2\<0\>\/XI2\<0\>\/XI2\<0\>\/XI2\<1\>\/XI2\<1\>\/XI2\<0\>\/XI2\<0\>\/RR4_pos \
 N_WLSEL\<100\>_XI2\<0\>\/XI2\<0\>\/XI2\<0\>\/XI2\<0\>\/XI2\<1\>\/XI2\<1\>\/XI2\<0\>\/XI2\<0\>\/RR4_neg \
 ) R_1X_LL w=1e-07 l=1e-07   res=0.149966
XXI2\<0\>\/XI2\<0\>\/XI2\<0\>\/XI2\<0\>\/XI2\<1\>\/XI2\<1\>\/XI2\<0\>\/XI2\<0\>\/RR7 \
 (  \
 N_SEL5\<0\>_XI2\<0\>\/XI2\<0\>\/XI2\<0\>\/XI2\<0\>\/XI2\<1\>\/XI2\<1\>\/XI2\<0\>\/XI2\<0\>\/RR7_pos \
 N_WLSEL\<101\>_XI2\<0\>\/XI2\<0\>\/XI2\<0\>\/XI2\<0\>\/XI2\<1\>\/XI2\<1\>\/XI2\<0\>\/XI2\<0\>\/RR7_neg \
 ) R_1X_LL w=1e-07 l=1e-07   res=0.149966
XXI2\<0\>\/XI2\<0\>\/XI2\<0\>\/XI2\<0\>\/XI2\<1\>\/XI2\<1\>\/XI2\<0\>\/XI2\<0\>\/RR6 \
 (  \
 N_SEL6\<0\>_XI2\<0\>\/XI2\<0\>\/XI2\<0\>\/XI2\<0\>\/XI2\<1\>\/XI2\<1\>\/XI2\<0\>\/XI2\<0\>\/RR6_pos \
 N_WLSEL\<102\>_XI2\<0\>\/XI2\<0\>\/XI2\<0\>\/XI2\<0\>\/XI2\<1\>\/XI2\<1\>\/XI2\<0\>\/XI2\<0\>\/RR6_neg \
 ) R_1X_LL w=1e-07 l=1e-07   res=0.149966
XXI2\<0\>\/XI2\<0\>\/XI2\<0\>\/XI2\<0\>\/XI2\<1\>\/XI2\<1\>\/XI2\<0\>\/XI2\<0\>\/RR5 \
 (  \
 N_SEL7\<0\>_XI2\<0\>\/XI2\<0\>\/XI2\<0\>\/XI2\<0\>\/XI2\<1\>\/XI2\<1\>\/XI2\<0\>\/XI2\<0\>\/RR5_pos \
 N_WLSEL\<103\>_XI2\<0\>\/XI2\<0\>\/XI2\<0\>\/XI2\<0\>\/XI2\<1\>\/XI2\<1\>\/XI2\<0\>\/XI2\<0\>\/RR5_neg \
 ) R_1X_LL w=1e-07 l=1e-07   res=0.149966
XXI2\<0\>\/XI2\<0\>\/XI2\<0\>\/XI2\<0\>\/XI2\<1\>\/XI2\<1\>\/XI2\<0\>\/XI2\<1\>\/RR0 \
 (  \
 N_SEL0\<1\>_XI2\<0\>\/XI2\<0\>\/XI2\<0\>\/XI2\<0\>\/XI2\<1\>\/XI2\<1\>\/XI2\<0\>\/XI2\<1\>\/RR0_pos \
 N_WLSEL\<104\>_XI2\<0\>\/XI2\<0\>\/XI2\<0\>\/XI2\<0\>\/XI2\<1\>\/XI2\<1\>\/XI2\<0\>\/XI2\<1\>\/RR0_neg \
 ) R_1X_LL w=1e-07 l=1e-07   res=0.149966
XXI2\<0\>\/XI2\<0\>\/XI2\<0\>\/XI2\<0\>\/XI2\<1\>\/XI2\<1\>\/XI2\<0\>\/XI2\<1\>\/RR1 \
 (  \
 N_SEL1\<0\>_XI2\<0\>\/XI2\<0\>\/XI2\<0\>\/XI2\<0\>\/XI2\<1\>\/XI2\<1\>\/XI2\<0\>\/XI2\<1\>\/RR1_pos \
 N_WLSEL\<105\>_XI2\<0\>\/XI2\<0\>\/XI2\<0\>\/XI2\<0\>\/XI2\<1\>\/XI2\<1\>\/XI2\<0\>\/XI2\<1\>\/RR1_neg \
 ) R_1X_LL w=1e-07 l=1e-07   res=0.149966
XXI2\<0\>\/XI2\<0\>\/XI2\<0\>\/XI2\<0\>\/XI2\<1\>\/XI2\<1\>\/XI2\<0\>\/XI2\<1\>\/RR2 \
 (  \
 N_SEL2\<1\>_XI2\<0\>\/XI2\<0\>\/XI2\<0\>\/XI2\<0\>\/XI2\<1\>\/XI2\<1\>\/XI2\<0\>\/XI2\<1\>\/RR2_pos \
 N_WLSEL\<106\>_XI2\<0\>\/XI2\<0\>\/XI2\<0\>\/XI2\<0\>\/XI2\<1\>\/XI2\<1\>\/XI2\<0\>\/XI2\<1\>\/RR2_neg \
 ) R_1X_LL w=1e-07 l=1e-07   res=0.149966
XXI2\<0\>\/XI2\<0\>\/XI2\<0\>\/XI2\<0\>\/XI2\<1\>\/XI2\<1\>\/XI2\<0\>\/XI2\<1\>\/RR3 \
 (  \
 N_SEL3\<1\>_XI2\<0\>\/XI2\<0\>\/XI2\<0\>\/XI2\<0\>\/XI2\<1\>\/XI2\<1\>\/XI2\<0\>\/XI2\<1\>\/RR3_pos \
 N_WLSEL\<107\>_XI2\<0\>\/XI2\<0\>\/XI2\<0\>\/XI2\<0\>\/XI2\<1\>\/XI2\<1\>\/XI2\<0\>\/XI2\<1\>\/RR3_neg \
 ) R_1X_LL w=1e-07 l=1e-07   res=0.149966
XXI2\<0\>\/XI2\<0\>\/XI2\<0\>\/XI2\<0\>\/XI2\<1\>\/XI2\<1\>\/XI2\<0\>\/XI2\<1\>\/RR4 \
 (  \
 N_SEL4\<0\>_XI2\<0\>\/XI2\<0\>\/XI2\<0\>\/XI2\<0\>\/XI2\<1\>\/XI2\<1\>\/XI2\<0\>\/XI2\<1\>\/RR4_pos \
 N_WLSEL\<108\>_XI2\<0\>\/XI2\<0\>\/XI2\<0\>\/XI2\<0\>\/XI2\<1\>\/XI2\<1\>\/XI2\<0\>\/XI2\<1\>\/RR4_neg \
 ) R_1X_LL w=1e-07 l=1e-07   res=0.149966
XXI2\<1\>\/XI2\<1\>\/XI2\<0\>\/XI2\<0\>\/XI2\<0\>\/XI2\<0\>\/XI2\<0\>\/XI2\<0\>\/RR0 \
 (  \
 N_SEL0\<0\>_XI2\<1\>\/XI2\<1\>\/XI2\<0\>\/XI2\<0\>\/XI2\<0\>\/XI2\<0\>\/XI2\<0\>\/XI2\<0\>\/RR0_pos \
 N_WLSEL\<1536\>_XI2\<1\>\/XI2\<1\>\/XI2\<0\>\/XI2\<0\>\/XI2\<0\>\/XI2\<0\>\/XI2\<0\>\/XI2\<0\>\/RR0_neg \
 ) R_1X_LL w=1e-07 l=1e-07   res=0.149966
XXI2\<1\>\/XI2\<1\>\/XI2\<0\>\/XI2\<0\>\/XI2\<0\>\/XI2\<0\>\/XI2\<0\>\/XI2\<0\>\/RR1 \
 (  \
 N_SEL1\<0\>_XI2\<1\>\/XI2\<1\>\/XI2\<0\>\/XI2\<0\>\/XI2\<0\>\/XI2\<0\>\/XI2\<0\>\/XI2\<0\>\/RR1_pos \
 N_WLSEL\<1537\>_XI2\<1\>\/XI2\<1\>\/XI2\<0\>\/XI2\<0\>\/XI2\<0\>\/XI2\<0\>\/XI2\<0\>\/XI2\<0\>\/RR1_neg \
 ) R_1X_LL w=1e-07 l=1e-07   res=0.149966
XXI2\<1\>\/XI2\<1\>\/XI2\<0\>\/XI2\<0\>\/XI2\<0\>\/XI2\<0\>\/XI2\<0\>\/XI2\<0\>\/RR2 \
 (  \
 N_SEL2\<0\>_XI2\<1\>\/XI2\<1\>\/XI2\<0\>\/XI2\<0\>\/XI2\<0\>\/XI2\<0\>\/XI2\<0\>\/XI2\<0\>\/RR2_pos \
 N_WLSEL\<1538\>_XI2\<1\>\/XI2\<1\>\/XI2\<0\>\/XI2\<0\>\/XI2\<0\>\/XI2\<0\>\/XI2\<0\>\/XI2\<0\>\/RR2_neg \
 ) R_1X_LL w=1e-07 l=1e-07   res=0.149966
XXI2\<1\>\/XI2\<1\>\/XI2\<0\>\/XI2\<0\>\/XI2\<0\>\/XI2\<0\>\/XI2\<0\>\/XI2\<0\>\/RR3 \
 (  \
 N_SEL3\<0\>_XI2\<1\>\/XI2\<1\>\/XI2\<0\>\/XI2\<0\>\/XI2\<0\>\/XI2\<0\>\/XI2\<0\>\/XI2\<0\>\/RR3_pos \
 N_WLSEL\<1539\>_XI2\<1\>\/XI2\<1\>\/XI2\<0\>\/XI2\<0\>\/XI2\<0\>\/XI2\<0\>\/XI2\<0\>\/XI2\<0\>\/RR3_neg \
 ) R_1X_LL w=1e-07 l=1e-07   res=0.149966
XXI2\<1\>\/XI2\<1\>\/XI2\<0\>\/XI2\<0\>\/XI2\<0\>\/XI2\<0\>\/XI2\<0\>\/XI2\<0\>\/RR4 \
 (  \
 N_SEL4\<0\>_XI2\<1\>\/XI2\<1\>\/XI2\<0\>\/XI2\<0\>\/XI2\<0\>\/XI2\<0\>\/XI2\<0\>\/XI2\<0\>\/RR4_pos \
 N_WLSEL\<1540\>_XI2\<1\>\/XI2\<1\>\/XI2\<0\>\/XI2\<0\>\/XI2\<0\>\/XI2\<0\>\/XI2\<0\>\/XI2\<0\>\/RR4_neg \
 ) R_1X_LL w=1e-07 l=1e-07   res=0.149966
XXI2\<1\>\/XI2\<1\>\/XI2\<0\>\/XI2\<0\>\/XI2\<0\>\/XI2\<0\>\/XI2\<0\>\/XI2\<0\>\/RR7 \
 (  \
 N_SEL5\<0\>_XI2\<1\>\/XI2\<1\>\/XI2\<0\>\/XI2\<0\>\/XI2\<0\>\/XI2\<0\>\/XI2\<0\>\/XI2\<0\>\/RR7_pos \
 N_WLSEL\<1541\>_XI2\<1\>\/XI2\<1\>\/XI2\<0\>\/XI2\<0\>\/XI2\<0\>\/XI2\<0\>\/XI2\<0\>\/XI2\<0\>\/RR7_neg \
 ) R_1X_LL w=1e-07 l=1e-07   res=0.149966
XXI2\<1\>\/XI2\<1\>\/XI2\<0\>\/XI2\<0\>\/XI2\<0\>\/XI2\<0\>\/XI2\<0\>\/XI2\<0\>\/RR6 \
 (  \
 N_SEL6\<1\>_XI2\<1\>\/XI2\<1\>\/XI2\<0\>\/XI2\<0\>\/XI2\<0\>\/XI2\<0\>\/XI2\<0\>\/XI2\<0\>\/RR6_pos \
 N_WLSEL\<1542\>_XI2\<1\>\/XI2\<1\>\/XI2\<0\>\/XI2\<0\>\/XI2\<0\>\/XI2\<0\>\/XI2\<0\>\/XI2\<0\>\/RR6_neg \
 ) R_1X_LL w=1e-07 l=1e-07   res=0.149966
XXI2\<1\>\/XI2\<1\>\/XI2\<0\>\/XI2\<0\>\/XI2\<0\>\/XI2\<0\>\/XI2\<0\>\/XI2\<0\>\/RR5 \
 (  \
 N_SEL7\<1\>_XI2\<1\>\/XI2\<1\>\/XI2\<0\>\/XI2\<0\>\/XI2\<0\>\/XI2\<0\>\/XI2\<0\>\/XI2\<0\>\/RR5_pos \
 N_WLSEL\<1543\>_XI2\<1\>\/XI2\<1\>\/XI2\<0\>\/XI2\<0\>\/XI2\<0\>\/XI2\<0\>\/XI2\<0\>\/XI2\<0\>\/RR5_neg \
 ) R_1X_LL w=1e-07 l=1e-07   res=0.149966
XXI2\<1\>\/XI2\<1\>\/XI2\<0\>\/XI2\<0\>\/XI2\<0\>\/XI2\<0\>\/XI2\<0\>\/XI2\<1\>\/RR0 \
 (  \
 N_SEL0\<1\>_XI2\<1\>\/XI2\<1\>\/XI2\<0\>\/XI2\<0\>\/XI2\<0\>\/XI2\<0\>\/XI2\<0\>\/XI2\<1\>\/RR0_pos \
 N_WLSEL\<1544\>_XI2\<1\>\/XI2\<1\>\/XI2\<0\>\/XI2\<0\>\/XI2\<0\>\/XI2\<0\>\/XI2\<0\>\/XI2\<1\>\/RR0_neg \
 ) R_1X_LL w=1e-07 l=1e-07   res=0.149966
XXI2\<1\>\/XI2\<1\>\/XI2\<0\>\/XI2\<0\>\/XI2\<0\>\/XI2\<0\>\/XI2\<0\>\/XI2\<1\>\/RR1 \
 (  \
 N_SEL1\<0\>_XI2\<1\>\/XI2\<1\>\/XI2\<0\>\/XI2\<0\>\/XI2\<0\>\/XI2\<0\>\/XI2\<0\>\/XI2\<1\>\/RR1_pos \
 N_WLSEL\<1545\>_XI2\<1\>\/XI2\<1\>\/XI2\<0\>\/XI2\<0\>\/XI2\<0\>\/XI2\<0\>\/XI2\<0\>\/XI2\<1\>\/RR1_neg \
 ) R_1X_LL w=1e-07 l=1e-07   res=0.149966
XXI2\<1\>\/XI2\<1\>\/XI2\<0\>\/XI2\<0\>\/XI2\<0\>\/XI2\<0\>\/XI2\<0\>\/XI2\<1\>\/RR2 \
 (  \
 N_SEL2\<0\>_XI2\<1\>\/XI2\<1\>\/XI2\<0\>\/XI2\<0\>\/XI2\<0\>\/XI2\<0\>\/XI2\<0\>\/XI2\<1\>\/RR2_pos \
 N_WLSEL\<1546\>_XI2\<1\>\/XI2\<1\>\/XI2\<0\>\/XI2\<0\>\/XI2\<0\>\/XI2\<0\>\/XI2\<0\>\/XI2\<1\>\/RR2_neg \
 ) R_1X_LL w=1e-07 l=1e-07   res=0.149966
XXI2\<1\>\/XI2\<1\>\/XI2\<0\>\/XI2\<0\>\/XI2\<0\>\/XI2\<0\>\/XI2\<0\>\/XI2\<1\>\/RR3 \
 (  \
 N_SEL3\<0\>_XI2\<1\>\/XI2\<1\>\/XI2\<0\>\/XI2\<0\>\/XI2\<0\>\/XI2\<0\>\/XI2\<0\>\/XI2\<1\>\/RR3_pos \
 N_WLSEL\<1547\>_XI2\<1\>\/XI2\<1\>\/XI2\<0\>\/XI2\<0\>\/XI2\<0\>\/XI2\<0\>\/XI2\<0\>\/XI2\<1\>\/RR3_neg \
 ) R_1X_LL w=1e-07 l=1e-07   res=0.149966
XXI2\<1\>\/XI2\<1\>\/XI2\<0\>\/XI2\<0\>\/XI2\<0\>\/XI2\<0\>\/XI2\<0\>\/XI2\<1\>\/RR4 \
 (  \
 N_SEL4\<0\>_XI2\<1\>\/XI2\<1\>\/XI2\<0\>\/XI2\<0\>\/XI2\<0\>\/XI2\<0\>\/XI2\<0\>\/XI2\<1\>\/RR4_pos \
 N_WLSEL\<1548\>_XI2\<1\>\/XI2\<1\>\/XI2\<0\>\/XI2\<0\>\/XI2\<0\>\/XI2\<0\>\/XI2\<0\>\/XI2\<1\>\/RR4_neg \
 ) R_1X_LL w=1e-07 l=1e-07   res=0.149966
XXI2\<1\>\/XI2\<1\>\/XI2\<0\>\/XI2\<0\>\/XI2\<0\>\/XI2\<0\>\/XI2\<0\>\/XI2\<1\>\/RR7 \
 (  \
 N_SEL5\<0\>_XI2\<1\>\/XI2\<1\>\/XI2\<0\>\/XI2\<0\>\/XI2\<0\>\/XI2\<0\>\/XI2\<0\>\/XI2\<1\>\/RR7_pos \
 N_WLSEL\<1549\>_XI2\<1\>\/XI2\<1\>\/XI2\<0\>\/XI2\<0\>\/XI2\<0\>\/XI2\<0\>\/XI2\<0\>\/XI2\<1\>\/RR7_neg \
 ) R_1X_LL w=1e-07 l=1e-07   res=0.149966
XXI2\<1\>\/XI2\<1\>\/XI2\<0\>\/XI2\<0\>\/XI2\<0\>\/XI2\<0\>\/XI2\<0\>\/XI2\<1\>\/RR6 \
 (  \
 N_SEL6\<1\>_XI2\<1\>\/XI2\<1\>\/XI2\<0\>\/XI2\<0\>\/XI2\<0\>\/XI2\<0\>\/XI2\<0\>\/XI2\<1\>\/RR6_pos \
 N_WLSEL\<1550\>_XI2\<1\>\/XI2\<1\>\/XI2\<0\>\/XI2\<0\>\/XI2\<0\>\/XI2\<0\>\/XI2\<0\>\/XI2\<1\>\/RR6_neg \
 ) R_1X_LL w=1e-07 l=1e-07   res=0.149966
XXI2\<1\>\/XI2\<1\>\/XI2\<0\>\/XI2\<0\>\/XI2\<0\>\/XI2\<0\>\/XI2\<0\>\/XI2\<1\>\/RR5 \
 (  \
 N_SEL7\<1\>_XI2\<1\>\/XI2\<1\>\/XI2\<0\>\/XI2\<0\>\/XI2\<0\>\/XI2\<0\>\/XI2\<0\>\/XI2\<1\>\/RR5_pos \
 N_WLSEL\<1551\>_XI2\<1\>\/XI2\<1\>\/XI2\<0\>\/XI2\<0\>\/XI2\<0\>\/XI2\<0\>\/XI2\<0\>\/XI2\<1\>\/RR5_neg \
 ) R_1X_LL w=1e-07 l=1e-07   res=0.149966
XXI2\<1\>\/XI2\<1\>\/XI2\<0\>\/XI2\<0\>\/XI2\<0\>\/XI2\<0\>\/XI2\<1\>\/XI2\<0\>\/RR0 \
 (  \
 N_SEL0\<0\>_XI2\<1\>\/XI2\<1\>\/XI2\<0\>\/XI2\<0\>\/XI2\<0\>\/XI2\<0\>\/XI2\<1\>\/XI2\<0\>\/RR0_pos \
 N_WLSEL\<1552\>_XI2\<1\>\/XI2\<1\>\/XI2\<0\>\/XI2\<0\>\/XI2\<0\>\/XI2\<0\>\/XI2\<1\>\/XI2\<0\>\/RR0_neg \
 ) R_1X_LL w=1e-07 l=1e-07   res=0.149966
XXI2\<1\>\/XI2\<1\>\/XI2\<0\>\/XI2\<0\>\/XI2\<0\>\/XI2\<0\>\/XI2\<1\>\/XI2\<0\>\/RR1 \
 (  \
 N_SEL1\<1\>_XI2\<1\>\/XI2\<1\>\/XI2\<0\>\/XI2\<0\>\/XI2\<0\>\/XI2\<0\>\/XI2\<1\>\/XI2\<0\>\/RR1_pos \
 N_WLSEL\<1553\>_XI2\<1\>\/XI2\<1\>\/XI2\<0\>\/XI2\<0\>\/XI2\<0\>\/XI2\<0\>\/XI2\<1\>\/XI2\<0\>\/RR1_neg \
 ) R_1X_LL w=1e-07 l=1e-07   res=0.149966
XXI2\<1\>\/XI2\<1\>\/XI2\<0\>\/XI2\<0\>\/XI2\<0\>\/XI2\<0\>\/XI2\<1\>\/XI2\<0\>\/RR2 \
 (  \
 N_SEL2\<0\>_XI2\<1\>\/XI2\<1\>\/XI2\<0\>\/XI2\<0\>\/XI2\<0\>\/XI2\<0\>\/XI2\<1\>\/XI2\<0\>\/RR2_pos \
 N_WLSEL\<1554\>_XI2\<1\>\/XI2\<1\>\/XI2\<0\>\/XI2\<0\>\/XI2\<0\>\/XI2\<0\>\/XI2\<1\>\/XI2\<0\>\/RR2_neg \
 ) R_1X_LL w=1e-07 l=1e-07   res=0.149966
XXI2\<1\>\/XI2\<1\>\/XI2\<0\>\/XI2\<0\>\/XI2\<0\>\/XI2\<0\>\/XI2\<1\>\/XI2\<0\>\/RR3 \
 (  \
 N_SEL3\<0\>_XI2\<1\>\/XI2\<1\>\/XI2\<0\>\/XI2\<0\>\/XI2\<0\>\/XI2\<0\>\/XI2\<1\>\/XI2\<0\>\/RR3_pos \
 N_WLSEL\<1555\>_XI2\<1\>\/XI2\<1\>\/XI2\<0\>\/XI2\<0\>\/XI2\<0\>\/XI2\<0\>\/XI2\<1\>\/XI2\<0\>\/RR3_neg \
 ) R_1X_LL w=1e-07 l=1e-07   res=0.149966
XXI2\<1\>\/XI2\<1\>\/XI2\<0\>\/XI2\<0\>\/XI2\<0\>\/XI2\<0\>\/XI2\<1\>\/XI2\<0\>\/RR4 \
 (  \
 N_SEL4\<0\>_XI2\<1\>\/XI2\<1\>\/XI2\<0\>\/XI2\<0\>\/XI2\<0\>\/XI2\<0\>\/XI2\<1\>\/XI2\<0\>\/RR4_pos \
 N_WLSEL\<1556\>_XI2\<1\>\/XI2\<1\>\/XI2\<0\>\/XI2\<0\>\/XI2\<0\>\/XI2\<0\>\/XI2\<1\>\/XI2\<0\>\/RR4_neg \
 ) R_1X_LL w=1e-07 l=1e-07   res=0.149966
XXI2\<1\>\/XI2\<1\>\/XI2\<0\>\/XI2\<0\>\/XI2\<0\>\/XI2\<0\>\/XI2\<1\>\/XI2\<0\>\/RR7 \
 (  \
 N_SEL5\<0\>_XI2\<1\>\/XI2\<1\>\/XI2\<0\>\/XI2\<0\>\/XI2\<0\>\/XI2\<0\>\/XI2\<1\>\/XI2\<0\>\/RR7_pos \
 N_WLSEL\<1557\>_XI2\<1\>\/XI2\<1\>\/XI2\<0\>\/XI2\<0\>\/XI2\<0\>\/XI2\<0\>\/XI2\<1\>\/XI2\<0\>\/RR7_neg \
 ) R_1X_LL w=1e-07 l=1e-07   res=0.149966
XXI2\<1\>\/XI2\<1\>\/XI2\<0\>\/XI2\<0\>\/XI2\<0\>\/XI2\<0\>\/XI2\<1\>\/XI2\<0\>\/RR6 \
 (  \
 N_SEL6\<1\>_XI2\<1\>\/XI2\<1\>\/XI2\<0\>\/XI2\<0\>\/XI2\<0\>\/XI2\<0\>\/XI2\<1\>\/XI2\<0\>\/RR6_pos \
 N_WLSEL\<1558\>_XI2\<1\>\/XI2\<1\>\/XI2\<0\>\/XI2\<0\>\/XI2\<0\>\/XI2\<0\>\/XI2\<1\>\/XI2\<0\>\/RR6_neg \
 ) R_1X_LL w=1e-07 l=1e-07   res=0.149966
XXI2\<1\>\/XI2\<1\>\/XI2\<0\>\/XI2\<0\>\/XI2\<0\>\/XI2\<0\>\/XI2\<1\>\/XI2\<0\>\/RR5 \
 (  \
 N_SEL7\<1\>_XI2\<1\>\/XI2\<1\>\/XI2\<0\>\/XI2\<0\>\/XI2\<0\>\/XI2\<0\>\/XI2\<1\>\/XI2\<0\>\/RR5_pos \
 N_WLSEL\<1559\>_XI2\<1\>\/XI2\<1\>\/XI2\<0\>\/XI2\<0\>\/XI2\<0\>\/XI2\<0\>\/XI2\<1\>\/XI2\<0\>\/RR5_neg \
 ) R_1X_LL w=1e-07 l=1e-07   res=0.149966
XXI2\<1\>\/XI2\<1\>\/XI2\<0\>\/XI2\<0\>\/XI2\<0\>\/XI2\<0\>\/XI2\<1\>\/XI2\<1\>\/RR0 \
 (  \
 N_SEL0\<1\>_XI2\<1\>\/XI2\<1\>\/XI2\<0\>\/XI2\<0\>\/XI2\<0\>\/XI2\<0\>\/XI2\<1\>\/XI2\<1\>\/RR0_pos \
 N_WLSEL\<1560\>_XI2\<1\>\/XI2\<1\>\/XI2\<0\>\/XI2\<0\>\/XI2\<0\>\/XI2\<0\>\/XI2\<1\>\/XI2\<1\>\/RR0_neg \
 ) R_1X_LL w=1e-07 l=1e-07   res=0.149966
XXI2\<1\>\/XI2\<1\>\/XI2\<0\>\/XI2\<0\>\/XI2\<0\>\/XI2\<0\>\/XI2\<1\>\/XI2\<1\>\/RR1 \
 (  \
 N_SEL1\<1\>_XI2\<1\>\/XI2\<1\>\/XI2\<0\>\/XI2\<0\>\/XI2\<0\>\/XI2\<0\>\/XI2\<1\>\/XI2\<1\>\/RR1_pos \
 N_WLSEL\<1561\>_XI2\<1\>\/XI2\<1\>\/XI2\<0\>\/XI2\<0\>\/XI2\<0\>\/XI2\<0\>\/XI2\<1\>\/XI2\<1\>\/RR1_neg \
 ) R_1X_LL w=1e-07 l=1e-07   res=0.149966
XXI2\<1\>\/XI2\<1\>\/XI2\<0\>\/XI2\<0\>\/XI2\<0\>\/XI2\<0\>\/XI2\<1\>\/XI2\<1\>\/RR2 \
 (  \
 N_SEL2\<0\>_XI2\<1\>\/XI2\<1\>\/XI2\<0\>\/XI2\<0\>\/XI2\<0\>\/XI2\<0\>\/XI2\<1\>\/XI2\<1\>\/RR2_pos \
 N_WLSEL\<1562\>_XI2\<1\>\/XI2\<1\>\/XI2\<0\>\/XI2\<0\>\/XI2\<0\>\/XI2\<0\>\/XI2\<1\>\/XI2\<1\>\/RR2_neg \
 ) R_1X_LL w=1e-07 l=1e-07   res=0.149966
XXI2\<1\>\/XI2\<1\>\/XI2\<0\>\/XI2\<0\>\/XI2\<0\>\/XI2\<0\>\/XI2\<1\>\/XI2\<1\>\/RR3 \
 (  \
 N_SEL3\<0\>_XI2\<1\>\/XI2\<1\>\/XI2\<0\>\/XI2\<0\>\/XI2\<0\>\/XI2\<0\>\/XI2\<1\>\/XI2\<1\>\/RR3_pos \
 N_WLSEL\<1563\>_XI2\<1\>\/XI2\<1\>\/XI2\<0\>\/XI2\<0\>\/XI2\<0\>\/XI2\<0\>\/XI2\<1\>\/XI2\<1\>\/RR3_neg \
 ) R_1X_LL w=1e-07 l=1e-07   res=0.149966
XXI2\<1\>\/XI2\<1\>\/XI2\<0\>\/XI2\<0\>\/XI2\<0\>\/XI2\<0\>\/XI2\<1\>\/XI2\<1\>\/RR4 \
 (  \
 N_SEL4\<0\>_XI2\<1\>\/XI2\<1\>\/XI2\<0\>\/XI2\<0\>\/XI2\<0\>\/XI2\<0\>\/XI2\<1\>\/XI2\<1\>\/RR4_pos \
 N_WLSEL\<1564\>_XI2\<1\>\/XI2\<1\>\/XI2\<0\>\/XI2\<0\>\/XI2\<0\>\/XI2\<0\>\/XI2\<1\>\/XI2\<1\>\/RR4_neg \
 ) R_1X_LL w=1e-07 l=1e-07   res=0.149966
XXI2\<1\>\/XI2\<0\>\/XI2\<0\>\/XI2\<0\>\/XI2\<0\>\/XI2\<0\>\/XI2\<0\>\/XI2\<0\>\/RR0 \
 (  \
 N_SEL0\<0\>_XI2\<1\>\/XI2\<0\>\/XI2\<0\>\/XI2\<0\>\/XI2\<0\>\/XI2\<0\>\/XI2\<0\>\/XI2\<0\>\/RR0_pos \
 N_WLSEL\<1024\>_XI2\<1\>\/XI2\<0\>\/XI2\<0\>\/XI2\<0\>\/XI2\<0\>\/XI2\<0\>\/XI2\<0\>\/XI2\<0\>\/RR0_neg \
 ) R_1X_LL w=1e-07 l=1e-07   res=0.149966
XXI2\<1\>\/XI2\<0\>\/XI2\<0\>\/XI2\<0\>\/XI2\<0\>\/XI2\<0\>\/XI2\<0\>\/XI2\<0\>\/RR1 \
 (  \
 N_SEL1\<0\>_XI2\<1\>\/XI2\<0\>\/XI2\<0\>\/XI2\<0\>\/XI2\<0\>\/XI2\<0\>\/XI2\<0\>\/XI2\<0\>\/RR1_pos \
 N_WLSEL\<1025\>_XI2\<1\>\/XI2\<0\>\/XI2\<0\>\/XI2\<0\>\/XI2\<0\>\/XI2\<0\>\/XI2\<0\>\/XI2\<0\>\/RR1_neg \
 ) R_1X_LL w=1e-07 l=1e-07   res=0.149966
XXI2\<1\>\/XI2\<0\>\/XI2\<0\>\/XI2\<0\>\/XI2\<0\>\/XI2\<0\>\/XI2\<0\>\/XI2\<0\>\/RR2 \
 (  \
 N_SEL2\<0\>_XI2\<1\>\/XI2\<0\>\/XI2\<0\>\/XI2\<0\>\/XI2\<0\>\/XI2\<0\>\/XI2\<0\>\/XI2\<0\>\/RR2_pos \
 N_WLSEL\<1026\>_XI2\<1\>\/XI2\<0\>\/XI2\<0\>\/XI2\<0\>\/XI2\<0\>\/XI2\<0\>\/XI2\<0\>\/XI2\<0\>\/RR2_neg \
 ) R_1X_LL w=1e-07 l=1e-07   res=0.149966
XXI2\<1\>\/XI2\<0\>\/XI2\<0\>\/XI2\<0\>\/XI2\<0\>\/XI2\<0\>\/XI2\<0\>\/XI2\<0\>\/RR3 \
 (  \
 N_SEL3\<0\>_XI2\<1\>\/XI2\<0\>\/XI2\<0\>\/XI2\<0\>\/XI2\<0\>\/XI2\<0\>\/XI2\<0\>\/XI2\<0\>\/RR3_pos \
 N_WLSEL\<1027\>_XI2\<1\>\/XI2\<0\>\/XI2\<0\>\/XI2\<0\>\/XI2\<0\>\/XI2\<0\>\/XI2\<0\>\/XI2\<0\>\/RR3_neg \
 ) R_1X_LL w=1e-07 l=1e-07   res=0.149966
XXI2\<1\>\/XI2\<0\>\/XI2\<0\>\/XI2\<0\>\/XI2\<0\>\/XI2\<0\>\/XI2\<0\>\/XI2\<0\>\/RR4 \
 (  \
 N_SEL4\<0\>_XI2\<1\>\/XI2\<0\>\/XI2\<0\>\/XI2\<0\>\/XI2\<0\>\/XI2\<0\>\/XI2\<0\>\/XI2\<0\>\/RR4_pos \
 N_WLSEL\<1028\>_XI2\<1\>\/XI2\<0\>\/XI2\<0\>\/XI2\<0\>\/XI2\<0\>\/XI2\<0\>\/XI2\<0\>\/XI2\<0\>\/RR4_neg \
 ) R_1X_LL w=1e-07 l=1e-07   res=0.149966
XXI2\<1\>\/XI2\<0\>\/XI2\<0\>\/XI2\<0\>\/XI2\<0\>\/XI2\<0\>\/XI2\<0\>\/XI2\<0\>\/RR7 \
 (  \
 N_SEL5\<0\>_XI2\<1\>\/XI2\<0\>\/XI2\<0\>\/XI2\<0\>\/XI2\<0\>\/XI2\<0\>\/XI2\<0\>\/XI2\<0\>\/RR7_pos \
 N_WLSEL\<1029\>_XI2\<1\>\/XI2\<0\>\/XI2\<0\>\/XI2\<0\>\/XI2\<0\>\/XI2\<0\>\/XI2\<0\>\/XI2\<0\>\/RR7_neg \
 ) R_1X_LL w=1e-07 l=1e-07   res=0.149966
XXI2\<1\>\/XI2\<0\>\/XI2\<0\>\/XI2\<0\>\/XI2\<0\>\/XI2\<0\>\/XI2\<0\>\/XI2\<0\>\/RR6 \
 (  \
 N_SEL6\<0\>_XI2\<1\>\/XI2\<0\>\/XI2\<0\>\/XI2\<0\>\/XI2\<0\>\/XI2\<0\>\/XI2\<0\>\/XI2\<0\>\/RR6_pos \
 N_WLSEL\<1030\>_XI2\<1\>\/XI2\<0\>\/XI2\<0\>\/XI2\<0\>\/XI2\<0\>\/XI2\<0\>\/XI2\<0\>\/XI2\<0\>\/RR6_neg \
 ) R_1X_LL w=1e-07 l=1e-07   res=0.149966
XXI2\<1\>\/XI2\<0\>\/XI2\<0\>\/XI2\<0\>\/XI2\<0\>\/XI2\<0\>\/XI2\<0\>\/XI2\<0\>\/RR5 \
 (  \
 N_SEL7\<1\>_XI2\<1\>\/XI2\<0\>\/XI2\<0\>\/XI2\<0\>\/XI2\<0\>\/XI2\<0\>\/XI2\<0\>\/XI2\<0\>\/RR5_pos \
 N_WLSEL\<1031\>_XI2\<1\>\/XI2\<0\>\/XI2\<0\>\/XI2\<0\>\/XI2\<0\>\/XI2\<0\>\/XI2\<0\>\/XI2\<0\>\/RR5_neg \
 ) R_1X_LL w=1e-07 l=1e-07   res=0.149966
XXI2\<1\>\/XI2\<0\>\/XI2\<0\>\/XI2\<0\>\/XI2\<0\>\/XI2\<0\>\/XI2\<0\>\/XI2\<1\>\/RR0 \
 (  \
 N_SEL0\<1\>_XI2\<1\>\/XI2\<0\>\/XI2\<0\>\/XI2\<0\>\/XI2\<0\>\/XI2\<0\>\/XI2\<0\>\/XI2\<1\>\/RR0_pos \
 N_WLSEL\<1032\>_XI2\<1\>\/XI2\<0\>\/XI2\<0\>\/XI2\<0\>\/XI2\<0\>\/XI2\<0\>\/XI2\<0\>\/XI2\<1\>\/RR0_neg \
 ) R_1X_LL w=1e-07 l=1e-07   res=0.149966
XXI2\<1\>\/XI2\<0\>\/XI2\<0\>\/XI2\<0\>\/XI2\<0\>\/XI2\<0\>\/XI2\<0\>\/XI2\<1\>\/RR1 \
 (  \
 N_SEL1\<0\>_XI2\<1\>\/XI2\<0\>\/XI2\<0\>\/XI2\<0\>\/XI2\<0\>\/XI2\<0\>\/XI2\<0\>\/XI2\<1\>\/RR1_pos \
 N_WLSEL\<1033\>_XI2\<1\>\/XI2\<0\>\/XI2\<0\>\/XI2\<0\>\/XI2\<0\>\/XI2\<0\>\/XI2\<0\>\/XI2\<1\>\/RR1_neg \
 ) R_1X_LL w=1e-07 l=1e-07   res=0.149966
XXI2\<1\>\/XI2\<0\>\/XI2\<0\>\/XI2\<0\>\/XI2\<0\>\/XI2\<0\>\/XI2\<0\>\/XI2\<1\>\/RR2 \
 (  \
 N_SEL2\<0\>_XI2\<1\>\/XI2\<0\>\/XI2\<0\>\/XI2\<0\>\/XI2\<0\>\/XI2\<0\>\/XI2\<0\>\/XI2\<1\>\/RR2_pos \
 N_WLSEL\<1034\>_XI2\<1\>\/XI2\<0\>\/XI2\<0\>\/XI2\<0\>\/XI2\<0\>\/XI2\<0\>\/XI2\<0\>\/XI2\<1\>\/RR2_neg \
 ) R_1X_LL w=1e-07 l=1e-07   res=0.149966
XXI2\<1\>\/XI2\<0\>\/XI2\<0\>\/XI2\<0\>\/XI2\<0\>\/XI2\<0\>\/XI2\<0\>\/XI2\<1\>\/RR3 \
 (  \
 N_SEL3\<0\>_XI2\<1\>\/XI2\<0\>\/XI2\<0\>\/XI2\<0\>\/XI2\<0\>\/XI2\<0\>\/XI2\<0\>\/XI2\<1\>\/RR3_pos \
 N_WLSEL\<1035\>_XI2\<1\>\/XI2\<0\>\/XI2\<0\>\/XI2\<0\>\/XI2\<0\>\/XI2\<0\>\/XI2\<0\>\/XI2\<1\>\/RR3_neg \
 ) R_1X_LL w=1e-07 l=1e-07   res=0.149966
XXI2\<1\>\/XI2\<0\>\/XI2\<0\>\/XI2\<0\>\/XI2\<0\>\/XI2\<0\>\/XI2\<0\>\/XI2\<1\>\/RR4 \
 (  \
 N_SEL4\<0\>_XI2\<1\>\/XI2\<0\>\/XI2\<0\>\/XI2\<0\>\/XI2\<0\>\/XI2\<0\>\/XI2\<0\>\/XI2\<1\>\/RR4_pos \
 N_WLSEL\<1036\>_XI2\<1\>\/XI2\<0\>\/XI2\<0\>\/XI2\<0\>\/XI2\<0\>\/XI2\<0\>\/XI2\<0\>\/XI2\<1\>\/RR4_neg \
 ) R_1X_LL w=1e-07 l=1e-07   res=0.149966
XXI2\<1\>\/XI2\<0\>\/XI2\<0\>\/XI2\<0\>\/XI2\<0\>\/XI2\<0\>\/XI2\<0\>\/XI2\<1\>\/RR7 \
 (  \
 N_SEL5\<0\>_XI2\<1\>\/XI2\<0\>\/XI2\<0\>\/XI2\<0\>\/XI2\<0\>\/XI2\<0\>\/XI2\<0\>\/XI2\<1\>\/RR7_pos \
 N_WLSEL\<1037\>_XI2\<1\>\/XI2\<0\>\/XI2\<0\>\/XI2\<0\>\/XI2\<0\>\/XI2\<0\>\/XI2\<0\>\/XI2\<1\>\/RR7_neg \
 ) R_1X_LL w=1e-07 l=1e-07   res=0.149966
XXI2\<1\>\/XI2\<0\>\/XI2\<0\>\/XI2\<0\>\/XI2\<0\>\/XI2\<0\>\/XI2\<0\>\/XI2\<1\>\/RR6 \
 (  \
 N_SEL6\<0\>_XI2\<1\>\/XI2\<0\>\/XI2\<0\>\/XI2\<0\>\/XI2\<0\>\/XI2\<0\>\/XI2\<0\>\/XI2\<1\>\/RR6_pos \
 N_WLSEL\<1038\>_XI2\<1\>\/XI2\<0\>\/XI2\<0\>\/XI2\<0\>\/XI2\<0\>\/XI2\<0\>\/XI2\<0\>\/XI2\<1\>\/RR6_neg \
 ) R_1X_LL w=1e-07 l=1e-07   res=0.149966
XXI2\<1\>\/XI2\<0\>\/XI2\<0\>\/XI2\<0\>\/XI2\<0\>\/XI2\<0\>\/XI2\<0\>\/XI2\<1\>\/RR5 \
 (  \
 N_SEL7\<1\>_XI2\<1\>\/XI2\<0\>\/XI2\<0\>\/XI2\<0\>\/XI2\<0\>\/XI2\<0\>\/XI2\<0\>\/XI2\<1\>\/RR5_pos \
 N_WLSEL\<1039\>_XI2\<1\>\/XI2\<0\>\/XI2\<0\>\/XI2\<0\>\/XI2\<0\>\/XI2\<0\>\/XI2\<0\>\/XI2\<1\>\/RR5_neg \
 ) R_1X_LL w=1e-07 l=1e-07   res=0.149966
XXI2\<1\>\/XI2\<0\>\/XI2\<0\>\/XI2\<0\>\/XI2\<0\>\/XI2\<0\>\/XI2\<1\>\/XI2\<0\>\/RR0 \
 (  \
 N_SEL0\<0\>_XI2\<1\>\/XI2\<0\>\/XI2\<0\>\/XI2\<0\>\/XI2\<0\>\/XI2\<0\>\/XI2\<1\>\/XI2\<0\>\/RR0_pos \
 N_WLSEL\<1040\>_XI2\<1\>\/XI2\<0\>\/XI2\<0\>\/XI2\<0\>\/XI2\<0\>\/XI2\<0\>\/XI2\<1\>\/XI2\<0\>\/RR0_neg \
 ) R_1X_LL w=1e-07 l=1e-07   res=0.149966
XXI2\<1\>\/XI2\<0\>\/XI2\<0\>\/XI2\<0\>\/XI2\<0\>\/XI2\<0\>\/XI2\<1\>\/XI2\<0\>\/RR1 \
 (  \
 N_SEL1\<1\>_XI2\<1\>\/XI2\<0\>\/XI2\<0\>\/XI2\<0\>\/XI2\<0\>\/XI2\<0\>\/XI2\<1\>\/XI2\<0\>\/RR1_pos \
 N_WLSEL\<1041\>_XI2\<1\>\/XI2\<0\>\/XI2\<0\>\/XI2\<0\>\/XI2\<0\>\/XI2\<0\>\/XI2\<1\>\/XI2\<0\>\/RR1_neg \
 ) R_1X_LL w=1e-07 l=1e-07   res=0.149966
XXI2\<1\>\/XI2\<0\>\/XI2\<0\>\/XI2\<0\>\/XI2\<0\>\/XI2\<0\>\/XI2\<1\>\/XI2\<0\>\/RR2 \
 (  \
 N_SEL2\<0\>_XI2\<1\>\/XI2\<0\>\/XI2\<0\>\/XI2\<0\>\/XI2\<0\>\/XI2\<0\>\/XI2\<1\>\/XI2\<0\>\/RR2_pos \
 N_WLSEL\<1042\>_XI2\<1\>\/XI2\<0\>\/XI2\<0\>\/XI2\<0\>\/XI2\<0\>\/XI2\<0\>\/XI2\<1\>\/XI2\<0\>\/RR2_neg \
 ) R_1X_LL w=1e-07 l=1e-07   res=0.149966
XXI2\<1\>\/XI2\<0\>\/XI2\<0\>\/XI2\<0\>\/XI2\<0\>\/XI2\<0\>\/XI2\<1\>\/XI2\<0\>\/RR3 \
 (  \
 N_SEL3\<0\>_XI2\<1\>\/XI2\<0\>\/XI2\<0\>\/XI2\<0\>\/XI2\<0\>\/XI2\<0\>\/XI2\<1\>\/XI2\<0\>\/RR3_pos \
 N_WLSEL\<1043\>_XI2\<1\>\/XI2\<0\>\/XI2\<0\>\/XI2\<0\>\/XI2\<0\>\/XI2\<0\>\/XI2\<1\>\/XI2\<0\>\/RR3_neg \
 ) R_1X_LL w=1e-07 l=1e-07   res=0.149966
XXI2\<1\>\/XI2\<0\>\/XI2\<0\>\/XI2\<0\>\/XI2\<0\>\/XI2\<0\>\/XI2\<1\>\/XI2\<0\>\/RR4 \
 (  \
 N_SEL4\<0\>_XI2\<1\>\/XI2\<0\>\/XI2\<0\>\/XI2\<0\>\/XI2\<0\>\/XI2\<0\>\/XI2\<1\>\/XI2\<0\>\/RR4_pos \
 N_WLSEL\<1044\>_XI2\<1\>\/XI2\<0\>\/XI2\<0\>\/XI2\<0\>\/XI2\<0\>\/XI2\<0\>\/XI2\<1\>\/XI2\<0\>\/RR4_neg \
 ) R_1X_LL w=1e-07 l=1e-07   res=0.149966
XXI2\<1\>\/XI2\<0\>\/XI2\<0\>\/XI2\<0\>\/XI2\<0\>\/XI2\<0\>\/XI2\<1\>\/XI2\<0\>\/RR7 \
 (  \
 N_SEL5\<0\>_XI2\<1\>\/XI2\<0\>\/XI2\<0\>\/XI2\<0\>\/XI2\<0\>\/XI2\<0\>\/XI2\<1\>\/XI2\<0\>\/RR7_pos \
 N_WLSEL\<1045\>_XI2\<1\>\/XI2\<0\>\/XI2\<0\>\/XI2\<0\>\/XI2\<0\>\/XI2\<0\>\/XI2\<1\>\/XI2\<0\>\/RR7_neg \
 ) R_1X_LL w=1e-07 l=1e-07   res=0.149966
XXI2\<1\>\/XI2\<0\>\/XI2\<0\>\/XI2\<0\>\/XI2\<0\>\/XI2\<0\>\/XI2\<1\>\/XI2\<0\>\/RR6 \
 (  \
 N_SEL6\<0\>_XI2\<1\>\/XI2\<0\>\/XI2\<0\>\/XI2\<0\>\/XI2\<0\>\/XI2\<0\>\/XI2\<1\>\/XI2\<0\>\/RR6_pos \
 N_WLSEL\<1046\>_XI2\<1\>\/XI2\<0\>\/XI2\<0\>\/XI2\<0\>\/XI2\<0\>\/XI2\<0\>\/XI2\<1\>\/XI2\<0\>\/RR6_neg \
 ) R_1X_LL w=1e-07 l=1e-07   res=0.149966
XXI2\<1\>\/XI2\<0\>\/XI2\<0\>\/XI2\<0\>\/XI2\<0\>\/XI2\<0\>\/XI2\<1\>\/XI2\<0\>\/RR5 \
 (  \
 N_SEL7\<1\>_XI2\<1\>\/XI2\<0\>\/XI2\<0\>\/XI2\<0\>\/XI2\<0\>\/XI2\<0\>\/XI2\<1\>\/XI2\<0\>\/RR5_pos \
 N_WLSEL\<1047\>_XI2\<1\>\/XI2\<0\>\/XI2\<0\>\/XI2\<0\>\/XI2\<0\>\/XI2\<0\>\/XI2\<1\>\/XI2\<0\>\/RR5_neg \
 ) R_1X_LL w=1e-07 l=1e-07   res=0.149966
XXI2\<1\>\/XI2\<0\>\/XI2\<0\>\/XI2\<0\>\/XI2\<0\>\/XI2\<0\>\/XI2\<1\>\/XI2\<1\>\/RR0 \
 (  \
 N_SEL0\<1\>_XI2\<1\>\/XI2\<0\>\/XI2\<0\>\/XI2\<0\>\/XI2\<0\>\/XI2\<0\>\/XI2\<1\>\/XI2\<1\>\/RR0_pos \
 N_WLSEL\<1048\>_XI2\<1\>\/XI2\<0\>\/XI2\<0\>\/XI2\<0\>\/XI2\<0\>\/XI2\<0\>\/XI2\<1\>\/XI2\<1\>\/RR0_neg \
 ) R_1X_LL w=1e-07 l=1e-07   res=0.149966
XXI2\<1\>\/XI2\<0\>\/XI2\<0\>\/XI2\<0\>\/XI2\<0\>\/XI2\<0\>\/XI2\<1\>\/XI2\<1\>\/RR1 \
 (  \
 N_SEL1\<1\>_XI2\<1\>\/XI2\<0\>\/XI2\<0\>\/XI2\<0\>\/XI2\<0\>\/XI2\<0\>\/XI2\<1\>\/XI2\<1\>\/RR1_pos \
 N_WLSEL\<1049\>_XI2\<1\>\/XI2\<0\>\/XI2\<0\>\/XI2\<0\>\/XI2\<0\>\/XI2\<0\>\/XI2\<1\>\/XI2\<1\>\/RR1_neg \
 ) R_1X_LL w=1e-07 l=1e-07   res=0.149966
XXI2\<1\>\/XI2\<0\>\/XI2\<0\>\/XI2\<0\>\/XI2\<0\>\/XI2\<0\>\/XI2\<1\>\/XI2\<1\>\/RR2 \
 (  \
 N_SEL2\<0\>_XI2\<1\>\/XI2\<0\>\/XI2\<0\>\/XI2\<0\>\/XI2\<0\>\/XI2\<0\>\/XI2\<1\>\/XI2\<1\>\/RR2_pos \
 N_WLSEL\<1050\>_XI2\<1\>\/XI2\<0\>\/XI2\<0\>\/XI2\<0\>\/XI2\<0\>\/XI2\<0\>\/XI2\<1\>\/XI2\<1\>\/RR2_neg \
 ) R_1X_LL w=1e-07 l=1e-07   res=0.149966
XXI2\<1\>\/XI2\<0\>\/XI2\<0\>\/XI2\<0\>\/XI2\<0\>\/XI2\<0\>\/XI2\<1\>\/XI2\<1\>\/RR3 \
 (  \
 N_SEL3\<0\>_XI2\<1\>\/XI2\<0\>\/XI2\<0\>\/XI2\<0\>\/XI2\<0\>\/XI2\<0\>\/XI2\<1\>\/XI2\<1\>\/RR3_pos \
 N_WLSEL\<1051\>_XI2\<1\>\/XI2\<0\>\/XI2\<0\>\/XI2\<0\>\/XI2\<0\>\/XI2\<0\>\/XI2\<1\>\/XI2\<1\>\/RR3_neg \
 ) R_1X_LL w=1e-07 l=1e-07   res=0.149966
XXI2\<1\>\/XI2\<0\>\/XI2\<0\>\/XI2\<0\>\/XI2\<0\>\/XI2\<0\>\/XI2\<1\>\/XI2\<1\>\/RR4 \
 (  \
 N_SEL4\<0\>_XI2\<1\>\/XI2\<0\>\/XI2\<0\>\/XI2\<0\>\/XI2\<0\>\/XI2\<0\>\/XI2\<1\>\/XI2\<1\>\/RR4_pos \
 N_WLSEL\<1052\>_XI2\<1\>\/XI2\<0\>\/XI2\<0\>\/XI2\<0\>\/XI2\<0\>\/XI2\<0\>\/XI2\<1\>\/XI2\<1\>\/RR4_neg \
 ) R_1X_LL w=1e-07 l=1e-07   res=0.149966
XXI2\<0\>\/XI2\<1\>\/XI2\<0\>\/XI2\<0\>\/XI2\<0\>\/XI2\<0\>\/XI2\<0\>\/XI2\<0\>\/RR0 \
 (  \
 N_SEL0\<0\>_XI2\<0\>\/XI2\<1\>\/XI2\<0\>\/XI2\<0\>\/XI2\<0\>\/XI2\<0\>\/XI2\<0\>\/XI2\<0\>\/RR0_pos \
 N_WLSEL\<512\>_XI2\<0\>\/XI2\<1\>\/XI2\<0\>\/XI2\<0\>\/XI2\<0\>\/XI2\<0\>\/XI2\<0\>\/XI2\<0\>\/RR0_neg \
 ) R_1X_LL w=1e-07 l=1e-07   res=0.149966
XXI2\<0\>\/XI2\<1\>\/XI2\<0\>\/XI2\<0\>\/XI2\<0\>\/XI2\<0\>\/XI2\<0\>\/XI2\<0\>\/RR1 \
 (  \
 N_SEL1\<0\>_XI2\<0\>\/XI2\<1\>\/XI2\<0\>\/XI2\<0\>\/XI2\<0\>\/XI2\<0\>\/XI2\<0\>\/XI2\<0\>\/RR1_pos \
 N_WLSEL\<513\>_XI2\<0\>\/XI2\<1\>\/XI2\<0\>\/XI2\<0\>\/XI2\<0\>\/XI2\<0\>\/XI2\<0\>\/XI2\<0\>\/RR1_neg \
 ) R_1X_LL w=1e-07 l=1e-07   res=0.149966
XXI2\<0\>\/XI2\<1\>\/XI2\<0\>\/XI2\<0\>\/XI2\<0\>\/XI2\<0\>\/XI2\<0\>\/XI2\<0\>\/RR2 \
 (  \
 N_SEL2\<0\>_XI2\<0\>\/XI2\<1\>\/XI2\<0\>\/XI2\<0\>\/XI2\<0\>\/XI2\<0\>\/XI2\<0\>\/XI2\<0\>\/RR2_pos \
 N_WLSEL\<514\>_XI2\<0\>\/XI2\<1\>\/XI2\<0\>\/XI2\<0\>\/XI2\<0\>\/XI2\<0\>\/XI2\<0\>\/XI2\<0\>\/RR2_neg \
 ) R_1X_LL w=1e-07 l=1e-07   res=0.149966
XXI2\<0\>\/XI2\<1\>\/XI2\<0\>\/XI2\<0\>\/XI2\<0\>\/XI2\<0\>\/XI2\<0\>\/XI2\<0\>\/RR3 \
 (  \
 N_SEL3\<0\>_XI2\<0\>\/XI2\<1\>\/XI2\<0\>\/XI2\<0\>\/XI2\<0\>\/XI2\<0\>\/XI2\<0\>\/XI2\<0\>\/RR3_pos \
 N_WLSEL\<515\>_XI2\<0\>\/XI2\<1\>\/XI2\<0\>\/XI2\<0\>\/XI2\<0\>\/XI2\<0\>\/XI2\<0\>\/XI2\<0\>\/RR3_neg \
 ) R_1X_LL w=1e-07 l=1e-07   res=0.149966
XXI2\<0\>\/XI2\<1\>\/XI2\<0\>\/XI2\<0\>\/XI2\<0\>\/XI2\<0\>\/XI2\<0\>\/XI2\<0\>\/RR4 \
 (  \
 N_SEL4\<0\>_XI2\<0\>\/XI2\<1\>\/XI2\<0\>\/XI2\<0\>\/XI2\<0\>\/XI2\<0\>\/XI2\<0\>\/XI2\<0\>\/RR4_pos \
 N_WLSEL\<516\>_XI2\<0\>\/XI2\<1\>\/XI2\<0\>\/XI2\<0\>\/XI2\<0\>\/XI2\<0\>\/XI2\<0\>\/XI2\<0\>\/RR4_neg \
 ) R_1X_LL w=1e-07 l=1e-07   res=0.149966
XXI2\<0\>\/XI2\<1\>\/XI2\<0\>\/XI2\<0\>\/XI2\<0\>\/XI2\<0\>\/XI2\<0\>\/XI2\<0\>\/RR7 \
 (  \
 N_SEL5\<0\>_XI2\<0\>\/XI2\<1\>\/XI2\<0\>\/XI2\<0\>\/XI2\<0\>\/XI2\<0\>\/XI2\<0\>\/XI2\<0\>\/RR7_pos \
 N_WLSEL\<517\>_XI2\<0\>\/XI2\<1\>\/XI2\<0\>\/XI2\<0\>\/XI2\<0\>\/XI2\<0\>\/XI2\<0\>\/XI2\<0\>\/RR7_neg \
 ) R_1X_LL w=1e-07 l=1e-07   res=0.149966
XXI2\<0\>\/XI2\<1\>\/XI2\<0\>\/XI2\<0\>\/XI2\<0\>\/XI2\<0\>\/XI2\<0\>\/XI2\<0\>\/RR6 \
 (  \
 N_SEL6\<1\>_XI2\<0\>\/XI2\<1\>\/XI2\<0\>\/XI2\<0\>\/XI2\<0\>\/XI2\<0\>\/XI2\<0\>\/XI2\<0\>\/RR6_pos \
 N_WLSEL\<518\>_XI2\<0\>\/XI2\<1\>\/XI2\<0\>\/XI2\<0\>\/XI2\<0\>\/XI2\<0\>\/XI2\<0\>\/XI2\<0\>\/RR6_neg \
 ) R_1X_LL w=1e-07 l=1e-07   res=0.149966
XXI2\<0\>\/XI2\<1\>\/XI2\<0\>\/XI2\<0\>\/XI2\<0\>\/XI2\<0\>\/XI2\<0\>\/XI2\<0\>\/RR5 \
 (  \
 N_SEL7\<0\>_XI2\<0\>\/XI2\<1\>\/XI2\<0\>\/XI2\<0\>\/XI2\<0\>\/XI2\<0\>\/XI2\<0\>\/XI2\<0\>\/RR5_pos \
 N_WLSEL\<519\>_XI2\<0\>\/XI2\<1\>\/XI2\<0\>\/XI2\<0\>\/XI2\<0\>\/XI2\<0\>\/XI2\<0\>\/XI2\<0\>\/RR5_neg \
 ) R_1X_LL w=1e-07 l=1e-07   res=0.149966
XXI2\<0\>\/XI2\<1\>\/XI2\<0\>\/XI2\<0\>\/XI2\<0\>\/XI2\<0\>\/XI2\<0\>\/XI2\<1\>\/RR0 \
 (  \
 N_SEL0\<1\>_XI2\<0\>\/XI2\<1\>\/XI2\<0\>\/XI2\<0\>\/XI2\<0\>\/XI2\<0\>\/XI2\<0\>\/XI2\<1\>\/RR0_pos \
 N_WLSEL\<520\>_XI2\<0\>\/XI2\<1\>\/XI2\<0\>\/XI2\<0\>\/XI2\<0\>\/XI2\<0\>\/XI2\<0\>\/XI2\<1\>\/RR0_neg \
 ) R_1X_LL w=1e-07 l=1e-07   res=0.149966
XXI2\<0\>\/XI2\<1\>\/XI2\<0\>\/XI2\<0\>\/XI2\<0\>\/XI2\<0\>\/XI2\<0\>\/XI2\<1\>\/RR1 \
 (  \
 N_SEL1\<0\>_XI2\<0\>\/XI2\<1\>\/XI2\<0\>\/XI2\<0\>\/XI2\<0\>\/XI2\<0\>\/XI2\<0\>\/XI2\<1\>\/RR1_pos \
 N_WLSEL\<521\>_XI2\<0\>\/XI2\<1\>\/XI2\<0\>\/XI2\<0\>\/XI2\<0\>\/XI2\<0\>\/XI2\<0\>\/XI2\<1\>\/RR1_neg \
 ) R_1X_LL w=1e-07 l=1e-07   res=0.149966
XXI2\<0\>\/XI2\<1\>\/XI2\<0\>\/XI2\<0\>\/XI2\<0\>\/XI2\<0\>\/XI2\<0\>\/XI2\<1\>\/RR2 \
 (  \
 N_SEL2\<0\>_XI2\<0\>\/XI2\<1\>\/XI2\<0\>\/XI2\<0\>\/XI2\<0\>\/XI2\<0\>\/XI2\<0\>\/XI2\<1\>\/RR2_pos \
 N_WLSEL\<522\>_XI2\<0\>\/XI2\<1\>\/XI2\<0\>\/XI2\<0\>\/XI2\<0\>\/XI2\<0\>\/XI2\<0\>\/XI2\<1\>\/RR2_neg \
 ) R_1X_LL w=1e-07 l=1e-07   res=0.149966
XXI2\<0\>\/XI2\<1\>\/XI2\<0\>\/XI2\<0\>\/XI2\<0\>\/XI2\<0\>\/XI2\<0\>\/XI2\<1\>\/RR3 \
 (  \
 N_SEL3\<0\>_XI2\<0\>\/XI2\<1\>\/XI2\<0\>\/XI2\<0\>\/XI2\<0\>\/XI2\<0\>\/XI2\<0\>\/XI2\<1\>\/RR3_pos \
 N_WLSEL\<523\>_XI2\<0\>\/XI2\<1\>\/XI2\<0\>\/XI2\<0\>\/XI2\<0\>\/XI2\<0\>\/XI2\<0\>\/XI2\<1\>\/RR3_neg \
 ) R_1X_LL w=1e-07 l=1e-07   res=0.149966
XXI2\<0\>\/XI2\<1\>\/XI2\<0\>\/XI2\<0\>\/XI2\<0\>\/XI2\<0\>\/XI2\<0\>\/XI2\<1\>\/RR4 \
 (  \
 N_SEL4\<0\>_XI2\<0\>\/XI2\<1\>\/XI2\<0\>\/XI2\<0\>\/XI2\<0\>\/XI2\<0\>\/XI2\<0\>\/XI2\<1\>\/RR4_pos \
 N_WLSEL\<524\>_XI2\<0\>\/XI2\<1\>\/XI2\<0\>\/XI2\<0\>\/XI2\<0\>\/XI2\<0\>\/XI2\<0\>\/XI2\<1\>\/RR4_neg \
 ) R_1X_LL w=1e-07 l=1e-07   res=0.149966
XXI2\<0\>\/XI2\<1\>\/XI2\<0\>\/XI2\<0\>\/XI2\<0\>\/XI2\<0\>\/XI2\<0\>\/XI2\<1\>\/RR7 \
 (  \
 N_SEL5\<0\>_XI2\<0\>\/XI2\<1\>\/XI2\<0\>\/XI2\<0\>\/XI2\<0\>\/XI2\<0\>\/XI2\<0\>\/XI2\<1\>\/RR7_pos \
 N_WLSEL\<525\>_XI2\<0\>\/XI2\<1\>\/XI2\<0\>\/XI2\<0\>\/XI2\<0\>\/XI2\<0\>\/XI2\<0\>\/XI2\<1\>\/RR7_neg \
 ) R_1X_LL w=1e-07 l=1e-07   res=0.149966
XXI2\<0\>\/XI2\<1\>\/XI2\<0\>\/XI2\<0\>\/XI2\<0\>\/XI2\<0\>\/XI2\<0\>\/XI2\<1\>\/RR6 \
 (  \
 N_SEL6\<1\>_XI2\<0\>\/XI2\<1\>\/XI2\<0\>\/XI2\<0\>\/XI2\<0\>\/XI2\<0\>\/XI2\<0\>\/XI2\<1\>\/RR6_pos \
 N_WLSEL\<526\>_XI2\<0\>\/XI2\<1\>\/XI2\<0\>\/XI2\<0\>\/XI2\<0\>\/XI2\<0\>\/XI2\<0\>\/XI2\<1\>\/RR6_neg \
 ) R_1X_LL w=1e-07 l=1e-07   res=0.149966
XXI2\<0\>\/XI2\<1\>\/XI2\<0\>\/XI2\<0\>\/XI2\<0\>\/XI2\<0\>\/XI2\<0\>\/XI2\<1\>\/RR5 \
 (  \
 N_SEL7\<0\>_XI2\<0\>\/XI2\<1\>\/XI2\<0\>\/XI2\<0\>\/XI2\<0\>\/XI2\<0\>\/XI2\<0\>\/XI2\<1\>\/RR5_pos \
 N_WLSEL\<527\>_XI2\<0\>\/XI2\<1\>\/XI2\<0\>\/XI2\<0\>\/XI2\<0\>\/XI2\<0\>\/XI2\<0\>\/XI2\<1\>\/RR5_neg \
 ) R_1X_LL w=1e-07 l=1e-07   res=0.149966
XXI2\<0\>\/XI2\<1\>\/XI2\<0\>\/XI2\<0\>\/XI2\<0\>\/XI2\<0\>\/XI2\<1\>\/XI2\<0\>\/RR0 \
 (  \
 N_SEL0\<0\>_XI2\<0\>\/XI2\<1\>\/XI2\<0\>\/XI2\<0\>\/XI2\<0\>\/XI2\<0\>\/XI2\<1\>\/XI2\<0\>\/RR0_pos \
 N_WLSEL\<528\>_XI2\<0\>\/XI2\<1\>\/XI2\<0\>\/XI2\<0\>\/XI2\<0\>\/XI2\<0\>\/XI2\<1\>\/XI2\<0\>\/RR0_neg \
 ) R_1X_LL w=1e-07 l=1e-07   res=0.149966
XXI2\<0\>\/XI2\<1\>\/XI2\<0\>\/XI2\<0\>\/XI2\<0\>\/XI2\<0\>\/XI2\<1\>\/XI2\<0\>\/RR1 \
 (  \
 N_SEL1\<1\>_XI2\<0\>\/XI2\<1\>\/XI2\<0\>\/XI2\<0\>\/XI2\<0\>\/XI2\<0\>\/XI2\<1\>\/XI2\<0\>\/RR1_pos \
 N_WLSEL\<529\>_XI2\<0\>\/XI2\<1\>\/XI2\<0\>\/XI2\<0\>\/XI2\<0\>\/XI2\<0\>\/XI2\<1\>\/XI2\<0\>\/RR1_neg \
 ) R_1X_LL w=1e-07 l=1e-07   res=0.149966
XXI2\<0\>\/XI2\<1\>\/XI2\<0\>\/XI2\<0\>\/XI2\<0\>\/XI2\<0\>\/XI2\<1\>\/XI2\<0\>\/RR2 \
 (  \
 N_SEL2\<0\>_XI2\<0\>\/XI2\<1\>\/XI2\<0\>\/XI2\<0\>\/XI2\<0\>\/XI2\<0\>\/XI2\<1\>\/XI2\<0\>\/RR2_pos \
 N_WLSEL\<530\>_XI2\<0\>\/XI2\<1\>\/XI2\<0\>\/XI2\<0\>\/XI2\<0\>\/XI2\<0\>\/XI2\<1\>\/XI2\<0\>\/RR2_neg \
 ) R_1X_LL w=1e-07 l=1e-07   res=0.149966
XXI2\<0\>\/XI2\<1\>\/XI2\<0\>\/XI2\<0\>\/XI2\<0\>\/XI2\<0\>\/XI2\<1\>\/XI2\<0\>\/RR3 \
 (  \
 N_SEL3\<0\>_XI2\<0\>\/XI2\<1\>\/XI2\<0\>\/XI2\<0\>\/XI2\<0\>\/XI2\<0\>\/XI2\<1\>\/XI2\<0\>\/RR3_pos \
 N_WLSEL\<531\>_XI2\<0\>\/XI2\<1\>\/XI2\<0\>\/XI2\<0\>\/XI2\<0\>\/XI2\<0\>\/XI2\<1\>\/XI2\<0\>\/RR3_neg \
 ) R_1X_LL w=1e-07 l=1e-07   res=0.149966
XXI2\<0\>\/XI2\<1\>\/XI2\<0\>\/XI2\<0\>\/XI2\<0\>\/XI2\<0\>\/XI2\<1\>\/XI2\<0\>\/RR4 \
 (  \
 N_SEL4\<0\>_XI2\<0\>\/XI2\<1\>\/XI2\<0\>\/XI2\<0\>\/XI2\<0\>\/XI2\<0\>\/XI2\<1\>\/XI2\<0\>\/RR4_pos \
 N_WLSEL\<532\>_XI2\<0\>\/XI2\<1\>\/XI2\<0\>\/XI2\<0\>\/XI2\<0\>\/XI2\<0\>\/XI2\<1\>\/XI2\<0\>\/RR4_neg \
 ) R_1X_LL w=1e-07 l=1e-07   res=0.149966
XXI2\<0\>\/XI2\<1\>\/XI2\<0\>\/XI2\<0\>\/XI2\<0\>\/XI2\<0\>\/XI2\<1\>\/XI2\<0\>\/RR7 \
 (  \
 N_SEL5\<0\>_XI2\<0\>\/XI2\<1\>\/XI2\<0\>\/XI2\<0\>\/XI2\<0\>\/XI2\<0\>\/XI2\<1\>\/XI2\<0\>\/RR7_pos \
 N_WLSEL\<533\>_XI2\<0\>\/XI2\<1\>\/XI2\<0\>\/XI2\<0\>\/XI2\<0\>\/XI2\<0\>\/XI2\<1\>\/XI2\<0\>\/RR7_neg \
 ) R_1X_LL w=1e-07 l=1e-07   res=0.149966
XXI2\<0\>\/XI2\<1\>\/XI2\<0\>\/XI2\<0\>\/XI2\<0\>\/XI2\<0\>\/XI2\<1\>\/XI2\<0\>\/RR6 \
 (  \
 N_SEL6\<1\>_XI2\<0\>\/XI2\<1\>\/XI2\<0\>\/XI2\<0\>\/XI2\<0\>\/XI2\<0\>\/XI2\<1\>\/XI2\<0\>\/RR6_pos \
 N_WLSEL\<534\>_XI2\<0\>\/XI2\<1\>\/XI2\<0\>\/XI2\<0\>\/XI2\<0\>\/XI2\<0\>\/XI2\<1\>\/XI2\<0\>\/RR6_neg \
 ) R_1X_LL w=1e-07 l=1e-07   res=0.149966
XXI2\<0\>\/XI2\<1\>\/XI2\<0\>\/XI2\<0\>\/XI2\<0\>\/XI2\<0\>\/XI2\<1\>\/XI2\<0\>\/RR5 \
 (  \
 N_SEL7\<0\>_XI2\<0\>\/XI2\<1\>\/XI2\<0\>\/XI2\<0\>\/XI2\<0\>\/XI2\<0\>\/XI2\<1\>\/XI2\<0\>\/RR5_pos \
 N_WLSEL\<535\>_XI2\<0\>\/XI2\<1\>\/XI2\<0\>\/XI2\<0\>\/XI2\<0\>\/XI2\<0\>\/XI2\<1\>\/XI2\<0\>\/RR5_neg \
 ) R_1X_LL w=1e-07 l=1e-07   res=0.149966
XXI2\<0\>\/XI2\<1\>\/XI2\<0\>\/XI2\<0\>\/XI2\<0\>\/XI2\<0\>\/XI2\<1\>\/XI2\<1\>\/RR0 \
 (  \
 N_SEL0\<1\>_XI2\<0\>\/XI2\<1\>\/XI2\<0\>\/XI2\<0\>\/XI2\<0\>\/XI2\<0\>\/XI2\<1\>\/XI2\<1\>\/RR0_pos \
 N_WLSEL\<536\>_XI2\<0\>\/XI2\<1\>\/XI2\<0\>\/XI2\<0\>\/XI2\<0\>\/XI2\<0\>\/XI2\<1\>\/XI2\<1\>\/RR0_neg \
 ) R_1X_LL w=1e-07 l=1e-07   res=0.149966
XXI2\<0\>\/XI2\<1\>\/XI2\<0\>\/XI2\<0\>\/XI2\<0\>\/XI2\<0\>\/XI2\<1\>\/XI2\<1\>\/RR1 \
 (  \
 N_SEL1\<1\>_XI2\<0\>\/XI2\<1\>\/XI2\<0\>\/XI2\<0\>\/XI2\<0\>\/XI2\<0\>\/XI2\<1\>\/XI2\<1\>\/RR1_pos \
 N_WLSEL\<537\>_XI2\<0\>\/XI2\<1\>\/XI2\<0\>\/XI2\<0\>\/XI2\<0\>\/XI2\<0\>\/XI2\<1\>\/XI2\<1\>\/RR1_neg \
 ) R_1X_LL w=1e-07 l=1e-07   res=0.149966
XXI2\<0\>\/XI2\<1\>\/XI2\<0\>\/XI2\<0\>\/XI2\<0\>\/XI2\<0\>\/XI2\<1\>\/XI2\<1\>\/RR2 \
 (  \
 N_SEL2\<0\>_XI2\<0\>\/XI2\<1\>\/XI2\<0\>\/XI2\<0\>\/XI2\<0\>\/XI2\<0\>\/XI2\<1\>\/XI2\<1\>\/RR2_pos \
 N_WLSEL\<538\>_XI2\<0\>\/XI2\<1\>\/XI2\<0\>\/XI2\<0\>\/XI2\<0\>\/XI2\<0\>\/XI2\<1\>\/XI2\<1\>\/RR2_neg \
 ) R_1X_LL w=1e-07 l=1e-07   res=0.149966
XXI2\<0\>\/XI2\<1\>\/XI2\<0\>\/XI2\<0\>\/XI2\<0\>\/XI2\<0\>\/XI2\<1\>\/XI2\<1\>\/RR3 \
 (  \
 N_SEL3\<0\>_XI2\<0\>\/XI2\<1\>\/XI2\<0\>\/XI2\<0\>\/XI2\<0\>\/XI2\<0\>\/XI2\<1\>\/XI2\<1\>\/RR3_pos \
 N_WLSEL\<539\>_XI2\<0\>\/XI2\<1\>\/XI2\<0\>\/XI2\<0\>\/XI2\<0\>\/XI2\<0\>\/XI2\<1\>\/XI2\<1\>\/RR3_neg \
 ) R_1X_LL w=1e-07 l=1e-07   res=0.149966
XXI2\<0\>\/XI2\<1\>\/XI2\<0\>\/XI2\<0\>\/XI2\<0\>\/XI2\<0\>\/XI2\<1\>\/XI2\<1\>\/RR4 \
 (  \
 N_SEL4\<0\>_XI2\<0\>\/XI2\<1\>\/XI2\<0\>\/XI2\<0\>\/XI2\<0\>\/XI2\<0\>\/XI2\<1\>\/XI2\<1\>\/RR4_pos \
 N_WLSEL\<540\>_XI2\<0\>\/XI2\<1\>\/XI2\<0\>\/XI2\<0\>\/XI2\<0\>\/XI2\<0\>\/XI2\<1\>\/XI2\<1\>\/RR4_neg \
 ) R_1X_LL w=1e-07 l=1e-07   res=0.149966
XXI2\<0\>\/XI2\<0\>\/XI2\<0\>\/XI2\<0\>\/XI2\<0\>\/XI2\<0\>\/XI2\<0\>\/XI2\<0\>\/RR0 \
 (  \
 N_SEL0\<0\>_XI2\<0\>\/XI2\<0\>\/XI2\<0\>\/XI2\<0\>\/XI2\<0\>\/XI2\<0\>\/XI2\<0\>\/XI2\<0\>\/RR0_pos \
 N_WLSEL\<0\>_XI2\<0\>\/XI2\<0\>\/XI2\<0\>\/XI2\<0\>\/XI2\<0\>\/XI2\<0\>\/XI2\<0\>\/XI2\<0\>\/RR0_neg \
 ) R_1X_LL w=1e-07 l=1e-07   res=0.149966
XXI2\<0\>\/XI2\<0\>\/XI2\<0\>\/XI2\<0\>\/XI2\<0\>\/XI2\<0\>\/XI2\<0\>\/XI2\<0\>\/RR1 \
 (  \
 N_SEL1\<0\>_XI2\<0\>\/XI2\<0\>\/XI2\<0\>\/XI2\<0\>\/XI2\<0\>\/XI2\<0\>\/XI2\<0\>\/XI2\<0\>\/RR1_pos \
 N_WLSEL\<1\>_XI2\<0\>\/XI2\<0\>\/XI2\<0\>\/XI2\<0\>\/XI2\<0\>\/XI2\<0\>\/XI2\<0\>\/XI2\<0\>\/RR1_neg \
 ) R_1X_LL w=1e-07 l=1e-07   res=0.149966
XXI2\<0\>\/XI2\<0\>\/XI2\<0\>\/XI2\<0\>\/XI2\<0\>\/XI2\<0\>\/XI2\<0\>\/XI2\<0\>\/RR2 \
 (  \
 N_SEL2\<0\>_XI2\<0\>\/XI2\<0\>\/XI2\<0\>\/XI2\<0\>\/XI2\<0\>\/XI2\<0\>\/XI2\<0\>\/XI2\<0\>\/RR2_pos \
 N_WLSEL\<2\>_XI2\<0\>\/XI2\<0\>\/XI2\<0\>\/XI2\<0\>\/XI2\<0\>\/XI2\<0\>\/XI2\<0\>\/XI2\<0\>\/RR2_neg \
 ) R_1X_LL w=1e-07 l=1e-07   res=0.149966
XXI2\<0\>\/XI2\<0\>\/XI2\<0\>\/XI2\<0\>\/XI2\<0\>\/XI2\<0\>\/XI2\<0\>\/XI2\<0\>\/RR3 \
 (  \
 N_SEL3\<0\>_XI2\<0\>\/XI2\<0\>\/XI2\<0\>\/XI2\<0\>\/XI2\<0\>\/XI2\<0\>\/XI2\<0\>\/XI2\<0\>\/RR3_pos \
 N_WLSEL\<3\>_XI2\<0\>\/XI2\<0\>\/XI2\<0\>\/XI2\<0\>\/XI2\<0\>\/XI2\<0\>\/XI2\<0\>\/XI2\<0\>\/RR3_neg \
 ) R_1X_LL w=1e-07 l=1e-07   res=0.149966
XXI2\<0\>\/XI2\<0\>\/XI2\<0\>\/XI2\<0\>\/XI2\<0\>\/XI2\<0\>\/XI2\<0\>\/XI2\<0\>\/RR4 \
 (  \
 N_SEL4\<0\>_XI2\<0\>\/XI2\<0\>\/XI2\<0\>\/XI2\<0\>\/XI2\<0\>\/XI2\<0\>\/XI2\<0\>\/XI2\<0\>\/RR4_pos \
 N_WLSEL\<4\>_XI2\<0\>\/XI2\<0\>\/XI2\<0\>\/XI2\<0\>\/XI2\<0\>\/XI2\<0\>\/XI2\<0\>\/XI2\<0\>\/RR4_neg \
 ) R_1X_LL w=1e-07 l=1e-07   res=0.149966
XXI2\<0\>\/XI2\<0\>\/XI2\<0\>\/XI2\<0\>\/XI2\<0\>\/XI2\<0\>\/XI2\<0\>\/XI2\<0\>\/RR7 \
 (  \
 N_SEL5\<0\>_XI2\<0\>\/XI2\<0\>\/XI2\<0\>\/XI2\<0\>\/XI2\<0\>\/XI2\<0\>\/XI2\<0\>\/XI2\<0\>\/RR7_pos \
 N_WLSEL\<5\>_XI2\<0\>\/XI2\<0\>\/XI2\<0\>\/XI2\<0\>\/XI2\<0\>\/XI2\<0\>\/XI2\<0\>\/XI2\<0\>\/RR7_neg \
 ) R_1X_LL w=1e-07 l=1e-07   res=0.149966
XXI2\<0\>\/XI2\<0\>\/XI2\<0\>\/XI2\<0\>\/XI2\<0\>\/XI2\<0\>\/XI2\<0\>\/XI2\<0\>\/RR6 \
 (  \
 N_SEL6\<0\>_XI2\<0\>\/XI2\<0\>\/XI2\<0\>\/XI2\<0\>\/XI2\<0\>\/XI2\<0\>\/XI2\<0\>\/XI2\<0\>\/RR6_pos \
 N_WLSEL\<6\>_XI2\<0\>\/XI2\<0\>\/XI2\<0\>\/XI2\<0\>\/XI2\<0\>\/XI2\<0\>\/XI2\<0\>\/XI2\<0\>\/RR6_neg \
 ) R_1X_LL w=1e-07 l=1e-07   res=0.149966
XXI2\<0\>\/XI2\<0\>\/XI2\<0\>\/XI2\<0\>\/XI2\<0\>\/XI2\<0\>\/XI2\<0\>\/XI2\<0\>\/RR5 \
 (  \
 N_SEL7\<0\>_XI2\<0\>\/XI2\<0\>\/XI2\<0\>\/XI2\<0\>\/XI2\<0\>\/XI2\<0\>\/XI2\<0\>\/XI2\<0\>\/RR5_pos \
 N_WLSEL\<7\>_XI2\<0\>\/XI2\<0\>\/XI2\<0\>\/XI2\<0\>\/XI2\<0\>\/XI2\<0\>\/XI2\<0\>\/XI2\<0\>\/RR5_neg \
 ) R_1X_LL w=1e-07 l=1e-07   res=0.149966
XXI2\<0\>\/XI2\<0\>\/XI2\<0\>\/XI2\<0\>\/XI2\<0\>\/XI2\<0\>\/XI2\<0\>\/XI2\<1\>\/RR0 \
 (  \
 N_SEL0\<1\>_XI2\<0\>\/XI2\<0\>\/XI2\<0\>\/XI2\<0\>\/XI2\<0\>\/XI2\<0\>\/XI2\<0\>\/XI2\<1\>\/RR0_pos \
 N_WLSEL\<8\>_XI2\<0\>\/XI2\<0\>\/XI2\<0\>\/XI2\<0\>\/XI2\<0\>\/XI2\<0\>\/XI2\<0\>\/XI2\<1\>\/RR0_neg \
 ) R_1X_LL w=1e-07 l=1e-07   res=0.149966
XXI2\<0\>\/XI2\<0\>\/XI2\<0\>\/XI2\<0\>\/XI2\<0\>\/XI2\<0\>\/XI2\<0\>\/XI2\<1\>\/RR1 \
 (  \
 N_SEL1\<0\>_XI2\<0\>\/XI2\<0\>\/XI2\<0\>\/XI2\<0\>\/XI2\<0\>\/XI2\<0\>\/XI2\<0\>\/XI2\<1\>\/RR1_pos \
 N_WLSEL\<9\>_XI2\<0\>\/XI2\<0\>\/XI2\<0\>\/XI2\<0\>\/XI2\<0\>\/XI2\<0\>\/XI2\<0\>\/XI2\<1\>\/RR1_neg \
 ) R_1X_LL w=1e-07 l=1e-07   res=0.149966
XXI2\<0\>\/XI2\<0\>\/XI2\<0\>\/XI2\<0\>\/XI2\<0\>\/XI2\<0\>\/XI2\<0\>\/XI2\<1\>\/RR2 \
 (  \
 N_SEL2\<0\>_XI2\<0\>\/XI2\<0\>\/XI2\<0\>\/XI2\<0\>\/XI2\<0\>\/XI2\<0\>\/XI2\<0\>\/XI2\<1\>\/RR2_pos \
 N_WLSEL\<10\>_XI2\<0\>\/XI2\<0\>\/XI2\<0\>\/XI2\<0\>\/XI2\<0\>\/XI2\<0\>\/XI2\<0\>\/XI2\<1\>\/RR2_neg \
 ) R_1X_LL w=1e-07 l=1e-07   res=0.149966
XXI2\<0\>\/XI2\<0\>\/XI2\<0\>\/XI2\<0\>\/XI2\<0\>\/XI2\<0\>\/XI2\<0\>\/XI2\<1\>\/RR3 \
 (  \
 N_SEL3\<0\>_XI2\<0\>\/XI2\<0\>\/XI2\<0\>\/XI2\<0\>\/XI2\<0\>\/XI2\<0\>\/XI2\<0\>\/XI2\<1\>\/RR3_pos \
 N_WLSEL\<11\>_XI2\<0\>\/XI2\<0\>\/XI2\<0\>\/XI2\<0\>\/XI2\<0\>\/XI2\<0\>\/XI2\<0\>\/XI2\<1\>\/RR3_neg \
 ) R_1X_LL w=1e-07 l=1e-07   res=0.149966
XXI2\<0\>\/XI2\<0\>\/XI2\<0\>\/XI2\<0\>\/XI2\<0\>\/XI2\<0\>\/XI2\<0\>\/XI2\<1\>\/RR4 \
 (  \
 N_SEL4\<0\>_XI2\<0\>\/XI2\<0\>\/XI2\<0\>\/XI2\<0\>\/XI2\<0\>\/XI2\<0\>\/XI2\<0\>\/XI2\<1\>\/RR4_pos \
 N_WLSEL\<12\>_XI2\<0\>\/XI2\<0\>\/XI2\<0\>\/XI2\<0\>\/XI2\<0\>\/XI2\<0\>\/XI2\<0\>\/XI2\<1\>\/RR4_neg \
 ) R_1X_LL w=1e-07 l=1e-07   res=0.149966
XXI2\<0\>\/XI2\<0\>\/XI2\<0\>\/XI2\<0\>\/XI2\<0\>\/XI2\<0\>\/XI2\<0\>\/XI2\<1\>\/RR7 \
 (  \
 N_SEL5\<0\>_XI2\<0\>\/XI2\<0\>\/XI2\<0\>\/XI2\<0\>\/XI2\<0\>\/XI2\<0\>\/XI2\<0\>\/XI2\<1\>\/RR7_pos \
 N_WLSEL\<13\>_XI2\<0\>\/XI2\<0\>\/XI2\<0\>\/XI2\<0\>\/XI2\<0\>\/XI2\<0\>\/XI2\<0\>\/XI2\<1\>\/RR7_neg \
 ) R_1X_LL w=1e-07 l=1e-07   res=0.149966
XXI2\<0\>\/XI2\<0\>\/XI2\<0\>\/XI2\<0\>\/XI2\<0\>\/XI2\<0\>\/XI2\<0\>\/XI2\<1\>\/RR6 \
 (  \
 N_SEL6\<0\>_XI2\<0\>\/XI2\<0\>\/XI2\<0\>\/XI2\<0\>\/XI2\<0\>\/XI2\<0\>\/XI2\<0\>\/XI2\<1\>\/RR6_pos \
 N_WLSEL\<14\>_XI2\<0\>\/XI2\<0\>\/XI2\<0\>\/XI2\<0\>\/XI2\<0\>\/XI2\<0\>\/XI2\<0\>\/XI2\<1\>\/RR6_neg \
 ) R_1X_LL w=1e-07 l=1e-07   res=0.149966
XXI2\<0\>\/XI2\<0\>\/XI2\<0\>\/XI2\<0\>\/XI2\<0\>\/XI2\<0\>\/XI2\<0\>\/XI2\<1\>\/RR5 \
 (  \
 N_SEL7\<0\>_XI2\<0\>\/XI2\<0\>\/XI2\<0\>\/XI2\<0\>\/XI2\<0\>\/XI2\<0\>\/XI2\<0\>\/XI2\<1\>\/RR5_pos \
 N_WLSEL\<15\>_XI2\<0\>\/XI2\<0\>\/XI2\<0\>\/XI2\<0\>\/XI2\<0\>\/XI2\<0\>\/XI2\<0\>\/XI2\<1\>\/RR5_neg \
 ) R_1X_LL w=1e-07 l=1e-07   res=0.149966
XXI2\<0\>\/XI2\<0\>\/XI2\<0\>\/XI2\<0\>\/XI2\<0\>\/XI2\<0\>\/XI2\<1\>\/XI2\<0\>\/RR0 \
 (  \
 N_SEL0\<0\>_XI2\<0\>\/XI2\<0\>\/XI2\<0\>\/XI2\<0\>\/XI2\<0\>\/XI2\<0\>\/XI2\<1\>\/XI2\<0\>\/RR0_pos \
 N_WLSEL\<16\>_XI2\<0\>\/XI2\<0\>\/XI2\<0\>\/XI2\<0\>\/XI2\<0\>\/XI2\<0\>\/XI2\<1\>\/XI2\<0\>\/RR0_neg \
 ) R_1X_LL w=1e-07 l=1e-07   res=0.149966
XXI2\<0\>\/XI2\<0\>\/XI2\<0\>\/XI2\<0\>\/XI2\<0\>\/XI2\<0\>\/XI2\<1\>\/XI2\<0\>\/RR1 \
 (  \
 N_SEL1\<1\>_XI2\<0\>\/XI2\<0\>\/XI2\<0\>\/XI2\<0\>\/XI2\<0\>\/XI2\<0\>\/XI2\<1\>\/XI2\<0\>\/RR1_pos \
 N_WLSEL\<17\>_XI2\<0\>\/XI2\<0\>\/XI2\<0\>\/XI2\<0\>\/XI2\<0\>\/XI2\<0\>\/XI2\<1\>\/XI2\<0\>\/RR1_neg \
 ) R_1X_LL w=1e-07 l=1e-07   res=0.149966
XXI2\<0\>\/XI2\<0\>\/XI2\<0\>\/XI2\<0\>\/XI2\<0\>\/XI2\<0\>\/XI2\<1\>\/XI2\<0\>\/RR2 \
 (  \
 N_SEL2\<0\>_XI2\<0\>\/XI2\<0\>\/XI2\<0\>\/XI2\<0\>\/XI2\<0\>\/XI2\<0\>\/XI2\<1\>\/XI2\<0\>\/RR2_pos \
 N_WLSEL\<18\>_XI2\<0\>\/XI2\<0\>\/XI2\<0\>\/XI2\<0\>\/XI2\<0\>\/XI2\<0\>\/XI2\<1\>\/XI2\<0\>\/RR2_neg \
 ) R_1X_LL w=1e-07 l=1e-07   res=0.149966
XXI2\<0\>\/XI2\<0\>\/XI2\<0\>\/XI2\<0\>\/XI2\<0\>\/XI2\<0\>\/XI2\<1\>\/XI2\<0\>\/RR3 \
 (  \
 N_SEL3\<0\>_XI2\<0\>\/XI2\<0\>\/XI2\<0\>\/XI2\<0\>\/XI2\<0\>\/XI2\<0\>\/XI2\<1\>\/XI2\<0\>\/RR3_pos \
 N_WLSEL\<19\>_XI2\<0\>\/XI2\<0\>\/XI2\<0\>\/XI2\<0\>\/XI2\<0\>\/XI2\<0\>\/XI2\<1\>\/XI2\<0\>\/RR3_neg \
 ) R_1X_LL w=1e-07 l=1e-07   res=0.149966
XXI2\<0\>\/XI2\<0\>\/XI2\<0\>\/XI2\<0\>\/XI2\<0\>\/XI2\<0\>\/XI2\<1\>\/XI2\<0\>\/RR4 \
 (  \
 N_SEL4\<0\>_XI2\<0\>\/XI2\<0\>\/XI2\<0\>\/XI2\<0\>\/XI2\<0\>\/XI2\<0\>\/XI2\<1\>\/XI2\<0\>\/RR4_pos \
 N_WLSEL\<20\>_XI2\<0\>\/XI2\<0\>\/XI2\<0\>\/XI2\<0\>\/XI2\<0\>\/XI2\<0\>\/XI2\<1\>\/XI2\<0\>\/RR4_neg \
 ) R_1X_LL w=1e-07 l=1e-07   res=0.149966
XXI2\<0\>\/XI2\<0\>\/XI2\<0\>\/XI2\<0\>\/XI2\<0\>\/XI2\<0\>\/XI2\<1\>\/XI2\<0\>\/RR7 \
 (  \
 N_SEL5\<0\>_XI2\<0\>\/XI2\<0\>\/XI2\<0\>\/XI2\<0\>\/XI2\<0\>\/XI2\<0\>\/XI2\<1\>\/XI2\<0\>\/RR7_pos \
 N_WLSEL\<21\>_XI2\<0\>\/XI2\<0\>\/XI2\<0\>\/XI2\<0\>\/XI2\<0\>\/XI2\<0\>\/XI2\<1\>\/XI2\<0\>\/RR7_neg \
 ) R_1X_LL w=1e-07 l=1e-07   res=0.149966
XXI2\<0\>\/XI2\<0\>\/XI2\<0\>\/XI2\<0\>\/XI2\<0\>\/XI2\<0\>\/XI2\<1\>\/XI2\<0\>\/RR6 \
 (  \
 N_SEL6\<0\>_XI2\<0\>\/XI2\<0\>\/XI2\<0\>\/XI2\<0\>\/XI2\<0\>\/XI2\<0\>\/XI2\<1\>\/XI2\<0\>\/RR6_pos \
 N_WLSEL\<22\>_XI2\<0\>\/XI2\<0\>\/XI2\<0\>\/XI2\<0\>\/XI2\<0\>\/XI2\<0\>\/XI2\<1\>\/XI2\<0\>\/RR6_neg \
 ) R_1X_LL w=1e-07 l=1e-07   res=0.149966
XXI2\<0\>\/XI2\<0\>\/XI2\<0\>\/XI2\<0\>\/XI2\<0\>\/XI2\<0\>\/XI2\<1\>\/XI2\<0\>\/RR5 \
 (  \
 N_SEL7\<0\>_XI2\<0\>\/XI2\<0\>\/XI2\<0\>\/XI2\<0\>\/XI2\<0\>\/XI2\<0\>\/XI2\<1\>\/XI2\<0\>\/RR5_pos \
 N_WLSEL\<23\>_XI2\<0\>\/XI2\<0\>\/XI2\<0\>\/XI2\<0\>\/XI2\<0\>\/XI2\<0\>\/XI2\<1\>\/XI2\<0\>\/RR5_neg \
 ) R_1X_LL w=1e-07 l=1e-07   res=0.149966
XXI2\<0\>\/XI2\<0\>\/XI2\<0\>\/XI2\<0\>\/XI2\<0\>\/XI2\<0\>\/XI2\<1\>\/XI2\<1\>\/RR0 \
 (  \
 N_SEL0\<1\>_XI2\<0\>\/XI2\<0\>\/XI2\<0\>\/XI2\<0\>\/XI2\<0\>\/XI2\<0\>\/XI2\<1\>\/XI2\<1\>\/RR0_pos \
 N_WLSEL\<24\>_XI2\<0\>\/XI2\<0\>\/XI2\<0\>\/XI2\<0\>\/XI2\<0\>\/XI2\<0\>\/XI2\<1\>\/XI2\<1\>\/RR0_neg \
 ) R_1X_LL w=1e-07 l=1e-07   res=0.149966
XXI2\<0\>\/XI2\<0\>\/XI2\<0\>\/XI2\<0\>\/XI2\<0\>\/XI2\<0\>\/XI2\<1\>\/XI2\<1\>\/RR1 \
 (  \
 N_SEL1\<1\>_XI2\<0\>\/XI2\<0\>\/XI2\<0\>\/XI2\<0\>\/XI2\<0\>\/XI2\<0\>\/XI2\<1\>\/XI2\<1\>\/RR1_pos \
 N_WLSEL\<25\>_XI2\<0\>\/XI2\<0\>\/XI2\<0\>\/XI2\<0\>\/XI2\<0\>\/XI2\<0\>\/XI2\<1\>\/XI2\<1\>\/RR1_neg \
 ) R_1X_LL w=1e-07 l=1e-07   res=0.149966
XXI2\<0\>\/XI2\<0\>\/XI2\<0\>\/XI2\<0\>\/XI2\<0\>\/XI2\<0\>\/XI2\<1\>\/XI2\<1\>\/RR2 \
 (  \
 N_SEL2\<0\>_XI2\<0\>\/XI2\<0\>\/XI2\<0\>\/XI2\<0\>\/XI2\<0\>\/XI2\<0\>\/XI2\<1\>\/XI2\<1\>\/RR2_pos \
 N_WLSEL\<26\>_XI2\<0\>\/XI2\<0\>\/XI2\<0\>\/XI2\<0\>\/XI2\<0\>\/XI2\<0\>\/XI2\<1\>\/XI2\<1\>\/RR2_neg \
 ) R_1X_LL w=1e-07 l=1e-07   res=0.149966
XXI2\<0\>\/XI2\<0\>\/XI2\<0\>\/XI2\<0\>\/XI2\<0\>\/XI2\<0\>\/XI2\<1\>\/XI2\<1\>\/RR3 \
 (  \
 N_SEL3\<0\>_XI2\<0\>\/XI2\<0\>\/XI2\<0\>\/XI2\<0\>\/XI2\<0\>\/XI2\<0\>\/XI2\<1\>\/XI2\<1\>\/RR3_pos \
 N_WLSEL\<27\>_XI2\<0\>\/XI2\<0\>\/XI2\<0\>\/XI2\<0\>\/XI2\<0\>\/XI2\<0\>\/XI2\<1\>\/XI2\<1\>\/RR3_neg \
 ) R_1X_LL w=1e-07 l=1e-07   res=0.149966
XXI2\<0\>\/XI2\<0\>\/XI2\<0\>\/XI2\<0\>\/XI2\<0\>\/XI2\<0\>\/XI2\<1\>\/XI2\<1\>\/RR4 \
 (  \
 N_SEL4\<0\>_XI2\<0\>\/XI2\<0\>\/XI2\<0\>\/XI2\<0\>\/XI2\<0\>\/XI2\<0\>\/XI2\<1\>\/XI2\<1\>\/RR4_pos \
 N_WLSEL\<28\>_XI2\<0\>\/XI2\<0\>\/XI2\<0\>\/XI2\<0\>\/XI2\<0\>\/XI2\<0\>\/XI2\<1\>\/XI2\<1\>\/RR4_neg \
 ) R_1X_LL w=1e-07 l=1e-07   res=0.149966
//
include "/home/edauser0/ayigit/RowDecoder_Project/CDS_VISIO/project_pex/Post_L8_256t8_Text/spectreText/spectre.scs.POST_L8_256T8_PEX2.pxi"
//
ends POST_L8_256T8_TEXT
//
//
