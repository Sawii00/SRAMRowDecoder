// Design: project_common/INV_tb
simulator lang=spectre
global 0
parameters cap_val=200.01a
include "/dkits/umc/65nm/lms65ll/pdk_b09pb/umc65ll/../Models/Spectre/l65ll_v151.lib.scs" section=tt_ll_rvt12
include "/dkits/umc/65nm/lms65ll/pdk_b09pb/umc65ll/../Models/Spectre/l65ll_v151.lib.scs" section=tt_ll_hvt12
include "/dkits/umc/65nm/lms65ll/pdk_b09pb/umc65ll/../Models/Spectre/l65ll_v151.lib.scs" section=tt_ll_lvt12
include "/dkits/umc/65nm/lms65ll/pdk_b09pb/umc65ll/../Models/Spectre/l65ll_v151.lib.scs" section=tt_ll_io18
include "/dkits/umc/65nm/lms65ll/pdk_b09pb/umc65ll/../Models/Spectre/l65ll_v151.lib.scs" section=tt_ll_io25od33
include "/dkits/umc/65nm/lms65ll/pdk_b09pb/umc65ll/../Models/Spectre/l65ll_v151.lib.scs" section=tt_ll_io33
include "/dkits/umc/65nm/lms65ll/pdk_b09pb/umc65ll/../Models/Spectre/l65ll_v151.lib.scs" section=tt_ll_nvt12
include "/dkits/umc/65nm/lms65ll/pdk_b09pb/umc65ll/../Models/Spectre/l65ll_v151.lib.scs" section=tt_ll_nvt12_bpw
include "/dkits/umc/65nm/lms65ll/pdk_b09pb/umc65ll/../Models/Spectre/l65ll_v151.lib.scs" section=tt_ll_nvt18
include "/dkits/umc/65nm/lms65ll/pdk_b09pb/umc65ll/../Models/Spectre/l65ll_v151.lib.scs" section=tt_ll_nvt18_bpw
include "/dkits/umc/65nm/lms65ll/pdk_b09pb/umc65ll/../Models/Spectre/l65ll_v151.lib.scs" section=tt_ll_nvt25od33
include "/dkits/umc/65nm/lms65ll/pdk_b09pb/umc65ll/../Models/Spectre/l65ll_v151.lib.scs" section=tt_ll_nvt25od33_bpw
include "/dkits/umc/65nm/lms65ll/pdk_b09pb/umc65ll/../Models/Spectre/l65ll_v151.lib.scs" section=tt_ll_nvt33
include "/dkits/umc/65nm/lms65ll/pdk_b09pb/umc65ll/../Models/Spectre/l65ll_v151.lib.scs" section=tt_ll_nvt33_bpw
include "/dkits/umc/65nm/lms65ll/pdk_b09pb/umc65ll/../Models/Spectre/l65ll_v151.lib.scs" section=tt_ll_bjt
include "/dkits/umc/65nm/lms65ll/pdk_b09pb/umc65ll/../Models/Spectre/l65ll_v151.lib.scs" section=tt_ll_diode
include "/dkits/umc/65nm/lms65ll/pdk_b09pb/umc65ll/../Models/Spectre/l65ll_v151.lib.scs" section=tt_65_momcaps
include "/dkits/umc/65nm/lms65ll/pdk_b09pb/umc65ll/../Models/Spectre/l65ll_v151.lib.scs" section=tt_ll_ncap12
include "/dkits/umc/65nm/lms65ll/pdk_b09pb/umc65ll/../Models/Spectre/l65ll_v151.lib.scs" section=tt_ll_ncap18
include "/dkits/umc/65nm/lms65ll/pdk_b09pb/umc65ll/../Models/Spectre/l65ll_v151.lib.scs" section=tt_ll_ncap25
include "/dkits/umc/65nm/lms65ll/pdk_b09pb/umc65ll/../Models/Spectre/l65ll_v151.lib.scs" section=tt_ll_ncap33
include "/dkits/umc/65nm/lms65ll/pdk_b09pb/umc65ll/../Models/Spectre/l65ll_v151.lib.scs" section=tt_ll_pcap12
include "/dkits/umc/65nm/lms65ll/pdk_b09pb/umc65ll/../Models/Spectre/l65ll_v151.lib.scs" section=tt_ll_pcap18
include "/dkits/umc/65nm/lms65ll/pdk_b09pb/umc65ll/../Models/Spectre/l65ll_v151.lib.scs" section=tt_ll_pcap25
include "/dkits/umc/65nm/lms65ll/pdk_b09pb/umc65ll/../Models/Spectre/l65ll_v151.lib.scs" section=tt_ll_pcap33
include "/dkits/umc/65nm/lms65ll/pdk_b09pb/umc65ll/../Models/Spectre/l65ll_v151.lib.scs" section=tt_ll_res
include "/dkits/umc/65nm/lms65ll/pdk_b09pb/umc65ll/../Models/Spectre/L65LL_RVT12_V101_RF.lib.scs" section=tt
include "/dkits/umc/65nm/lms65ll/pdk_b09pb/umc65ll/../Models/Spectre/L65LL_HVT12_V101_RF.lib.scs" section=tt
include "/dkits/umc/65nm/lms65ll/pdk_b09pb/umc65ll/../Models/Spectre/L65LL_LVT12_V101_RF.lib.scs" section=tt
include "/dkits/umc/65nm/lms65ll/pdk_b09pb/umc65ll/../Models/Spectre/L65LL_IO18_V101_RF.lib.scs" section=tt
include "/dkits/umc/65nm/lms65ll/pdk_b09pb/umc65ll/../Models/Spectre/L65LL_IO25_V101_RF.lib.scs" section=tt
include "/dkits/umc/65nm/lms65ll/pdk_b09pb/umc65ll/../Models/Spectre/L65LL_IO33_V111_RF.lib.scs" section=tt
include "/dkits/umc/65nm/lms65ll/pdk_b09pb/umc65ll/../Models/Spectre/L65LL_VARMIS12_V111_RF.lib.scs" section=typ
include "/dkits/umc/65nm/lms65ll/pdk_b09pb/umc65ll/../Models/Spectre/L65LL_VARMIS18_V111_RF.lib.scs" section=typ
include "/dkits/umc/65nm/lms65ll/pdk_b09pb/umc65ll/../Models/Spectre/L65LL_VARMIS25_V121_RF.lib.scs" section=typ
include "/dkits/umc/65nm/lms65ll/pdk_b09pb/umc65ll/../Models/Spectre/L65LL_VARMIS33_V111_RF.lib.scs" section=typ
include "/dkits/umc/65nm/lms65ll/pdk_b09pb/umc65ll/../Models/Spectre/L65LL_VARDIOP_V101_RF.lib.scs" section=typ
include "/dkits/umc/65nm/lms65ll/pdk_b09pb/umc65ll/../Models/Spectre/momcaps_array_vp3_rfvcl_V101.lib.scs" section=typ
include "/dkits/umc/65nm/lms65ll/pdk_b09pb/umc65ll/../Models/Spectre/momcaps_array_vp4_rfvcl_V101.lib.scs" section=typ
include "/dkits/umc/65nm/lms65ll/pdk_b09pb/umc65ll/../Models/Spectre/momcaps_array_vp5_rfvcl_V101.lib.scs" section=typ
include "/dkits/umc/65nm/lms65ll/pdk_b09pb/umc65ll/../Models/Spectre/L65_MIMCAPS_20F_KF_V101_RF.lib.scs" section=tt
include "/dkits/umc/65nm/lms65ll/pdk_b09pb/umc65ll/../Models/Spectre/L65LL_RNPPO_V101_RF.lib.scs" section=typ
include "/dkits/umc/65nm/lms65ll/pdk_b09pb/umc65ll/../Models/Spectre/L65LL_RNNPO_V101_RF.lib.scs" section=typ
include "/dkits/umc/65nm/lms65ll/pdk_b09pb/umc65ll/../Models/Spectre/L65LL_RNHR_V101_RF.lib.scs" section=typ
include "/dkits/umc/65nm/lms65ll/pdk_b09pb/umc65ll/../Models/Spectre/L65_pad_rf_V101.lib.scs" section=typ

// project_common/INV_tb/schematic
V0 (I 0) vsource type=pulse val0=0 val1=1 period=10n
C0 (O 0) capacitor c=cap_val
V1 (net06 0) vsource dc=1 type=dc
PM0 (O I net06 net06) p_12_llrvt l=60n w=200n nf=1 mis_flag=1 m=1 mf=1
NM0 (O I 0 0) n_12_llrvt l=60n w=80n nf=1 mis_flag=1 m=1 mf=1
simulatorOptions options temp=27
tran tran stop=100n errpreset=conservative
