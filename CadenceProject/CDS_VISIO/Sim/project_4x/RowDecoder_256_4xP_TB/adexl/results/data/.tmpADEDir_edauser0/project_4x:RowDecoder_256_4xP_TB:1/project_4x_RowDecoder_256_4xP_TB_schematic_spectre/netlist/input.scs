// Design: project_4x/RowDecoder_256_4xP_TB
simulator lang=spectre
global 0 vdd!
include "/dkits/umc/65nm/lms65ll/pdk_b09pb/umc65ll/../Models/Spectre/l65ll_v151.lib.scs" section=tt_ll_rvt12
include "/dkits/umc/65nm/lms65ll/pdk_b09pb/umc65ll/../Models/Spectre/l65ll_v151.lib.scs" section=tt_ll_hvt12
include "/dkits/umc/65nm/lms65ll/pdk_b09pb/umc65ll/../Models/Spectre/l65ll_v151.lib.scs" section=tt_ll_lvt12
include "/dkits/umc/65nm/lms65ll/pdk_b09pb/umc65ll/../Models/Spectre/l65ll_v151.lib.scs" section=tt_ll_io18
include "/dkits/umc/65nm/lms65ll/pdk_b09pb/umc65ll/../Models/Spectre/l65ll_v151.lib.scs" section=tt_ll_io25od33
include "/dkits/umc/65nm/lms65ll/pdk_b09pb/umc65ll/../Models/Spectre/l65ll_v151.lib.scs" section=tt_ll_io33
include "/dkits/umc/65nm/lms65ll/pdk_b09pb/umc65ll/../Models/Spectre/l65ll_v151.lib.scs" section=tt_ll_nvt12
include "/dkits/umc/65nm/lms65ll/pdk_b09pb/umc65ll/../Models/Spectre/l65ll_v151.lib.scs" section=tt_ll_nvt12_bpw
include "/dkits/umc/65nm/lms65ll/pdk_b09pb/umc65ll/../Models/Spectre/l65ll_v151.lib.scs" section=tt_ll_nvt18
include "/dkits/umc/65nm/lms65ll/pdk_b09pb/umc65ll/../Models/Spectre/l65ll_v151.lib.scs" section=tt_ll_nvt18_bpw
include "/dkits/umc/65nm/lms65ll/pdk_b09pb/umc65ll/../Models/Spectre/l65ll_v151.lib.scs" section=tt_ll_nvt25od33
include "/dkits/umc/65nm/lms65ll/pdk_b09pb/umc65ll/../Models/Spectre/l65ll_v151.lib.scs" section=tt_ll_nvt25od33_bpw
include "/dkits/umc/65nm/lms65ll/pdk_b09pb/umc65ll/../Models/Spectre/l65ll_v151.lib.scs" section=tt_ll_nvt33
include "/dkits/umc/65nm/lms65ll/pdk_b09pb/umc65ll/../Models/Spectre/l65ll_v151.lib.scs" section=tt_ll_nvt33_bpw
include "/dkits/umc/65nm/lms65ll/pdk_b09pb/umc65ll/../Models/Spectre/l65ll_v151.lib.scs" section=tt_ll_bjt
include "/dkits/umc/65nm/lms65ll/pdk_b09pb/umc65ll/../Models/Spectre/l65ll_v151.lib.scs" section=tt_ll_diode
include "/dkits/umc/65nm/lms65ll/pdk_b09pb/umc65ll/../Models/Spectre/l65ll_v151.lib.scs" section=tt_65_momcaps
include "/dkits/umc/65nm/lms65ll/pdk_b09pb/umc65ll/../Models/Spectre/l65ll_v151.lib.scs" section=tt_ll_ncap12
include "/dkits/umc/65nm/lms65ll/pdk_b09pb/umc65ll/../Models/Spectre/l65ll_v151.lib.scs" section=tt_ll_ncap18
include "/dkits/umc/65nm/lms65ll/pdk_b09pb/umc65ll/../Models/Spectre/l65ll_v151.lib.scs" section=tt_ll_ncap25
include "/dkits/umc/65nm/lms65ll/pdk_b09pb/umc65ll/../Models/Spectre/l65ll_v151.lib.scs" section=tt_ll_ncap33
include "/dkits/umc/65nm/lms65ll/pdk_b09pb/umc65ll/../Models/Spectre/l65ll_v151.lib.scs" section=tt_ll_pcap12
include "/dkits/umc/65nm/lms65ll/pdk_b09pb/umc65ll/../Models/Spectre/l65ll_v151.lib.scs" section=tt_ll_pcap18
include "/dkits/umc/65nm/lms65ll/pdk_b09pb/umc65ll/../Models/Spectre/l65ll_v151.lib.scs" section=tt_ll_pcap25
include "/dkits/umc/65nm/lms65ll/pdk_b09pb/umc65ll/../Models/Spectre/l65ll_v151.lib.scs" section=tt_ll_pcap33
include "/dkits/umc/65nm/lms65ll/pdk_b09pb/umc65ll/../Models/Spectre/l65ll_v151.lib.scs" section=tt_ll_res
include "/dkits/umc/65nm/lms65ll/pdk_b09pb/umc65ll/../Models/Spectre/L65LL_RVT12_V101_RF.lib.scs" section=tt
include "/dkits/umc/65nm/lms65ll/pdk_b09pb/umc65ll/../Models/Spectre/L65LL_HVT12_V101_RF.lib.scs" section=tt
include "/dkits/umc/65nm/lms65ll/pdk_b09pb/umc65ll/../Models/Spectre/L65LL_LVT12_V101_RF.lib.scs" section=tt
include "/dkits/umc/65nm/lms65ll/pdk_b09pb/umc65ll/../Models/Spectre/L65LL_IO18_V101_RF.lib.scs" section=tt
include "/dkits/umc/65nm/lms65ll/pdk_b09pb/umc65ll/../Models/Spectre/L65LL_IO25_V101_RF.lib.scs" section=tt
include "/dkits/umc/65nm/lms65ll/pdk_b09pb/umc65ll/../Models/Spectre/L65LL_IO33_V111_RF.lib.scs" section=tt
include "/dkits/umc/65nm/lms65ll/pdk_b09pb/umc65ll/../Models/Spectre/L65LL_VARMIS12_V111_RF.lib.scs" section=typ
include "/dkits/umc/65nm/lms65ll/pdk_b09pb/umc65ll/../Models/Spectre/L65LL_VARMIS18_V111_RF.lib.scs" section=typ
include "/dkits/umc/65nm/lms65ll/pdk_b09pb/umc65ll/../Models/Spectre/L65LL_VARMIS25_V121_RF.lib.scs" section=typ
include "/dkits/umc/65nm/lms65ll/pdk_b09pb/umc65ll/../Models/Spectre/L65LL_VARMIS33_V111_RF.lib.scs" section=typ
include "/dkits/umc/65nm/lms65ll/pdk_b09pb/umc65ll/../Models/Spectre/L65LL_VARDIOP_V101_RF.lib.scs" section=typ
include "/dkits/umc/65nm/lms65ll/pdk_b09pb/umc65ll/../Models/Spectre/momcaps_array_vp3_rfvcl_V101.lib.scs" section=typ
include "/dkits/umc/65nm/lms65ll/pdk_b09pb/umc65ll/../Models/Spectre/momcaps_array_vp4_rfvcl_V101.lib.scs" section=typ
include "/dkits/umc/65nm/lms65ll/pdk_b09pb/umc65ll/../Models/Spectre/momcaps_array_vp5_rfvcl_V101.lib.scs" section=typ
include "/dkits/umc/65nm/lms65ll/pdk_b09pb/umc65ll/../Models/Spectre/L65_MIMCAPS_20F_KF_V101_RF.lib.scs" section=tt
include "/dkits/umc/65nm/lms65ll/pdk_b09pb/umc65ll/../Models/Spectre/L65LL_RNPPO_V101_RF.lib.scs" section=typ
include "/dkits/umc/65nm/lms65ll/pdk_b09pb/umc65ll/../Models/Spectre/L65LL_RNNPO_V101_RF.lib.scs" section=typ
include "/dkits/umc/65nm/lms65ll/pdk_b09pb/umc65ll/../Models/Spectre/L65LL_RNHR_V101_RF.lib.scs" section=typ
include "/dkits/umc/65nm/lms65ll/pdk_b09pb/umc65ll/../Models/Spectre/L65_pad_rf_V101.lib.scs" section=typ

// project_common/INV/schematic
subckt INV A Z
parameters gamma=1 beta=2
    NM0 (Z A 0 0) n_12_llrvt l=60n w=gamma*80n nf=1 mis_flag=1 m=1 mf=1
    PM0 (Z A vdd! vdd!) p_12_llrvt l=60n w=gamma*beta*80n nf=1 mis_flag=1 m=1 mf=1
ends INV

// project_common/NAND2/schematic
subckt NAND2 A B Z
parameters gamma=2 beta=1
    NM1 (net12 B 0 0) n_12_llrvt l=60n w=2*gamma*80n nf=1 mis_flag=1 m=1 mf=1
    NM0 (Z A net12 0) n_12_llrvt l=60n w=2*gamma*80n nf=1 mis_flag=1 m=1 mf=1
    PM1 (Z B vdd! vdd!) p_12_llrvt l=60n w=gamma*beta*80n nf=1 mis_flag=1 m=1 mf=1
    PM0 (Z A vdd! vdd!) p_12_llrvt l=60n w=gamma*beta*80n nf=1 mis_flag=1 m=1 mf=1
ends NAND2

// project_4x/Post/schematic
subckt Post A\<1\> A\<0\> WL
    I1 (net7 WL) INV gamma=1 beta=2
    I0 (A\<0\> A\<1\> net7) NAND2 gamma=1 beta=2
ends Post

// project_pex/BitCellArray_Pex/schematic
subckt BitCellArray_Pex WL\<255\> WL\<254\> WL\<253\> WL\<252\> WL\<251\> WL\<250\> WL\<249\> WL\<248\> WL\<247\> WL\<246\> WL\<245\> WL\<244\> WL\<243\> WL\<242\> WL\<241\> WL\<240\> WL\<239\> WL\<238\> WL\<237\> WL\<236\> WL\<235\> WL\<234\> WL\<233\> WL\<232\> WL\<231\> WL\<230\> WL\<229\> WL\<228\> WL\<227\> WL\<226\> WL\<225\> WL\<224\> WL\<223\> WL\<222\> WL\<221\> WL\<220\> WL\<219\> WL\<218\> WL\<217\> WL\<216\> WL\<215\> WL\<214\> WL\<213\> WL\<212\> WL\<211\> WL\<210\> WL\<209\> WL\<208\> WL\<207\> WL\<206\> WL\<205\> WL\<204\> WL\<203\> WL\<202\> WL\<201\> WL\<200\> WL\<199\> WL\<198\> WL\<197\> WL\<196\> WL\<195\> WL\<194\> WL\<193\> WL\<192\> WL\<191\> WL\<190\> WL\<189\> WL\<188\> WL\<187\> WL\<186\> WL\<185\> WL\<184\> WL\<183\> WL\<182\> WL\<181\> WL\<180\> WL\<179\> WL\<178\> WL\<177\> WL\<176\> WL\<175\> WL\<174\> WL\<173\> WL\<172\> WL\<171\> WL\<170\> WL\<169\> WL\<168\> WL\<167\> WL\<166\> WL\<165\> WL\<164\> WL\<163\> WL\<162\> WL\<161\> WL\<160\> WL\<159\> WL\<158\> WL\<157\> WL\<156\> WL\<155\> WL\<154\> WL\<153\> WL\<152\> WL\<151\> WL\<150\> WL\<149\> WL\<148\> WL\<147\> WL\<146\> WL\<145\> WL\<144\> WL\<143\> WL\<142\> WL\<141\> WL\<140\> WL\<139\> WL\<138\> WL\<137\> WL\<136\> WL\<135\> WL\<134\> WL\<133\> WL\<132\> WL\<131\> WL\<130\> WL\<129\> WL\<128\> WL\<127\> WL\<126\> WL\<125\> WL\<124\> WL\<123\> WL\<122\> WL\<121\> WL\<120\> WL\<119\> WL\<118\> WL\<117\> WL\<116\> WL\<115\> WL\<114\> WL\<113\> WL\<112\> WL\<111\> WL\<110\> WL\<109\> WL\<108\> WL\<107\> WL\<106\> WL\<105\> WL\<104\> WL\<103\> WL\<102\> WL\<101\> WL\<100\> WL\<99\> WL\<98\> WL\<97\> WL\<96\> WL\<95\> WL\<94\> WL\<93\> WL\<92\> WL\<91\> WL\<90\> WL\<89\> WL\<88\> WL\<87\> WL\<86\> WL\<85\> WL\<84\> WL\<83\> WL\<82\> WL\<81\> WL\<80\> WL\<79\> WL\<78\> WL\<77\> WL\<76\> WL\<75\> WL\<74\> WL\<73\> WL\<72\> WL\<71\> WL\<70\> WL\<69\> WL\<68\> WL\<67\> WL\<66\> WL\<65\> WL\<64\> WL\<63\> WL\<62\> WL\<61\> WL\<60\> WL\<59\> WL\<58\> WL\<57\> WL\<56\> WL\<55\> WL\<54\> WL\<53\> WL\<52\> WL\<51\> WL\<50\> WL\<49\> WL\<48\> WL\<47\> WL\<46\> WL\<45\> WL\<44\> WL\<43\> WL\<42\> WL\<41\> WL\<40\> WL\<39\> WL\<38\> WL\<37\> WL\<36\> WL\<35\> WL\<34\> WL\<33\> WL\<32\> WL\<31\> WL\<30\> WL\<29\> WL\<28\> WL\<27\> WL\<26\> WL\<25\> WL\<24\> WL\<23\> WL\<22\> WL\<21\> WL\<20\> WL\<19\> WL\<18\> WL\<17\> WL\<16\> WL\<15\> WL\<14\> WL\<13\> WL\<12\> WL\<11\> WL\<10\> WL\<9\> WL\<8\> WL\<7\> WL\<6\> WL\<5\> WL\<4\> WL\<3\> WL\<2\> WL\<1\> WL\<0\>
    I0 (WL\<0\> WL\<1\> WL\<2\> WL\<3\> WL\<4\> WL\<5\> WL\<6\> WL\<7\> WL\<8\> WL\<9\> WL\<10\> WL\<11\> WL\<12\> WL\<13\> WL\<14\> WL\<15\> WL\<16\> WL\<17\> WL\<18\> WL\<19\> WL\<20\> WL\<21\> WL\<22\> WL\<23\> WL\<24\> WL\<25\> WL\<26\> WL\<27\> WL\<28\> WL\<29\> WL\<30\> WL\<31\> WL\<32\> WL\<33\> WL\<34\> WL\<35\> WL\<36\> WL\<37\> WL\<38\> WL\<39\> WL\<40\> WL\<41\> WL\<42\> WL\<43\> WL\<44\> WL\<45\> WL\<46\> WL\<47\> WL\<48\> WL\<49\> WL\<50\> WL\<51\> WL\<52\> WL\<53\> WL\<54\> WL\<55\> WL\<56\> WL\<57\> WL\<58\> WL\<59\> WL\<60\> WL\<61\> WL\<62\> WL\<63\> WL\<64\> WL\<65\> WL\<66\> WL\<67\> WL\<68\> WL\<69\> WL\<70\> WL\<71\> WL\<72\> WL\<73\> WL\<74\> WL\<75\> WL\<76\> WL\<77\> WL\<78\> WL\<79\> WL\<80\> WL\<81\> WL\<82\> WL\<83\> WL\<84\> WL\<85\> WL\<86\> WL\<87\> WL\<88\> WL\<89\> WL\<90\> WL\<91\> WL\<92\> WL\<93\> WL\<94\> WL\<95\> WL\<96\> WL\<97\> WL\<98\> WL\<99\> WL\<100\> WL\<101\> WL\<102\> WL\<103\> WL\<104\> WL\<105\> WL\<106\> WL\<107\> WL\<108\> WL\<109\> WL\<110\> WL\<111\> WL\<112\> WL\<113\> WL\<114\> WL\<115\> WL\<116\> WL\<117\> WL\<118\> WL\<119\> WL\<120\> WL\<121\> WL\<122\> WL\<123\> WL\<124\> WL\<125\> WL\<126\> WL\<127\> WL\<128\> WL\<129\> WL\<130\> WL\<131\> WL\<132\> WL\<133\> WL\<134\> WL\<135\> WL\<136\> WL\<137\> WL\<138\> WL\<139\> WL\<140\> WL\<141\> WL\<142\> WL\<143\> WL\<144\> WL\<145\> WL\<146\> WL\<147\> WL\<148\> WL\<149\> WL\<150\> WL\<151\> WL\<152\> WL\<153\> WL\<154\> WL\<155\> WL\<156\> WL\<157\> WL\<158\> WL\<159\> WL\<160\> WL\<161\> WL\<162\> WL\<163\> WL\<164\> WL\<165\> WL\<166\> WL\<167\> WL\<168\> WL\<169\> WL\<170\> WL\<171\> WL\<172\> WL\<173\> WL\<174\> WL\<175\> WL\<176\> WL\<177\> WL\<178\> WL\<179\> WL\<180\> WL\<181\> WL\<182\> WL\<183\> WL\<184\> WL\<185\> WL\<186\> WL\<187\> WL\<188\> WL\<189\> WL\<190\> WL\<191\> WL\<192\> WL\<193\> WL\<194\> WL\<195\> WL\<196\> WL\<197\> WL\<198\> WL\<199\> WL\<200\> WL\<201\> WL\<202\> WL\<203\> WL\<204\> WL\<205\> WL\<206\> WL\<207\> WL\<208\> WL\<209\> WL\<210\> WL\<211\> WL\<212\> WL\<213\> WL\<214\> WL\<215\> WL\<216\> WL\<217\> WL\<218\> WL\<219\> WL\<220\> WL\<221\> WL\<222\> WL\<223\> WL\<224\> WL\<225\> WL\<226\> WL\<227\> WL\<228\> WL\<229\> WL\<230\> WL\<231\> WL\<232\> WL\<233\> WL\<234\> WL\<235\> WL\<236\> WL\<237\> WL\<238\> WL\<239\> WL\<240\> WL\<241\> WL\<242\> WL\<243\> WL\<244\> WL\<245\> WL\<246\> WL\<247\> WL\<248\> WL\<249\> WL\<250\> WL\<251\> WL\<252\> WL\<253\> WL\<254\> WL\<255\> vdd! 0) BitCellArray_Text
ends BitCellArray_Pex

// project_common/NOR2/schematic
subckt NOR2 A B Z
parameters gamma=1 beta=2
    NM1 (Z B 0 0) n_12_llrvt l=60n w=gamma*80n nf=1 mis_flag=1 m=1 mf=1
    NM0 (Z A 0 0) n_12_llrvt l=60n w=gamma*80n nf=1 mis_flag=1 m=1 mf=1
    PM1 (Z B net07 vdd!) p_12_llrvt l=60n w=2*gamma*beta*80n nf=1 mis_flag=1 m=1 mf=1
    PM0 (net07 A vdd! vdd!) p_12_llrvt l=60n w=2*gamma*beta*80n nf=1 mis_flag=1 m=1 mf=1
ends NOR2

// project_4x/Pre/schematic
subckt Pre A\<3\> A\<2\> A\<1\> A\<0\> SelOUT
    I2 (net6 net7 SelOUT) NOR2 gamma=1 beta=2
    I1 (A\<1\> A\<0\> net7) NAND2 gamma=1 beta=2
    I0 (A\<3\> A\<2\> net6) NAND2 gamma=1 beta=2
ends Pre

// project_4x/Pre_L0_1t2/schematic
subckt Pre_L0_1t2 A\<3\> A\<2\> A\<1\> ADDR\<0\> ADDRb\<0\> AOut\<7\> AOut\<6\> AOut\<5\> AOut\<4\> AOut\<3\> AOut\<2\> AOut\<1\> AOut\<0\>
    I1\<7\> (A\<3\> AOut\<7\>) iprobe
    I1\<6\> (A\<2\> AOut\<6\>) iprobe
    I1\<5\> (A\<1\> AOut\<5\>) iprobe
    I1\<4\> (ADDR\<0\> AOut\<4\>) iprobe
    I1\<3\> (A\<3\> AOut\<3\>) iprobe
    I1\<2\> (A\<2\> AOut\<2\>) iprobe
    I1\<1\> (A\<1\> AOut\<1\>) iprobe
    I1\<0\> (ADDRb\<0\> AOut\<0\>) iprobe
ends Pre_L0_1t2

// project_4x/Pre_L1_2t4/schematic
subckt Pre_L1_2t4 A\<3\> A\<2\> ADDR\<1\> ADDR\<0\> ADDRb\<1\> ADDRb\<0\> AOut\<15\> AOut\<14\> AOut\<13\> AOut\<12\> AOut\<11\> AOut\<10\> AOut\<9\> AOut\<8\> AOut\<7\> AOut\<6\> AOut\<5\> AOut\<4\> AOut\<3\> AOut\<2\> AOut\<1\> AOut\<0\>
    I5 (A\<3\> A\<2\> ADDRb\<1\> ADDR\<0\> ADDRb\<0\> AOut\<7\> AOut\<6\> AOut\<5\> AOut\<4\> AOut\<3\> AOut\<2\> AOut\<1\> AOut\<0\>) Pre_L0_1t2
    I4 (A\<3\> A\<2\> ADDR\<1\> ADDR\<0\> ADDRb\<0\> AOut\<15\> AOut\<14\> AOut\<13\> AOut\<12\> AOut\<11\> AOut\<10\> AOut\<9\> AOut\<8\>) Pre_L0_1t2
ends Pre_L1_2t4

// project_4x/Pre_L2_3t8/schematic
subckt Pre_L2_3t8 A\<3\> ADDR\<2\> ADDR\<1\> ADDR\<0\> ADDRb\<2\> ADDRb\<1\> ADDRb\<0\> AOut\<31\> AOut\<30\> AOut\<29\> AOut\<28\> AOut\<27\> AOut\<26\> AOut\<25\> AOut\<24\> AOut\<23\> AOut\<22\> AOut\<21\> AOut\<20\> AOut\<19\> AOut\<18\> AOut\<17\> AOut\<16\> AOut\<15\> AOut\<14\> AOut\<13\> AOut\<12\> AOut\<11\> AOut\<10\> AOut\<9\> AOut\<8\> AOut\<7\> AOut\<6\> AOut\<5\> AOut\<4\> AOut\<3\> AOut\<2\> AOut\<1\> AOut\<0\>
    I3 (A\<3\> ADDRb\<2\> ADDR\<1\> ADDR\<0\> ADDRb\<1\> ADDRb\<0\> AOut\<15\> AOut\<14\> AOut\<13\> AOut\<12\> AOut\<11\> AOut\<10\> AOut\<9\> AOut\<8\> AOut\<7\> AOut\<6\> AOut\<5\> AOut\<4\> AOut\<3\> AOut\<2\> AOut\<1\> AOut\<0\>) Pre_L1_2t4
    I2 (A\<3\> ADDR\<2\> ADDR\<1\> ADDR\<0\> ADDRb\<1\> ADDRb\<0\> AOut\<31\> AOut\<30\> AOut\<29\> AOut\<28\> AOut\<27\> AOut\<26\> AOut\<25\> AOut\<24\> AOut\<23\> AOut\<22\> AOut\<21\> AOut\<20\> AOut\<19\> AOut\<18\> AOut\<17\> AOut\<16\>) Pre_L1_2t4
ends Pre_L2_3t8

// project_4x/Pre_L3_4t16_NAND/schematic
subckt Pre_L3_4t16_NAND ADDR\<3\> ADDR\<2\> ADDR\<1\> ADDR\<0\> ADDRb\<3\> ADDRb\<2\> ADDRb\<1\> ADDRb\<0\> AOut\<63\> AOut\<62\> AOut\<61\> AOut\<60\> AOut\<59\> AOut\<58\> AOut\<57\> AOut\<56\> AOut\<55\> AOut\<54\> AOut\<53\> AOut\<52\> AOut\<51\> AOut\<50\> AOut\<49\> AOut\<48\> AOut\<47\> AOut\<46\> AOut\<45\> AOut\<44\> AOut\<43\> AOut\<42\> AOut\<41\> AOut\<40\> AOut\<39\> AOut\<38\> AOut\<37\> AOut\<36\> AOut\<35\> AOut\<34\> AOut\<33\> AOut\<32\> AOut\<31\> AOut\<30\> AOut\<29\> AOut\<28\> AOut\<27\> AOut\<26\> AOut\<25\> AOut\<24\> AOut\<23\> AOut\<22\> AOut\<21\> AOut\<20\> AOut\<19\> AOut\<18\> AOut\<17\> AOut\<16\> AOut\<15\> AOut\<14\> AOut\<13\> AOut\<12\> AOut\<11\> AOut\<10\> AOut\<9\> AOut\<8\> AOut\<7\> AOut\<6\> AOut\<5\> AOut\<4\> AOut\<3\> AOut\<2\> AOut\<1\> AOut\<0\>
    I1 (ADDRb\<3\> ADDR\<2\> ADDR\<1\> ADDR\<0\> ADDRb\<2\> ADDRb\<1\> ADDRb\<0\> AOut\<31\> AOut\<30\> AOut\<29\> AOut\<28\> AOut\<27\> AOut\<26\> AOut\<25\> AOut\<24\> AOut\<23\> AOut\<22\> AOut\<21\> AOut\<20\> AOut\<19\> AOut\<18\> AOut\<17\> AOut\<16\> AOut\<15\> AOut\<14\> AOut\<13\> AOut\<12\> AOut\<11\> AOut\<10\> AOut\<9\> AOut\<8\> AOut\<7\> AOut\<6\> AOut\<5\> AOut\<4\> AOut\<3\> AOut\<2\> AOut\<1\> AOut\<0\>) Pre_L2_3t8
    I0 (ADDR\<3\> ADDR\<2\> ADDR\<1\> ADDR\<0\> ADDRb\<2\> ADDRb\<1\> ADDRb\<0\> AOut\<63\> AOut\<62\> AOut\<61\> AOut\<60\> AOut\<59\> AOut\<58\> AOut\<57\> AOut\<56\> AOut\<55\> AOut\<54\> AOut\<53\> AOut\<52\> AOut\<51\> AOut\<50\> AOut\<49\> AOut\<48\> AOut\<47\> AOut\<46\> AOut\<45\> AOut\<44\> AOut\<43\> AOut\<42\> AOut\<41\> AOut\<40\> AOut\<39\> AOut\<38\> AOut\<37\> AOut\<36\> AOut\<35\> AOut\<34\> AOut\<33\> AOut\<32\>) Pre_L2_3t8
ends Pre_L3_4t16_NAND

// project_common/BUF/schematic
subckt BUF A Z
parameters gamma beta
    I1 (net5 Z) INV gamma=gamma beta=beta
    I0 (A net5) INV gamma=gamma beta=beta
ends BUF

// project_4x/AddrBuf/schematic
subckt AddrBuf A Z
    I3 (A Z) BUF gamma=1 beta=2
ends AddrBuf

// project_pex/Post_L2_256t2_Pex/schematic
subckt Post_L2_256t2_Pex SEL0\<15\> SEL0\<14\> SEL0\<13\> SEL0\<12\> SEL0\<11\> SEL0\<10\> SEL0\<9\> SEL0\<8\> SEL0\<7\> SEL0\<6\> SEL0\<5\> SEL0\<4\> SEL0\<3\> SEL0\<2\> SEL0\<1\> SEL0\<0\> SEL1\<15\> SEL1\<14\> SEL1\<13\> SEL1\<12\> SEL1\<11\> SEL1\<10\> SEL1\<9\> SEL1\<8\> SEL1\<7\> SEL1\<6\> SEL1\<5\> SEL1\<4\> SEL1\<3\> SEL1\<2\> SEL1\<1\> SEL1\<0\> WLSEL\<511\> WLSEL\<510\> WLSEL\<509\> WLSEL\<508\> WLSEL\<507\> WLSEL\<506\> WLSEL\<505\> WLSEL\<504\> WLSEL\<503\> WLSEL\<502\> WLSEL\<501\> WLSEL\<500\> WLSEL\<499\> WLSEL\<498\> WLSEL\<497\> WLSEL\<496\> WLSEL\<495\> WLSEL\<494\> WLSEL\<493\> WLSEL\<492\> WLSEL\<491\> WLSEL\<490\> WLSEL\<489\> WLSEL\<488\> WLSEL\<487\> WLSEL\<486\> WLSEL\<485\> WLSEL\<484\> WLSEL\<483\> WLSEL\<482\> WLSEL\<481\> WLSEL\<480\> WLSEL\<479\> WLSEL\<478\> WLSEL\<477\> WLSEL\<476\> WLSEL\<475\> WLSEL\<474\> WLSEL\<473\> WLSEL\<472\> WLSEL\<471\> WLSEL\<470\> WLSEL\<469\> WLSEL\<468\> WLSEL\<467\> WLSEL\<466\> WLSEL\<465\> WLSEL\<464\> WLSEL\<463\> WLSEL\<462\> WLSEL\<461\> WLSEL\<460\> WLSEL\<459\> WLSEL\<458\> WLSEL\<457\> WLSEL\<456\> WLSEL\<455\> WLSEL\<454\> WLSEL\<453\> WLSEL\<452\> WLSEL\<451\> WLSEL\<450\> WLSEL\<449\> WLSEL\<448\> WLSEL\<447\> WLSEL\<446\> WLSEL\<445\> WLSEL\<444\> WLSEL\<443\> WLSEL\<442\> WLSEL\<441\> WLSEL\<440\> WLSEL\<439\> WLSEL\<438\> WLSEL\<437\> WLSEL\<436\> WLSEL\<435\> WLSEL\<434\> WLSEL\<433\> WLSEL\<432\> WLSEL\<431\> WLSEL\<430\> WLSEL\<429\> WLSEL\<428\> WLSEL\<427\> WLSEL\<426\> WLSEL\<425\> WLSEL\<424\> WLSEL\<423\> WLSEL\<422\> WLSEL\<421\> WLSEL\<420\> WLSEL\<419\> WLSEL\<418\> WLSEL\<417\> WLSEL\<416\> WLSEL\<415\> WLSEL\<414\> WLSEL\<413\> WLSEL\<412\> WLSEL\<411\> WLSEL\<410\> WLSEL\<409\> WLSEL\<408\> WLSEL\<407\> WLSEL\<406\> WLSEL\<405\> WLSEL\<404\> WLSEL\<403\> WLSEL\<402\> WLSEL\<401\> WLSEL\<400\> WLSEL\<399\> WLSEL\<398\> WLSEL\<397\> WLSEL\<396\> WLSEL\<395\> WLSEL\<394\> WLSEL\<393\> WLSEL\<392\> WLSEL\<391\> WLSEL\<390\> WLSEL\<389\> WLSEL\<388\> WLSEL\<387\> WLSEL\<386\> WLSEL\<385\> WLSEL\<384\> WLSEL\<383\> WLSEL\<382\> WLSEL\<381\> WLSEL\<380\> WLSEL\<379\> WLSEL\<378\> WLSEL\<377\> WLSEL\<376\> WLSEL\<375\> WLSEL\<374\> WLSEL\<373\> WLSEL\<372\> WLSEL\<371\> WLSEL\<370\> WLSEL\<369\> WLSEL\<368\> WLSEL\<367\> WLSEL\<366\> WLSEL\<365\> WLSEL\<364\> WLSEL\<363\> WLSEL\<362\> WLSEL\<361\> WLSEL\<360\> WLSEL\<359\> WLSEL\<358\> WLSEL\<357\> WLSEL\<356\> WLSEL\<355\> WLSEL\<354\> WLSEL\<353\> WLSEL\<352\> WLSEL\<351\> WLSEL\<350\> WLSEL\<349\> WLSEL\<348\> WLSEL\<347\> WLSEL\<346\> WLSEL\<345\> WLSEL\<344\> WLSEL\<343\> WLSEL\<342\> WLSEL\<341\> WLSEL\<340\> WLSEL\<339\> WLSEL\<338\> WLSEL\<337\> WLSEL\<336\> WLSEL\<335\> WLSEL\<334\> WLSEL\<333\> WLSEL\<332\> WLSEL\<331\> WLSEL\<330\> WLSEL\<329\> WLSEL\<328\> WLSEL\<327\> WLSEL\<326\> WLSEL\<325\> WLSEL\<324\> WLSEL\<323\> WLSEL\<322\> WLSEL\<321\> WLSEL\<320\> WLSEL\<319\> WLSEL\<318\> WLSEL\<317\> WLSEL\<316\> WLSEL\<315\> WLSEL\<314\> WLSEL\<313\> WLSEL\<312\> WLSEL\<311\> WLSEL\<310\> WLSEL\<309\> WLSEL\<308\> WLSEL\<307\> WLSEL\<306\> WLSEL\<305\> WLSEL\<304\> WLSEL\<303\> WLSEL\<302\> WLSEL\<301\> WLSEL\<300\> WLSEL\<299\> WLSEL\<298\> WLSEL\<297\> WLSEL\<296\> WLSEL\<295\> WLSEL\<294\> WLSEL\<293\> WLSEL\<292\> WLSEL\<291\> WLSEL\<290\> WLSEL\<289\> WLSEL\<288\> WLSEL\<287\> WLSEL\<286\> WLSEL\<285\> WLSEL\<284\> WLSEL\<283\> WLSEL\<282\> WLSEL\<281\> WLSEL\<280\> WLSEL\<279\> WLSEL\<278\> WLSEL\<277\> WLSEL\<276\> WLSEL\<275\> WLSEL\<274\> WLSEL\<273\> WLSEL\<272\> WLSEL\<271\> WLSEL\<270\> WLSEL\<269\> WLSEL\<268\> WLSEL\<267\> WLSEL\<266\> WLSEL\<265\> WLSEL\<264\> WLSEL\<263\> WLSEL\<262\> WLSEL\<261\> WLSEL\<260\> WLSEL\<259\> WLSEL\<258\> WLSEL\<257\> WLSEL\<256\> WLSEL\<255\> WLSEL\<254\> WLSEL\<253\> WLSEL\<252\> WLSEL\<251\> WLSEL\<250\> WLSEL\<249\> WLSEL\<248\> WLSEL\<247\> WLSEL\<246\> WLSEL\<245\> WLSEL\<244\> WLSEL\<243\> WLSEL\<242\> WLSEL\<241\> WLSEL\<240\> WLSEL\<239\> WLSEL\<238\> WLSEL\<237\> WLSEL\<236\> WLSEL\<235\> WLSEL\<234\> WLSEL\<233\> WLSEL\<232\> WLSEL\<231\> WLSEL\<230\> WLSEL\<229\> WLSEL\<228\> WLSEL\<227\> WLSEL\<226\> WLSEL\<225\> WLSEL\<224\> WLSEL\<223\> WLSEL\<222\> WLSEL\<221\> WLSEL\<220\> WLSEL\<219\> WLSEL\<218\> WLSEL\<217\> WLSEL\<216\> WLSEL\<215\> WLSEL\<214\> WLSEL\<213\> WLSEL\<212\> WLSEL\<211\> WLSEL\<210\> WLSEL\<209\> WLSEL\<208\> WLSEL\<207\> WLSEL\<206\> WLSEL\<205\> WLSEL\<204\> WLSEL\<203\> WLSEL\<202\> WLSEL\<201\> WLSEL\<200\> WLSEL\<199\> WLSEL\<198\> WLSEL\<197\> WLSEL\<196\> WLSEL\<195\> WLSEL\<194\> WLSEL\<193\> WLSEL\<192\> WLSEL\<191\> WLSEL\<190\> WLSEL\<189\> WLSEL\<188\> WLSEL\<187\> WLSEL\<186\> WLSEL\<185\> WLSEL\<184\> WLSEL\<183\> WLSEL\<182\> WLSEL\<181\> WLSEL\<180\> WLSEL\<179\> WLSEL\<178\> WLSEL\<177\> WLSEL\<176\> WLSEL\<175\> WLSEL\<174\> WLSEL\<173\> WLSEL\<172\> WLSEL\<171\> WLSEL\<170\> WLSEL\<169\> WLSEL\<168\> WLSEL\<167\> WLSEL\<166\> WLSEL\<165\> WLSEL\<164\> WLSEL\<163\> WLSEL\<162\> WLSEL\<161\> WLSEL\<160\> WLSEL\<159\> WLSEL\<158\> WLSEL\<157\> WLSEL\<156\> WLSEL\<155\> WLSEL\<154\> WLSEL\<153\> WLSEL\<152\> WLSEL\<151\> WLSEL\<150\> WLSEL\<149\> WLSEL\<148\> WLSEL\<147\> WLSEL\<146\> WLSEL\<145\> WLSEL\<144\> WLSEL\<143\> WLSEL\<142\> WLSEL\<141\> WLSEL\<140\> WLSEL\<139\> WLSEL\<138\> WLSEL\<137\> WLSEL\<136\> WLSEL\<135\> WLSEL\<134\> WLSEL\<133\> WLSEL\<132\> WLSEL\<131\> WLSEL\<130\> WLSEL\<129\> WLSEL\<128\> WLSEL\<127\> WLSEL\<126\> WLSEL\<125\> WLSEL\<124\> WLSEL\<123\> WLSEL\<122\> WLSEL\<121\> WLSEL\<120\> WLSEL\<119\> WLSEL\<118\> WLSEL\<117\> WLSEL\<116\> WLSEL\<115\> WLSEL\<114\> WLSEL\<113\> WLSEL\<112\> WLSEL\<111\> WLSEL\<110\> WLSEL\<109\> WLSEL\<108\> WLSEL\<107\> WLSEL\<106\> WLSEL\<105\> WLSEL\<104\> WLSEL\<103\> WLSEL\<102\> WLSEL\<101\> WLSEL\<100\> WLSEL\<99\> WLSEL\<98\> WLSEL\<97\> WLSEL\<96\> WLSEL\<95\> WLSEL\<94\> WLSEL\<93\> WLSEL\<92\> WLSEL\<91\> WLSEL\<90\> WLSEL\<89\> WLSEL\<88\> WLSEL\<87\> WLSEL\<86\> WLSEL\<85\> WLSEL\<84\> WLSEL\<83\> WLSEL\<82\> WLSEL\<81\> WLSEL\<80\> WLSEL\<79\> WLSEL\<78\> WLSEL\<77\> WLSEL\<76\> WLSEL\<75\> WLSEL\<74\> WLSEL\<73\> WLSEL\<72\> WLSEL\<71\> WLSEL\<70\> WLSEL\<69\> WLSEL\<68\> WLSEL\<67\> WLSEL\<66\> WLSEL\<65\> WLSEL\<64\> WLSEL\<63\> WLSEL\<62\> WLSEL\<61\> WLSEL\<60\> WLSEL\<59\> WLSEL\<58\> WLSEL\<57\> WLSEL\<56\> WLSEL\<55\> WLSEL\<54\> WLSEL\<53\> WLSEL\<52\> WLSEL\<51\> WLSEL\<50\> WLSEL\<49\> WLSEL\<48\> WLSEL\<47\> WLSEL\<46\> WLSEL\<45\> WLSEL\<44\> WLSEL\<43\> WLSEL\<42\> WLSEL\<41\> WLSEL\<40\> WLSEL\<39\> WLSEL\<38\> WLSEL\<37\> WLSEL\<36\> WLSEL\<35\> WLSEL\<34\> WLSEL\<33\> WLSEL\<32\> WLSEL\<31\> WLSEL\<30\> WLSEL\<29\> WLSEL\<28\> WLSEL\<27\> WLSEL\<26\> WLSEL\<25\> WLSEL\<24\> WLSEL\<23\> WLSEL\<22\> WLSEL\<21\> WLSEL\<20\> WLSEL\<19\> WLSEL\<18\> WLSEL\<17\> WLSEL\<16\> WLSEL\<15\> WLSEL\<14\> WLSEL\<13\> WLSEL\<12\> WLSEL\<11\> WLSEL\<10\> WLSEL\<9\> WLSEL\<8\> WLSEL\<7\> WLSEL\<6\> WLSEL\<5\> WLSEL\<4\> WLSEL\<3\> WLSEL\<2\> WLSEL\<1\> WLSEL\<0\>
    I0 (SEL1\<15\> WLSEL\<511\> SEL0\<15\> WLSEL\<510\> WLSEL\<509\> SEL0\<14\> WLSEL\<508\> WLSEL\<507\> SEL0\<13\> WLSEL\<506\> WLSEL\<505\> SEL0\<12\> WLSEL\<504\> WLSEL\<503\> SEL0\<11\> WLSEL\<502\> WLSEL\<501\> SEL0\<10\> WLSEL\<500\> WLSEL\<499\> SEL0\<9\> WLSEL\<498\> WLSEL\<497\> SEL0\<8\> WLSEL\<496\> WLSEL\<495\> SEL0\<7\> WLSEL\<494\> WLSEL\<493\> SEL0\<6\> WLSEL\<492\> WLSEL\<491\> SEL0\<5\> WLSEL\<490\> WLSEL\<489\> SEL0\<4\> WLSEL\<488\> WLSEL\<487\> SEL0\<3\> WLSEL\<486\> WLSEL\<485\> SEL0\<2\> WLSEL\<484\> WLSEL\<483\> SEL0\<1\> WLSEL\<482\> WLSEL\<481\> SEL0\<0\> WLSEL\<480\> SEL1\<14\> WLSEL\<479\> WLSEL\<478\> WLSEL\<477\> WLSEL\<476\> WLSEL\<475\> WLSEL\<474\> WLSEL\<473\> WLSEL\<472\> WLSEL\<471\> WLSEL\<470\> WLSEL\<469\> WLSEL\<468\> WLSEL\<467\> WLSEL\<466\> WLSEL\<465\> WLSEL\<464\> WLSEL\<463\> WLSEL\<462\> WLSEL\<461\> WLSEL\<460\> WLSEL\<459\> WLSEL\<458\> WLSEL\<457\> WLSEL\<456\> WLSEL\<455\> WLSEL\<454\> WLSEL\<453\> WLSEL\<452\> WLSEL\<451\> WLSEL\<450\> WLSEL\<449\> WLSEL\<448\> SEL1\<13\> WLSEL\<447\> WLSEL\<446\> WLSEL\<445\> WLSEL\<444\> WLSEL\<443\> WLSEL\<442\> WLSEL\<441\> WLSEL\<440\> WLSEL\<439\> WLSEL\<438\> WLSEL\<437\> WLSEL\<436\> WLSEL\<435\> WLSEL\<434\> WLSEL\<433\> WLSEL\<432\> WLSEL\<431\> WLSEL\<430\> WLSEL\<429\> WLSEL\<428\> WLSEL\<427\> WLSEL\<426\> WLSEL\<425\> WLSEL\<424\> WLSEL\<423\> WLSEL\<422\> WLSEL\<421\> WLSEL\<420\> WLSEL\<419\> WLSEL\<418\> WLSEL\<417\> WLSEL\<416\> SEL1\<12\> WLSEL\<415\> WLSEL\<414\> WLSEL\<413\> WLSEL\<412\> WLSEL\<411\> WLSEL\<410\> WLSEL\<409\> WLSEL\<408\> WLSEL\<407\> WLSEL\<406\> WLSEL\<405\> WLSEL\<404\> WLSEL\<403\> WLSEL\<402\> WLSEL\<401\> WLSEL\<400\> WLSEL\<399\> WLSEL\<398\> WLSEL\<397\> WLSEL\<396\> WLSEL\<395\> WLSEL\<394\> WLSEL\<393\> WLSEL\<392\> WLSEL\<391\> WLSEL\<390\> WLSEL\<389\> WLSEL\<388\> WLSEL\<387\> WLSEL\<386\> WLSEL\<385\> WLSEL\<384\> SEL1\<11\> WLSEL\<383\> WLSEL\<382\> WLSEL\<381\> WLSEL\<380\> WLSEL\<379\> WLSEL\<378\> WLSEL\<377\> WLSEL\<376\> WLSEL\<375\> WLSEL\<374\> WLSEL\<373\> WLSEL\<372\> WLSEL\<371\> WLSEL\<370\> WLSEL\<369\> WLSEL\<368\> WLSEL\<367\> WLSEL\<366\> WLSEL\<365\> WLSEL\<364\> WLSEL\<363\> WLSEL\<362\> WLSEL\<361\> WLSEL\<360\> WLSEL\<359\> WLSEL\<358\> WLSEL\<357\> WLSEL\<356\> WLSEL\<355\> WLSEL\<354\> WLSEL\<353\> WLSEL\<352\> SEL1\<10\> WLSEL\<351\> WLSEL\<350\> WLSEL\<349\> WLSEL\<348\> WLSEL\<347\> WLSEL\<346\> WLSEL\<345\> WLSEL\<344\> WLSEL\<343\> WLSEL\<342\> WLSEL\<341\> WLSEL\<340\> WLSEL\<339\> WLSEL\<338\> WLSEL\<337\> WLSEL\<336\> WLSEL\<335\> WLSEL\<334\> WLSEL\<333\> WLSEL\<332\> WLSEL\<331\> WLSEL\<330\> WLSEL\<329\> WLSEL\<328\> WLSEL\<327\> WLSEL\<326\> WLSEL\<325\> WLSEL\<324\> WLSEL\<323\> WLSEL\<322\> WLSEL\<321\> WLSEL\<320\> SEL1\<9\> WLSEL\<319\> WLSEL\<318\> WLSEL\<317\> WLSEL\<316\> WLSEL\<315\> WLSEL\<314\> WLSEL\<313\> WLSEL\<312\> WLSEL\<311\> WLSEL\<310\> WLSEL\<309\> WLSEL\<308\> WLSEL\<307\> WLSEL\<306\> WLSEL\<305\> WLSEL\<304\> WLSEL\<303\> WLSEL\<302\> WLSEL\<301\> WLSEL\<300\> WLSEL\<299\> WLSEL\<298\> WLSEL\<297\> WLSEL\<296\> WLSEL\<295\> WLSEL\<294\> WLSEL\<293\> WLSEL\<292\> WLSEL\<291\> WLSEL\<290\> WLSEL\<289\> WLSEL\<288\> SEL1\<8\> WLSEL\<287\> WLSEL\<286\> WLSEL\<285\> WLSEL\<284\> WLSEL\<283\> WLSEL\<282\> WLSEL\<281\> WLSEL\<280\> WLSEL\<279\> WLSEL\<278\> WLSEL\<277\> WLSEL\<276\> WLSEL\<275\> WLSEL\<274\> WLSEL\<273\> WLSEL\<272\> WLSEL\<271\> WLSEL\<270\> WLSEL\<269\> WLSEL\<268\> WLSEL\<267\> WLSEL\<266\> WLSEL\<265\> WLSEL\<264\> WLSEL\<263\> WLSEL\<262\> WLSEL\<261\> WLSEL\<260\> WLSEL\<259\> WLSEL\<258\> WLSEL\<257\> WLSEL\<256\> SEL1\<7\> WLSEL\<255\> WLSEL\<254\> WLSEL\<253\> WLSEL\<252\> WLSEL\<251\> WLSEL\<250\> WLSEL\<249\> WLSEL\<248\> WLSEL\<247\> WLSEL\<246\> WLSEL\<245\> WLSEL\<244\> WLSEL\<243\> WLSEL\<242\> WLSEL\<241\> WLSEL\<240\> WLSEL\<239\> WLSEL\<238\> WLSEL\<237\> WLSEL\<236\> WLSEL\<235\> WLSEL\<234\> WLSEL\<233\> WLSEL\<232\> WLSEL\<231\> WLSEL\<230\> WLSEL\<229\> WLSEL\<228\> WLSEL\<227\> WLSEL\<226\> WLSEL\<225\> WLSEL\<224\> SEL1\<6\> WLSEL\<223\> WLSEL\<222\> WLSEL\<221\> WLSEL\<220\> WLSEL\<219\> WLSEL\<218\> WLSEL\<217\> WLSEL\<216\> WLSEL\<215\> WLSEL\<214\> WLSEL\<213\> WLSEL\<212\> WLSEL\<211\> WLSEL\<210\> WLSEL\<209\> WLSEL\<208\> WLSEL\<207\> WLSEL\<206\> WLSEL\<205\> WLSEL\<204\> WLSEL\<203\> WLSEL\<202\> WLSEL\<201\> WLSEL\<200\> WLSEL\<199\> WLSEL\<198\> WLSEL\<197\> WLSEL\<196\> WLSEL\<195\> WLSEL\<194\> WLSEL\<193\> WLSEL\<192\> SEL1\<5\> WLSEL\<191\> WLSEL\<190\> WLSEL\<189\> WLSEL\<188\> WLSEL\<187\> WLSEL\<186\> WLSEL\<185\> WLSEL\<184\> WLSEL\<183\> WLSEL\<182\> WLSEL\<181\> WLSEL\<180\> WLSEL\<179\> WLSEL\<178\> WLSEL\<177\> WLSEL\<176\> WLSEL\<175\> WLSEL\<174\> WLSEL\<173\> WLSEL\<172\> WLSEL\<171\> WLSEL\<170\> WLSEL\<169\> WLSEL\<168\> WLSEL\<167\> WLSEL\<166\> WLSEL\<165\> WLSEL\<164\> WLSEL\<163\> WLSEL\<162\> WLSEL\<161\> WLSEL\<160\> SEL1\<4\> WLSEL\<159\> WLSEL\<158\> WLSEL\<157\> WLSEL\<156\> WLSEL\<155\> WLSEL\<154\> WLSEL\<153\> WLSEL\<152\> WLSEL\<151\> WLSEL\<150\> WLSEL\<149\> WLSEL\<148\> WLSEL\<147\> WLSEL\<146\> WLSEL\<145\> WLSEL\<144\> WLSEL\<143\> WLSEL\<142\> WLSEL\<141\> WLSEL\<140\> WLSEL\<139\> WLSEL\<138\> WLSEL\<137\> WLSEL\<136\> WLSEL\<135\> WLSEL\<134\> WLSEL\<133\> WLSEL\<132\> WLSEL\<131\> WLSEL\<130\> WLSEL\<129\> WLSEL\<128\> SEL1\<3\> WLSEL\<127\> WLSEL\<126\> WLSEL\<125\> WLSEL\<124\> WLSEL\<123\> WLSEL\<122\> WLSEL\<121\> WLSEL\<120\> WLSEL\<119\> WLSEL\<118\> WLSEL\<117\> WLSEL\<116\> WLSEL\<115\> WLSEL\<114\> WLSEL\<113\> WLSEL\<112\> WLSEL\<111\> WLSEL\<110\> WLSEL\<109\> WLSEL\<108\> WLSEL\<107\> WLSEL\<106\> WLSEL\<105\> WLSEL\<104\> WLSEL\<103\> WLSEL\<102\> WLSEL\<101\> WLSEL\<100\> WLSEL\<99\> WLSEL\<98\> WLSEL\<97\> WLSEL\<96\> SEL1\<2\> WLSEL\<95\> WLSEL\<94\> WLSEL\<93\> WLSEL\<92\> WLSEL\<91\> WLSEL\<90\> WLSEL\<89\> WLSEL\<88\> WLSEL\<87\> WLSEL\<86\> WLSEL\<85\> WLSEL\<84\> WLSEL\<83\> WLSEL\<82\> WLSEL\<81\> WLSEL\<80\> WLSEL\<79\> WLSEL\<78\> WLSEL\<77\> WLSEL\<76\> WLSEL\<75\> WLSEL\<74\> WLSEL\<73\> WLSEL\<72\> WLSEL\<71\> WLSEL\<70\> WLSEL\<69\> WLSEL\<68\> WLSEL\<67\> WLSEL\<66\> WLSEL\<65\> WLSEL\<64\> SEL1\<1\> WLSEL\<63\> WLSEL\<62\> WLSEL\<61\> WLSEL\<60\> WLSEL\<59\> WLSEL\<58\> WLSEL\<57\> WLSEL\<56\> WLSEL\<55\> WLSEL\<54\> WLSEL\<53\> WLSEL\<52\> WLSEL\<51\> WLSEL\<50\> WLSEL\<49\> WLSEL\<48\> WLSEL\<47\> WLSEL\<46\> WLSEL\<45\> WLSEL\<44\> WLSEL\<43\> WLSEL\<42\> WLSEL\<41\> WLSEL\<40\> WLSEL\<39\> WLSEL\<38\> WLSEL\<37\> WLSEL\<36\> WLSEL\<35\> WLSEL\<34\> WLSEL\<33\> WLSEL\<32\> SEL1\<0\> WLSEL\<31\> WLSEL\<30\> WLSEL\<29\> WLSEL\<28\> WLSEL\<27\> WLSEL\<26\> WLSEL\<25\> WLSEL\<24\> WLSEL\<23\> WLSEL\<22\> WLSEL\<21\> WLSEL\<20\> WLSEL\<19\> WLSEL\<18\> WLSEL\<17\> WLSEL\<16\> WLSEL\<15\> WLSEL\<14\> WLSEL\<13\> WLSEL\<12\> WLSEL\<11\> WLSEL\<10\> WLSEL\<9\> WLSEL\<8\> WLSEL\<7\> WLSEL\<6\> WLSEL\<5\> WLSEL\<4\> WLSEL\<3\> WLSEL\<2\> WLSEL\<1\> WLSEL\<0\>) Post_L2_256t2_Text
ends Post_L2_256t2_Pex

// project_4x/RowDecoder_256_4xP/schematic
subckt RowDecoder_256_4xP ADDR\<7\> ADDR\<6\> ADDR\<5\> ADDR\<4\> ADDR\<3\> ADDR\<2\> ADDR\<1\> ADDR\<0\> WL\<255\> WL\<254\> WL\<253\> WL\<252\> WL\<251\> WL\<250\> WL\<249\> WL\<248\> WL\<247\> WL\<246\> WL\<245\> WL\<244\> WL\<243\> WL\<242\> WL\<241\> WL\<240\> WL\<239\> WL\<238\> WL\<237\> WL\<236\> WL\<235\> WL\<234\> WL\<233\> WL\<232\> WL\<231\> WL\<230\> WL\<229\> WL\<228\> WL\<227\> WL\<226\> WL\<225\> WL\<224\> WL\<223\> WL\<222\> WL\<221\> WL\<220\> WL\<219\> WL\<218\> WL\<217\> WL\<216\> WL\<215\> WL\<214\> WL\<213\> WL\<212\> WL\<211\> WL\<210\> WL\<209\> WL\<208\> WL\<207\> WL\<206\> WL\<205\> WL\<204\> WL\<203\> WL\<202\> WL\<201\> WL\<200\> WL\<199\> WL\<198\> WL\<197\> WL\<196\> WL\<195\> WL\<194\> WL\<193\> WL\<192\> WL\<191\> WL\<190\> WL\<189\> WL\<188\> WL\<187\> WL\<186\> WL\<185\> WL\<184\> WL\<183\> WL\<182\> WL\<181\> WL\<180\> WL\<179\> WL\<178\> WL\<177\> WL\<176\> WL\<175\> WL\<174\> WL\<173\> WL\<172\> WL\<171\> WL\<170\> WL\<169\> WL\<168\> WL\<167\> WL\<166\> WL\<165\> WL\<164\> WL\<163\> WL\<162\> WL\<161\> WL\<160\> WL\<159\> WL\<158\> WL\<157\> WL\<156\> WL\<155\> WL\<154\> WL\<153\> WL\<152\> WL\<151\> WL\<150\> WL\<149\> WL\<148\> WL\<147\> WL\<146\> WL\<145\> WL\<144\> WL\<143\> WL\<142\> WL\<141\> WL\<140\> WL\<139\> WL\<138\> WL\<137\> WL\<136\> WL\<135\> WL\<134\> WL\<133\> WL\<132\> WL\<131\> WL\<130\> WL\<129\> WL\<128\> WL\<127\> WL\<126\> WL\<125\> WL\<124\> WL\<123\> WL\<122\> WL\<121\> WL\<120\> WL\<119\> WL\<118\> WL\<117\> WL\<116\> WL\<115\> WL\<114\> WL\<113\> WL\<112\> WL\<111\> WL\<110\> WL\<109\> WL\<108\> WL\<107\> WL\<106\> WL\<105\> WL\<104\> WL\<103\> WL\<102\> WL\<101\> WL\<100\> WL\<99\> WL\<98\> WL\<97\> WL\<96\> WL\<95\> WL\<94\> WL\<93\> WL\<92\> WL\<91\> WL\<90\> WL\<89\> WL\<88\> WL\<87\> WL\<86\> WL\<85\> WL\<84\> WL\<83\> WL\<82\> WL\<81\> WL\<80\> WL\<79\> WL\<78\> WL\<77\> WL\<76\> WL\<75\> WL\<74\> WL\<73\> WL\<72\> WL\<71\> WL\<70\> WL\<69\> WL\<68\> WL\<67\> WL\<66\> WL\<65\> WL\<64\> WL\<63\> WL\<62\> WL\<61\> WL\<60\> WL\<59\> WL\<58\> WL\<57\> WL\<56\> WL\<55\> WL\<54\> WL\<53\> WL\<52\> WL\<51\> WL\<50\> WL\<49\> WL\<48\> WL\<47\> WL\<46\> WL\<45\> WL\<44\> WL\<43\> WL\<42\> WL\<41\> WL\<40\> WL\<39\> WL\<38\> WL\<37\> WL\<36\> WL\<35\> WL\<34\> WL\<33\> WL\<32\> WL\<31\> WL\<30\> WL\<29\> WL\<28\> WL\<27\> WL\<26\> WL\<25\> WL\<24\> WL\<23\> WL\<22\> WL\<21\> WL\<20\> WL\<19\> WL\<18\> WL\<17\> WL\<16\> WL\<15\> WL\<14\> WL\<13\> WL\<12\> WL\<11\> WL\<10\> WL\<9\> WL\<8\> WL\<7\> WL\<6\> WL\<5\> WL\<4\> WL\<3\> WL\<2\> WL\<1\> WL\<0\>
    IPost\<255\> (WLSel\<511\> WLSel\<510\> WL\<255\>) Post
    IPost\<254\> (WLSel\<509\> WLSel\<508\> WL\<254\>) Post
    IPost\<253\> (WLSel\<507\> WLSel\<506\> WL\<253\>) Post
    IPost\<252\> (WLSel\<505\> WLSel\<504\> WL\<252\>) Post
    IPost\<251\> (WLSel\<503\> WLSel\<502\> WL\<251\>) Post
    IPost\<250\> (WLSel\<501\> WLSel\<500\> WL\<250\>) Post
    IPost\<249\> (WLSel\<499\> WLSel\<498\> WL\<249\>) Post
    IPost\<248\> (WLSel\<497\> WLSel\<496\> WL\<248\>) Post
    IPost\<247\> (WLSel\<495\> WLSel\<494\> WL\<247\>) Post
    IPost\<246\> (WLSel\<493\> WLSel\<492\> WL\<246\>) Post
    IPost\<245\> (WLSel\<491\> WLSel\<490\> WL\<245\>) Post
    IPost\<244\> (WLSel\<489\> WLSel\<488\> WL\<244\>) Post
    IPost\<243\> (WLSel\<487\> WLSel\<486\> WL\<243\>) Post
    IPost\<242\> (WLSel\<485\> WLSel\<484\> WL\<242\>) Post
    IPost\<241\> (WLSel\<483\> WLSel\<482\> WL\<241\>) Post
    IPost\<240\> (WLSel\<481\> WLSel\<480\> WL\<240\>) Post
    IPost\<239\> (WLSel\<479\> WLSel\<478\> WL\<239\>) Post
    IPost\<238\> (WLSel\<477\> WLSel\<476\> WL\<238\>) Post
    IPost\<237\> (WLSel\<475\> WLSel\<474\> WL\<237\>) Post
    IPost\<236\> (WLSel\<473\> WLSel\<472\> WL\<236\>) Post
    IPost\<235\> (WLSel\<471\> WLSel\<470\> WL\<235\>) Post
    IPost\<234\> (WLSel\<469\> WLSel\<468\> WL\<234\>) Post
    IPost\<233\> (WLSel\<467\> WLSel\<466\> WL\<233\>) Post
    IPost\<232\> (WLSel\<465\> WLSel\<464\> WL\<232\>) Post
    IPost\<231\> (WLSel\<463\> WLSel\<462\> WL\<231\>) Post
    IPost\<230\> (WLSel\<461\> WLSel\<460\> WL\<230\>) Post
    IPost\<229\> (WLSel\<459\> WLSel\<458\> WL\<229\>) Post
    IPost\<228\> (WLSel\<457\> WLSel\<456\> WL\<228\>) Post
    IPost\<227\> (WLSel\<455\> WLSel\<454\> WL\<227\>) Post
    IPost\<226\> (WLSel\<453\> WLSel\<452\> WL\<226\>) Post
    IPost\<225\> (WLSel\<451\> WLSel\<450\> WL\<225\>) Post
    IPost\<224\> (WLSel\<449\> WLSel\<448\> WL\<224\>) Post
    IPost\<223\> (WLSel\<447\> WLSel\<446\> WL\<223\>) Post
    IPost\<222\> (WLSel\<445\> WLSel\<444\> WL\<222\>) Post
    IPost\<221\> (WLSel\<443\> WLSel\<442\> WL\<221\>) Post
    IPost\<220\> (WLSel\<441\> WLSel\<440\> WL\<220\>) Post
    IPost\<219\> (WLSel\<439\> WLSel\<438\> WL\<219\>) Post
    IPost\<218\> (WLSel\<437\> WLSel\<436\> WL\<218\>) Post
    IPost\<217\> (WLSel\<435\> WLSel\<434\> WL\<217\>) Post
    IPost\<216\> (WLSel\<433\> WLSel\<432\> WL\<216\>) Post
    IPost\<215\> (WLSel\<431\> WLSel\<430\> WL\<215\>) Post
    IPost\<214\> (WLSel\<429\> WLSel\<428\> WL\<214\>) Post
    IPost\<213\> (WLSel\<427\> WLSel\<426\> WL\<213\>) Post
    IPost\<212\> (WLSel\<425\> WLSel\<424\> WL\<212\>) Post
    IPost\<211\> (WLSel\<423\> WLSel\<422\> WL\<211\>) Post
    IPost\<210\> (WLSel\<421\> WLSel\<420\> WL\<210\>) Post
    IPost\<209\> (WLSel\<419\> WLSel\<418\> WL\<209\>) Post
    IPost\<208\> (WLSel\<417\> WLSel\<416\> WL\<208\>) Post
    IPost\<207\> (WLSel\<415\> WLSel\<414\> WL\<207\>) Post
    IPost\<206\> (WLSel\<413\> WLSel\<412\> WL\<206\>) Post
    IPost\<205\> (WLSel\<411\> WLSel\<410\> WL\<205\>) Post
    IPost\<204\> (WLSel\<409\> WLSel\<408\> WL\<204\>) Post
    IPost\<203\> (WLSel\<407\> WLSel\<406\> WL\<203\>) Post
    IPost\<202\> (WLSel\<405\> WLSel\<404\> WL\<202\>) Post
    IPost\<201\> (WLSel\<403\> WLSel\<402\> WL\<201\>) Post
    IPost\<200\> (WLSel\<401\> WLSel\<400\> WL\<200\>) Post
    IPost\<199\> (WLSel\<399\> WLSel\<398\> WL\<199\>) Post
    IPost\<198\> (WLSel\<397\> WLSel\<396\> WL\<198\>) Post
    IPost\<197\> (WLSel\<395\> WLSel\<394\> WL\<197\>) Post
    IPost\<196\> (WLSel\<393\> WLSel\<392\> WL\<196\>) Post
    IPost\<195\> (WLSel\<391\> WLSel\<390\> WL\<195\>) Post
    IPost\<194\> (WLSel\<389\> WLSel\<388\> WL\<194\>) Post
    IPost\<193\> (WLSel\<387\> WLSel\<386\> WL\<193\>) Post
    IPost\<192\> (WLSel\<385\> WLSel\<384\> WL\<192\>) Post
    IPost\<191\> (WLSel\<383\> WLSel\<382\> WL\<191\>) Post
    IPost\<190\> (WLSel\<381\> WLSel\<380\> WL\<190\>) Post
    IPost\<189\> (WLSel\<379\> WLSel\<378\> WL\<189\>) Post
    IPost\<188\> (WLSel\<377\> WLSel\<376\> WL\<188\>) Post
    IPost\<187\> (WLSel\<375\> WLSel\<374\> WL\<187\>) Post
    IPost\<186\> (WLSel\<373\> WLSel\<372\> WL\<186\>) Post
    IPost\<185\> (WLSel\<371\> WLSel\<370\> WL\<185\>) Post
    IPost\<184\> (WLSel\<369\> WLSel\<368\> WL\<184\>) Post
    IPost\<183\> (WLSel\<367\> WLSel\<366\> WL\<183\>) Post
    IPost\<182\> (WLSel\<365\> WLSel\<364\> WL\<182\>) Post
    IPost\<181\> (WLSel\<363\> WLSel\<362\> WL\<181\>) Post
    IPost\<180\> (WLSel\<361\> WLSel\<360\> WL\<180\>) Post
    IPost\<179\> (WLSel\<359\> WLSel\<358\> WL\<179\>) Post
    IPost\<178\> (WLSel\<357\> WLSel\<356\> WL\<178\>) Post
    IPost\<177\> (WLSel\<355\> WLSel\<354\> WL\<177\>) Post
    IPost\<176\> (WLSel\<353\> WLSel\<352\> WL\<176\>) Post
    IPost\<175\> (WLSel\<351\> WLSel\<350\> WL\<175\>) Post
    IPost\<174\> (WLSel\<349\> WLSel\<348\> WL\<174\>) Post
    IPost\<173\> (WLSel\<347\> WLSel\<346\> WL\<173\>) Post
    IPost\<172\> (WLSel\<345\> WLSel\<344\> WL\<172\>) Post
    IPost\<171\> (WLSel\<343\> WLSel\<342\> WL\<171\>) Post
    IPost\<170\> (WLSel\<341\> WLSel\<340\> WL\<170\>) Post
    IPost\<169\> (WLSel\<339\> WLSel\<338\> WL\<169\>) Post
    IPost\<168\> (WLSel\<337\> WLSel\<336\> WL\<168\>) Post
    IPost\<167\> (WLSel\<335\> WLSel\<334\> WL\<167\>) Post
    IPost\<166\> (WLSel\<333\> WLSel\<332\> WL\<166\>) Post
    IPost\<165\> (WLSel\<331\> WLSel\<330\> WL\<165\>) Post
    IPost\<164\> (WLSel\<329\> WLSel\<328\> WL\<164\>) Post
    IPost\<163\> (WLSel\<327\> WLSel\<326\> WL\<163\>) Post
    IPost\<162\> (WLSel\<325\> WLSel\<324\> WL\<162\>) Post
    IPost\<161\> (WLSel\<323\> WLSel\<322\> WL\<161\>) Post
    IPost\<160\> (WLSel\<321\> WLSel\<320\> WL\<160\>) Post
    IPost\<159\> (WLSel\<319\> WLSel\<318\> WL\<159\>) Post
    IPost\<158\> (WLSel\<317\> WLSel\<316\> WL\<158\>) Post
    IPost\<157\> (WLSel\<315\> WLSel\<314\> WL\<157\>) Post
    IPost\<156\> (WLSel\<313\> WLSel\<312\> WL\<156\>) Post
    IPost\<155\> (WLSel\<311\> WLSel\<310\> WL\<155\>) Post
    IPost\<154\> (WLSel\<309\> WLSel\<308\> WL\<154\>) Post
    IPost\<153\> (WLSel\<307\> WLSel\<306\> WL\<153\>) Post
    IPost\<152\> (WLSel\<305\> WLSel\<304\> WL\<152\>) Post
    IPost\<151\> (WLSel\<303\> WLSel\<302\> WL\<151\>) Post
    IPost\<150\> (WLSel\<301\> WLSel\<300\> WL\<150\>) Post
    IPost\<149\> (WLSel\<299\> WLSel\<298\> WL\<149\>) Post
    IPost\<148\> (WLSel\<297\> WLSel\<296\> WL\<148\>) Post
    IPost\<147\> (WLSel\<295\> WLSel\<294\> WL\<147\>) Post
    IPost\<146\> (WLSel\<293\> WLSel\<292\> WL\<146\>) Post
    IPost\<145\> (WLSel\<291\> WLSel\<290\> WL\<145\>) Post
    IPost\<144\> (WLSel\<289\> WLSel\<288\> WL\<144\>) Post
    IPost\<143\> (WLSel\<287\> WLSel\<286\> WL\<143\>) Post
    IPost\<142\> (WLSel\<285\> WLSel\<284\> WL\<142\>) Post
    IPost\<141\> (WLSel\<283\> WLSel\<282\> WL\<141\>) Post
    IPost\<140\> (WLSel\<281\> WLSel\<280\> WL\<140\>) Post
    IPost\<139\> (WLSel\<279\> WLSel\<278\> WL\<139\>) Post
    IPost\<138\> (WLSel\<277\> WLSel\<276\> WL\<138\>) Post
    IPost\<137\> (WLSel\<275\> WLSel\<274\> WL\<137\>) Post
    IPost\<136\> (WLSel\<273\> WLSel\<272\> WL\<136\>) Post
    IPost\<135\> (WLSel\<271\> WLSel\<270\> WL\<135\>) Post
    IPost\<134\> (WLSel\<269\> WLSel\<268\> WL\<134\>) Post
    IPost\<133\> (WLSel\<267\> WLSel\<266\> WL\<133\>) Post
    IPost\<132\> (WLSel\<265\> WLSel\<264\> WL\<132\>) Post
    IPost\<131\> (WLSel\<263\> WLSel\<262\> WL\<131\>) Post
    IPost\<130\> (WLSel\<261\> WLSel\<260\> WL\<130\>) Post
    IPost\<129\> (WLSel\<259\> WLSel\<258\> WL\<129\>) Post
    IPost\<128\> (WLSel\<257\> WLSel\<256\> WL\<128\>) Post
    IPost\<127\> (WLSel\<255\> WLSel\<254\> WL\<127\>) Post
    IPost\<126\> (WLSel\<253\> WLSel\<252\> WL\<126\>) Post
    IPost\<125\> (WLSel\<251\> WLSel\<250\> WL\<125\>) Post
    IPost\<124\> (WLSel\<249\> WLSel\<248\> WL\<124\>) Post
    IPost\<123\> (WLSel\<247\> WLSel\<246\> WL\<123\>) Post
    IPost\<122\> (WLSel\<245\> WLSel\<244\> WL\<122\>) Post
    IPost\<121\> (WLSel\<243\> WLSel\<242\> WL\<121\>) Post
    IPost\<120\> (WLSel\<241\> WLSel\<240\> WL\<120\>) Post
    IPost\<119\> (WLSel\<239\> WLSel\<238\> WL\<119\>) Post
    IPost\<118\> (WLSel\<237\> WLSel\<236\> WL\<118\>) Post
    IPost\<117\> (WLSel\<235\> WLSel\<234\> WL\<117\>) Post
    IPost\<116\> (WLSel\<233\> WLSel\<232\> WL\<116\>) Post
    IPost\<115\> (WLSel\<231\> WLSel\<230\> WL\<115\>) Post
    IPost\<114\> (WLSel\<229\> WLSel\<228\> WL\<114\>) Post
    IPost\<113\> (WLSel\<227\> WLSel\<226\> WL\<113\>) Post
    IPost\<112\> (WLSel\<225\> WLSel\<224\> WL\<112\>) Post
    IPost\<111\> (WLSel\<223\> WLSel\<222\> WL\<111\>) Post
    IPost\<110\> (WLSel\<221\> WLSel\<220\> WL\<110\>) Post
    IPost\<109\> (WLSel\<219\> WLSel\<218\> WL\<109\>) Post
    IPost\<108\> (WLSel\<217\> WLSel\<216\> WL\<108\>) Post
    IPost\<107\> (WLSel\<215\> WLSel\<214\> WL\<107\>) Post
    IPost\<106\> (WLSel\<213\> WLSel\<212\> WL\<106\>) Post
    IPost\<105\> (WLSel\<211\> WLSel\<210\> WL\<105\>) Post
    IPost\<104\> (WLSel\<209\> WLSel\<208\> WL\<104\>) Post
    IPost\<103\> (WLSel\<207\> WLSel\<206\> WL\<103\>) Post
    IPost\<102\> (WLSel\<205\> WLSel\<204\> WL\<102\>) Post
    IPost\<101\> (WLSel\<203\> WLSel\<202\> WL\<101\>) Post
    IPost\<100\> (WLSel\<201\> WLSel\<200\> WL\<100\>) Post
    IPost\<99\> (WLSel\<199\> WLSel\<198\> WL\<99\>) Post
    IPost\<98\> (WLSel\<197\> WLSel\<196\> WL\<98\>) Post
    IPost\<97\> (WLSel\<195\> WLSel\<194\> WL\<97\>) Post
    IPost\<96\> (WLSel\<193\> WLSel\<192\> WL\<96\>) Post
    IPost\<95\> (WLSel\<191\> WLSel\<190\> WL\<95\>) Post
    IPost\<94\> (WLSel\<189\> WLSel\<188\> WL\<94\>) Post
    IPost\<93\> (WLSel\<187\> WLSel\<186\> WL\<93\>) Post
    IPost\<92\> (WLSel\<185\> WLSel\<184\> WL\<92\>) Post
    IPost\<91\> (WLSel\<183\> WLSel\<182\> WL\<91\>) Post
    IPost\<90\> (WLSel\<181\> WLSel\<180\> WL\<90\>) Post
    IPost\<89\> (WLSel\<179\> WLSel\<178\> WL\<89\>) Post
    IPost\<88\> (WLSel\<177\> WLSel\<176\> WL\<88\>) Post
    IPost\<87\> (WLSel\<175\> WLSel\<174\> WL\<87\>) Post
    IPost\<86\> (WLSel\<173\> WLSel\<172\> WL\<86\>) Post
    IPost\<85\> (WLSel\<171\> WLSel\<170\> WL\<85\>) Post
    IPost\<84\> (WLSel\<169\> WLSel\<168\> WL\<84\>) Post
    IPost\<83\> (WLSel\<167\> WLSel\<166\> WL\<83\>) Post
    IPost\<82\> (WLSel\<165\> WLSel\<164\> WL\<82\>) Post
    IPost\<81\> (WLSel\<163\> WLSel\<162\> WL\<81\>) Post
    IPost\<80\> (WLSel\<161\> WLSel\<160\> WL\<80\>) Post
    IPost\<79\> (WLSel\<159\> WLSel\<158\> WL\<79\>) Post
    IPost\<78\> (WLSel\<157\> WLSel\<156\> WL\<78\>) Post
    IPost\<77\> (WLSel\<155\> WLSel\<154\> WL\<77\>) Post
    IPost\<76\> (WLSel\<153\> WLSel\<152\> WL\<76\>) Post
    IPost\<75\> (WLSel\<151\> WLSel\<150\> WL\<75\>) Post
    IPost\<74\> (WLSel\<149\> WLSel\<148\> WL\<74\>) Post
    IPost\<73\> (WLSel\<147\> WLSel\<146\> WL\<73\>) Post
    IPost\<72\> (WLSel\<145\> WLSel\<144\> WL\<72\>) Post
    IPost\<71\> (WLSel\<143\> WLSel\<142\> WL\<71\>) Post
    IPost\<70\> (WLSel\<141\> WLSel\<140\> WL\<70\>) Post
    IPost\<69\> (WLSel\<139\> WLSel\<138\> WL\<69\>) Post
    IPost\<68\> (WLSel\<137\> WLSel\<136\> WL\<68\>) Post
    IPost\<67\> (WLSel\<135\> WLSel\<134\> WL\<67\>) Post
    IPost\<66\> (WLSel\<133\> WLSel\<132\> WL\<66\>) Post
    IPost\<65\> (WLSel\<131\> WLSel\<130\> WL\<65\>) Post
    IPost\<64\> (WLSel\<129\> WLSel\<128\> WL\<64\>) Post
    IPost\<63\> (WLSel\<127\> WLSel\<126\> WL\<63\>) Post
    IPost\<62\> (WLSel\<125\> WLSel\<124\> WL\<62\>) Post
    IPost\<61\> (WLSel\<123\> WLSel\<122\> WL\<61\>) Post
    IPost\<60\> (WLSel\<121\> WLSel\<120\> WL\<60\>) Post
    IPost\<59\> (WLSel\<119\> WLSel\<118\> WL\<59\>) Post
    IPost\<58\> (WLSel\<117\> WLSel\<116\> WL\<58\>) Post
    IPost\<57\> (WLSel\<115\> WLSel\<114\> WL\<57\>) Post
    IPost\<56\> (WLSel\<113\> WLSel\<112\> WL\<56\>) Post
    IPost\<55\> (WLSel\<111\> WLSel\<110\> WL\<55\>) Post
    IPost\<54\> (WLSel\<109\> WLSel\<108\> WL\<54\>) Post
    IPost\<53\> (WLSel\<107\> WLSel\<106\> WL\<53\>) Post
    IPost\<52\> (WLSel\<105\> WLSel\<104\> WL\<52\>) Post
    IPost\<51\> (WLSel\<103\> WLSel\<102\> WL\<51\>) Post
    IPost\<50\> (WLSel\<101\> WLSel\<100\> WL\<50\>) Post
    IPost\<49\> (WLSel\<99\> WLSel\<98\> WL\<49\>) Post
    IPost\<48\> (WLSel\<97\> WLSel\<96\> WL\<48\>) Post
    IPost\<47\> (WLSel\<95\> WLSel\<94\> WL\<47\>) Post
    IPost\<46\> (WLSel\<93\> WLSel\<92\> WL\<46\>) Post
    IPost\<45\> (WLSel\<91\> WLSel\<90\> WL\<45\>) Post
    IPost\<44\> (WLSel\<89\> WLSel\<88\> WL\<44\>) Post
    IPost\<43\> (WLSel\<87\> WLSel\<86\> WL\<43\>) Post
    IPost\<42\> (WLSel\<85\> WLSel\<84\> WL\<42\>) Post
    IPost\<41\> (WLSel\<83\> WLSel\<82\> WL\<41\>) Post
    IPost\<40\> (WLSel\<81\> WLSel\<80\> WL\<40\>) Post
    IPost\<39\> (WLSel\<79\> WLSel\<78\> WL\<39\>) Post
    IPost\<38\> (WLSel\<77\> WLSel\<76\> WL\<38\>) Post
    IPost\<37\> (WLSel\<75\> WLSel\<74\> WL\<37\>) Post
    IPost\<36\> (WLSel\<73\> WLSel\<72\> WL\<36\>) Post
    IPost\<35\> (WLSel\<71\> WLSel\<70\> WL\<35\>) Post
    IPost\<34\> (WLSel\<69\> WLSel\<68\> WL\<34\>) Post
    IPost\<33\> (WLSel\<67\> WLSel\<66\> WL\<33\>) Post
    IPost\<32\> (WLSel\<65\> WLSel\<64\> WL\<32\>) Post
    IPost\<31\> (WLSel\<63\> WLSel\<62\> WL\<31\>) Post
    IPost\<30\> (WLSel\<61\> WLSel\<60\> WL\<30\>) Post
    IPost\<29\> (WLSel\<59\> WLSel\<58\> WL\<29\>) Post
    IPost\<28\> (WLSel\<57\> WLSel\<56\> WL\<28\>) Post
    IPost\<27\> (WLSel\<55\> WLSel\<54\> WL\<27\>) Post
    IPost\<26\> (WLSel\<53\> WLSel\<52\> WL\<26\>) Post
    IPost\<25\> (WLSel\<51\> WLSel\<50\> WL\<25\>) Post
    IPost\<24\> (WLSel\<49\> WLSel\<48\> WL\<24\>) Post
    IPost\<23\> (WLSel\<47\> WLSel\<46\> WL\<23\>) Post
    IPost\<22\> (WLSel\<45\> WLSel\<44\> WL\<22\>) Post
    IPost\<21\> (WLSel\<43\> WLSel\<42\> WL\<21\>) Post
    IPost\<20\> (WLSel\<41\> WLSel\<40\> WL\<20\>) Post
    IPost\<19\> (WLSel\<39\> WLSel\<38\> WL\<19\>) Post
    IPost\<18\> (WLSel\<37\> WLSel\<36\> WL\<18\>) Post
    IPost\<17\> (WLSel\<35\> WLSel\<34\> WL\<17\>) Post
    IPost\<16\> (WLSel\<33\> WLSel\<32\> WL\<16\>) Post
    IPost\<15\> (WLSel\<31\> WLSel\<30\> WL\<15\>) Post
    IPost\<14\> (WLSel\<29\> WLSel\<28\> WL\<14\>) Post
    IPost\<13\> (WLSel\<27\> WLSel\<26\> WL\<13\>) Post
    IPost\<12\> (WLSel\<25\> WLSel\<24\> WL\<12\>) Post
    IPost\<11\> (WLSel\<23\> WLSel\<22\> WL\<11\>) Post
    IPost\<10\> (WLSel\<21\> WLSel\<20\> WL\<10\>) Post
    IPost\<9\> (WLSel\<19\> WLSel\<18\> WL\<9\>) Post
    IPost\<8\> (WLSel\<17\> WLSel\<16\> WL\<8\>) Post
    IPost\<7\> (WLSel\<15\> WLSel\<14\> WL\<7\>) Post
    IPost\<6\> (WLSel\<13\> WLSel\<12\> WL\<6\>) Post
    IPost\<5\> (WLSel\<11\> WLSel\<10\> WL\<5\>) Post
    IPost\<4\> (WLSel\<9\> WLSel\<8\> WL\<4\>) Post
    IPost\<3\> (WLSel\<7\> WLSel\<6\> WL\<3\>) Post
    IPost\<2\> (WLSel\<5\> WLSel\<4\> WL\<2\>) Post
    IPost\<1\> (WLSel\<3\> WLSel\<2\> WL\<1\>) Post
    IPost\<0\> (WLSel\<1\> WLSel\<0\> WL\<0\>) Post
    I9 (WL\<255\> WL\<254\> WL\<253\> WL\<252\> WL\<251\> WL\<250\> WL\<249\> WL\<248\> WL\<247\> WL\<246\> WL\<245\> WL\<244\> WL\<243\> WL\<242\> WL\<241\> WL\<240\> WL\<239\> WL\<238\> WL\<237\> WL\<236\> WL\<235\> WL\<234\> WL\<233\> WL\<232\> WL\<231\> WL\<230\> WL\<229\> WL\<228\> WL\<227\> WL\<226\> WL\<225\> WL\<224\> WL\<223\> WL\<222\> WL\<221\> WL\<220\> WL\<219\> WL\<218\> WL\<217\> WL\<216\> WL\<215\> WL\<214\> WL\<213\> WL\<212\> WL\<211\> WL\<210\> WL\<209\> WL\<208\> WL\<207\> WL\<206\> WL\<205\> WL\<204\> WL\<203\> WL\<202\> WL\<201\> WL\<200\> WL\<199\> WL\<198\> WL\<197\> WL\<196\> WL\<195\> WL\<194\> WL\<193\> WL\<192\> WL\<191\> WL\<190\> WL\<189\> WL\<188\> WL\<187\> WL\<186\> WL\<185\> WL\<184\> WL\<183\> WL\<182\> WL\<181\> WL\<180\> WL\<179\> WL\<178\> WL\<177\> WL\<176\> WL\<175\> WL\<174\> WL\<173\> WL\<172\> WL\<171\> WL\<170\> WL\<169\> WL\<168\> WL\<167\> WL\<166\> WL\<165\> WL\<164\> WL\<163\> WL\<162\> WL\<161\> WL\<160\> WL\<159\> WL\<158\> WL\<157\> WL\<156\> WL\<155\> WL\<154\> WL\<153\> WL\<152\> WL\<151\> WL\<150\> WL\<149\> WL\<148\> WL\<147\> WL\<146\> WL\<145\> WL\<144\> WL\<143\> WL\<142\> WL\<141\> WL\<140\> WL\<139\> WL\<138\> WL\<137\> WL\<136\> WL\<135\> WL\<134\> WL\<133\> WL\<132\> WL\<131\> WL\<130\> WL\<129\> WL\<128\> WL\<127\> WL\<126\> WL\<125\> WL\<124\> WL\<123\> WL\<122\> WL\<121\> WL\<120\> WL\<119\> WL\<118\> WL\<117\> WL\<116\> WL\<115\> WL\<114\> WL\<113\> WL\<112\> WL\<111\> WL\<110\> WL\<109\> WL\<108\> WL\<107\> WL\<106\> WL\<105\> WL\<104\> WL\<103\> WL\<102\> WL\<101\> WL\<100\> WL\<99\> WL\<98\> WL\<97\> WL\<96\> WL\<95\> WL\<94\> WL\<93\> WL\<92\> WL\<91\> WL\<90\> WL\<89\> WL\<88\> WL\<87\> WL\<86\> WL\<85\> WL\<84\> WL\<83\> WL\<82\> WL\<81\> WL\<80\> WL\<79\> WL\<78\> WL\<77\> WL\<76\> WL\<75\> WL\<74\> WL\<73\> WL\<72\> WL\<71\> WL\<70\> WL\<69\> WL\<68\> WL\<67\> WL\<66\> WL\<65\> WL\<64\> WL\<63\> WL\<62\> WL\<61\> WL\<60\> WL\<59\> WL\<58\> WL\<57\> WL\<56\> WL\<55\> WL\<54\> WL\<53\> WL\<52\> WL\<51\> WL\<50\> WL\<49\> WL\<48\> WL\<47\> WL\<46\> WL\<45\> WL\<44\> WL\<43\> WL\<42\> WL\<41\> WL\<40\> WL\<39\> WL\<38\> WL\<37\> WL\<36\> WL\<35\> WL\<34\> WL\<33\> WL\<32\> WL\<31\> WL\<30\> WL\<29\> WL\<28\> WL\<27\> WL\<26\> WL\<25\> WL\<24\> WL\<23\> WL\<22\> WL\<21\> WL\<20\> WL\<19\> WL\<18\> WL\<17\> WL\<16\> WL\<15\> WL\<14\> WL\<13\> WL\<12\> WL\<11\> WL\<10\> WL\<9\> WL\<8\> WL\<7\> WL\<6\> WL\<5\> WL\<4\> WL\<3\> WL\<2\> WL\<1\> WL\<0\>) BitCellArray_Pex
    IPre0\<15\> (net11\<0\> net11\<1\> net11\<2\> net11\<3\> net013\<0\>) Pre
    IPre0\<14\> (net11\<4\> net11\<5\> net11\<6\> net11\<7\> net013\<1\>) Pre
    IPre0\<13\> (net11\<8\> net11\<9\> net11\<10\> net11\<11\> net013\<2\>) Pre
    IPre0\<12\> (net11\<12\> net11\<13\> net11\<14\> net11\<15\> net013\<3\>) Pre
    IPre0\<11\> (net11\<16\> net11\<17\> net11\<18\> net11\<19\> net013\<4\>) Pre
    IPre0\<10\> (net11\<20\> net11\<21\> net11\<22\> net11\<23\> net013\<5\>) Pre
    IPre0\<9\> (net11\<24\> net11\<25\> net11\<26\> net11\<27\> net013\<6\>) Pre
    IPre0\<8\> (net11\<28\> net11\<29\> net11\<30\> net11\<31\> net013\<7\>) Pre
    IPre0\<7\> (net11\<32\> net11\<33\> net11\<34\> net11\<35\> net013\<8\>) Pre
    IPre0\<6\> (net11\<36\> net11\<37\> net11\<38\> net11\<39\> net013\<9\>) Pre
    IPre0\<5\> (net11\<40\> net11\<41\> net11\<42\> net11\<43\> net013\<10\>) Pre
    IPre0\<4\> (net11\<44\> net11\<45\> net11\<46\> net11\<47\> net013\<11\>) Pre
    IPre0\<3\> (net11\<48\> net11\<49\> net11\<50\> net11\<51\> net013\<12\>) Pre
    IPre0\<2\> (net11\<52\> net11\<53\> net11\<54\> net11\<55\> net013\<13\>) Pre
    IPre0\<1\> (net11\<56\> net11\<57\> net11\<58\> net11\<59\> net013\<14\>) Pre
    IPre0\<0\> (net11\<60\> net11\<61\> net11\<62\> net11\<63\> net013\<15\>) Pre
    IPre1\<15\> (net9\<0\> net9\<1\> net9\<2\> net9\<3\> net014\<0\>) Pre
    IPre1\<14\> (net9\<4\> net9\<5\> net9\<6\> net9\<7\> net014\<1\>) Pre
    IPre1\<13\> (net9\<8\> net9\<9\> net9\<10\> net9\<11\> net014\<2\>) Pre
    IPre1\<12\> (net9\<12\> net9\<13\> net9\<14\> net9\<15\> net014\<3\>) Pre
    IPre1\<11\> (net9\<16\> net9\<17\> net9\<18\> net9\<19\> net014\<4\>) Pre
    IPre1\<10\> (net9\<20\> net9\<21\> net9\<22\> net9\<23\> net014\<5\>) Pre
    IPre1\<9\> (net9\<24\> net9\<25\> net9\<26\> net9\<27\> net014\<6\>) Pre
    IPre1\<8\> (net9\<28\> net9\<29\> net9\<30\> net9\<31\> net014\<7\>) Pre
    IPre1\<7\> (net9\<32\> net9\<33\> net9\<34\> net9\<35\> net014\<8\>) Pre
    IPre1\<6\> (net9\<36\> net9\<37\> net9\<38\> net9\<39\> net014\<9\>) Pre
    IPre1\<5\> (net9\<40\> net9\<41\> net9\<42\> net9\<43\> net014\<10\>) Pre
    IPre1\<4\> (net9\<44\> net9\<45\> net9\<46\> net9\<47\> net014\<11\>) Pre
    IPre1\<3\> (net9\<48\> net9\<49\> net9\<50\> net9\<51\> net014\<12\>) Pre
    IPre1\<2\> (net9\<52\> net9\<53\> net9\<54\> net9\<55\> net014\<13\>) Pre
    IPre1\<1\> (net9\<56\> net9\<57\> net9\<58\> net9\<59\> net014\<14\>) Pre
    IPre1\<0\> (net9\<60\> net9\<61\> net9\<62\> net9\<63\> net014\<15\>) Pre
    I3 (net028\<0\> net028\<1\> net028\<2\> net028\<3\> net032\<0\> net032\<1\> net032\<2\> net032\<3\> net11\<0\> net11\<1\> net11\<2\> net11\<3\> net11\<4\> net11\<5\> net11\<6\> net11\<7\> net11\<8\> net11\<9\> net11\<10\> net11\<11\> net11\<12\> net11\<13\> net11\<14\> net11\<15\> net11\<16\> net11\<17\> net11\<18\> net11\<19\> net11\<20\> net11\<21\> net11\<22\> net11\<23\> net11\<24\> net11\<25\> net11\<26\> net11\<27\> net11\<28\> net11\<29\> net11\<30\> net11\<31\> net11\<32\> net11\<33\> net11\<34\> net11\<35\> net11\<36\> net11\<37\> net11\<38\> net11\<39\> net11\<40\> net11\<41\> net11\<42\> net11\<43\> net11\<44\> net11\<45\> net11\<46\> net11\<47\> net11\<48\> net11\<49\> net11\<50\> net11\<51\> net11\<52\> net11\<53\> net11\<54\> net11\<55\> net11\<56\> net11\<57\> net11\<58\> net11\<59\> net11\<60\> net11\<61\> net11\<62\> net11\<63\>) Pre_L3_4t16_NAND
    I0 (net021\<0\> net021\<1\> net021\<2\> net021\<3\> net025\<0\> net025\<1\> net025\<2\> net025\<3\> net9\<0\> net9\<1\> net9\<2\> net9\<3\> net9\<4\> net9\<5\> net9\<6\> net9\<7\> net9\<8\> net9\<9\> net9\<10\> net9\<11\> net9\<12\> net9\<13\> net9\<14\> net9\<15\> net9\<16\> net9\<17\> net9\<18\> net9\<19\> net9\<20\> net9\<21\> net9\<22\> net9\<23\> net9\<24\> net9\<25\> net9\<26\> net9\<27\> net9\<28\> net9\<29\> net9\<30\> net9\<31\> net9\<32\> net9\<33\> net9\<34\> net9\<35\> net9\<36\> net9\<37\> net9\<38\> net9\<39\> net9\<40\> net9\<41\> net9\<42\> net9\<43\> net9\<44\> net9\<45\> net9\<46\> net9\<47\> net9\<48\> net9\<49\> net9\<50\> net9\<51\> net9\<52\> net9\<53\> net9\<54\> net9\<55\> net9\<56\> net9\<57\> net9\<58\> net9\<59\> net9\<60\> net9\<61\> net9\<62\> net9\<63\>) Pre_L3_4t16_NAND
    I16\<3\> (net020\<0\> net021\<0\>) AddrBuf
    I16\<2\> (net020\<1\> net021\<1\>) AddrBuf
    I16\<1\> (net020\<2\> net021\<2\>) AddrBuf
    I16\<0\> (net020\<3\> net021\<3\>) AddrBuf
    I19\<3\> (net031\<0\> net032\<0\>) AddrBuf
    I19\<2\> (net031\<1\> net032\<1\>) AddrBuf
    I19\<1\> (net031\<2\> net032\<2\>) AddrBuf
    I19\<0\> (net031\<3\> net032\<3\>) AddrBuf
    I18\<3\> (net027\<0\> net028\<0\>) AddrBuf
    I18\<2\> (net027\<1\> net028\<1\>) AddrBuf
    I18\<1\> (net027\<2\> net028\<2\>) AddrBuf
    I18\<0\> (net027\<3\> net028\<3\>) AddrBuf
    I17\<3\> (net024\<0\> net025\<0\>) AddrBuf
    I17\<2\> (net024\<1\> net025\<1\>) AddrBuf
    I17\<1\> (net024\<2\> net025\<2\>) AddrBuf
    I17\<0\> (net024\<3\> net025\<3\>) AddrBuf
    I4\<3\> (ADDR\<3\> net031\<0\>) INV gamma=1 beta=2
    I4\<2\> (ADDR\<2\> net031\<1\>) INV gamma=1 beta=2
    I4\<1\> (ADDR\<1\> net031\<2\>) INV gamma=1 beta=2
    I4\<0\> (ADDR\<0\> net031\<3\>) INV gamma=1 beta=2
    I1\<3\> (ADDR\<7\> net024\<0\>) INV gamma=1 beta=2
    I1\<2\> (ADDR\<6\> net024\<1\>) INV gamma=1 beta=2
    I1\<1\> (ADDR\<5\> net024\<2\>) INV gamma=1 beta=2
    I1\<0\> (ADDR\<4\> net024\<3\>) INV gamma=1 beta=2
    I7 (net013\<0\> net013\<1\> net013\<2\> net013\<3\> net013\<4\> net013\<5\> net013\<6\> net013\<7\> net013\<8\> net013\<9\> net013\<10\> net013\<11\> net013\<12\> net013\<13\> net013\<14\> net013\<15\> net014\<0\> net014\<1\> net014\<2\> net014\<3\> net014\<4\> net014\<5\> net014\<6\> net014\<7\> net014\<8\> net014\<9\> net014\<10\> net014\<11\> net014\<12\> net014\<13\> net014\<14\> net014\<15\> WLSel\<511\> WLSel\<510\> WLSel\<509\> WLSel\<508\> WLSel\<507\> WLSel\<506\> WLSel\<505\> WLSel\<504\> WLSel\<503\> WLSel\<502\> WLSel\<501\> WLSel\<500\> WLSel\<499\> WLSel\<498\> WLSel\<497\> WLSel\<496\> WLSel\<495\> WLSel\<494\> WLSel\<493\> WLSel\<492\> WLSel\<491\> WLSel\<490\> WLSel\<489\> WLSel\<488\> WLSel\<487\> WLSel\<486\> WLSel\<485\> WLSel\<484\> WLSel\<483\> WLSel\<482\> WLSel\<481\> WLSel\<480\> WLSel\<479\> WLSel\<478\> WLSel\<477\> WLSel\<476\> WLSel\<475\> WLSel\<474\> WLSel\<473\> WLSel\<472\> WLSel\<471\> WLSel\<470\> WLSel\<469\> WLSel\<468\> WLSel\<467\> WLSel\<466\> WLSel\<465\> WLSel\<464\> WLSel\<463\> WLSel\<462\> WLSel\<461\> WLSel\<460\> WLSel\<459\> WLSel\<458\> WLSel\<457\> WLSel\<456\> WLSel\<455\> WLSel\<454\> WLSel\<453\> WLSel\<452\> WLSel\<451\> WLSel\<450\> WLSel\<449\> WLSel\<448\> WLSel\<447\> WLSel\<446\> WLSel\<445\> WLSel\<444\> WLSel\<443\> WLSel\<442\> WLSel\<441\> WLSel\<440\> WLSel\<439\> WLSel\<438\> WLSel\<437\> WLSel\<436\> WLSel\<435\> WLSel\<434\> WLSel\<433\> WLSel\<432\> WLSel\<431\> WLSel\<430\> WLSel\<429\> WLSel\<428\> WLSel\<427\> WLSel\<426\> WLSel\<425\> WLSel\<424\> WLSel\<423\> WLSel\<422\> WLSel\<421\> WLSel\<420\> WLSel\<419\> WLSel\<418\> WLSel\<417\> WLSel\<416\> WLSel\<415\> WLSel\<414\> WLSel\<413\> WLSel\<412\> WLSel\<411\> WLSel\<410\> WLSel\<409\> WLSel\<408\> WLSel\<407\> WLSel\<406\> WLSel\<405\> WLSel\<404\> WLSel\<403\> WLSel\<402\> WLSel\<401\> WLSel\<400\> WLSel\<399\> WLSel\<398\> WLSel\<397\> WLSel\<396\> WLSel\<395\> WLSel\<394\> WLSel\<393\> WLSel\<392\> WLSel\<391\> WLSel\<390\> WLSel\<389\> WLSel\<388\> WLSel\<387\> WLSel\<386\> WLSel\<385\> WLSel\<384\> WLSel\<383\> WLSel\<382\> WLSel\<381\> WLSel\<380\> WLSel\<379\> WLSel\<378\> WLSel\<377\> WLSel\<376\> WLSel\<375\> WLSel\<374\> WLSel\<373\> WLSel\<372\> WLSel\<371\> WLSel\<370\> WLSel\<369\> WLSel\<368\> WLSel\<367\> WLSel\<366\> WLSel\<365\> WLSel\<364\> WLSel\<363\> WLSel\<362\> WLSel\<361\> WLSel\<360\> WLSel\<359\> WLSel\<358\> WLSel\<357\> WLSel\<356\> WLSel\<355\> WLSel\<354\> WLSel\<353\> WLSel\<352\> WLSel\<351\> WLSel\<350\> WLSel\<349\> WLSel\<348\> WLSel\<347\> WLSel\<346\> WLSel\<345\> WLSel\<344\> WLSel\<343\> WLSel\<342\> WLSel\<341\> WLSel\<340\> WLSel\<339\> WLSel\<338\> WLSel\<337\> WLSel\<336\> WLSel\<335\> WLSel\<334\> WLSel\<333\> WLSel\<332\> WLSel\<331\> WLSel\<330\> WLSel\<329\> WLSel\<328\> WLSel\<327\> WLSel\<326\> WLSel\<325\> WLSel\<324\> WLSel\<323\> WLSel\<322\> WLSel\<321\> WLSel\<320\> WLSel\<319\> WLSel\<318\> WLSel\<317\> WLSel\<316\> WLSel\<315\> WLSel\<314\> WLSel\<313\> WLSel\<312\> WLSel\<311\> WLSel\<310\> WLSel\<309\> WLSel\<308\> WLSel\<307\> WLSel\<306\> WLSel\<305\> WLSel\<304\> WLSel\<303\> WLSel\<302\> WLSel\<301\> WLSel\<300\> WLSel\<299\> WLSel\<298\> WLSel\<297\> WLSel\<296\> WLSel\<295\> WLSel\<294\> WLSel\<293\> WLSel\<292\> WLSel\<291\> WLSel\<290\> WLSel\<289\> WLSel\<288\> WLSel\<287\> WLSel\<286\> WLSel\<285\> WLSel\<284\> WLSel\<283\> WLSel\<282\> WLSel\<281\> WLSel\<280\> WLSel\<279\> WLSel\<278\> WLSel\<277\> WLSel\<276\> WLSel\<275\> WLSel\<274\> WLSel\<273\> WLSel\<272\> WLSel\<271\> WLSel\<270\> WLSel\<269\> WLSel\<268\> WLSel\<267\> WLSel\<266\> WLSel\<265\> WLSel\<264\> WLSel\<263\> WLSel\<262\> WLSel\<261\> WLSel\<260\> WLSel\<259\> WLSel\<258\> WLSel\<257\> WLSel\<256\> WLSel\<255\> WLSel\<254\> WLSel\<253\> WLSel\<252\> WLSel\<251\> WLSel\<250\> WLSel\<249\> WLSel\<248\> WLSel\<247\> WLSel\<246\> WLSel\<245\> WLSel\<244\> WLSel\<243\> WLSel\<242\> WLSel\<241\> WLSel\<240\> WLSel\<239\> WLSel\<238\> WLSel\<237\> WLSel\<236\> WLSel\<235\> WLSel\<234\> WLSel\<233\> WLSel\<232\> WLSel\<231\> WLSel\<230\> WLSel\<229\> WLSel\<228\> WLSel\<227\> WLSel\<226\> WLSel\<225\> WLSel\<224\> WLSel\<223\> WLSel\<222\> WLSel\<221\> WLSel\<220\> WLSel\<219\> WLSel\<218\> WLSel\<217\> WLSel\<216\> WLSel\<215\> WLSel\<214\> WLSel\<213\> WLSel\<212\> WLSel\<211\> WLSel\<210\> WLSel\<209\> WLSel\<208\> WLSel\<207\> WLSel\<206\> WLSel\<205\> WLSel\<204\> WLSel\<203\> WLSel\<202\> WLSel\<201\> WLSel\<200\> WLSel\<199\> WLSel\<198\> WLSel\<197\> WLSel\<196\> WLSel\<195\> WLSel\<194\> WLSel\<193\> WLSel\<192\> WLSel\<191\> WLSel\<190\> WLSel\<189\> WLSel\<188\> WLSel\<187\> WLSel\<186\> WLSel\<185\> WLSel\<184\> WLSel\<183\> WLSel\<182\> WLSel\<181\> WLSel\<180\> WLSel\<179\> WLSel\<178\> WLSel\<177\> WLSel\<176\> WLSel\<175\> WLSel\<174\> WLSel\<173\> WLSel\<172\> WLSel\<171\> WLSel\<170\> WLSel\<169\> WLSel\<168\> WLSel\<167\> WLSel\<166\> WLSel\<165\> WLSel\<164\> WLSel\<163\> WLSel\<162\> WLSel\<161\> WLSel\<160\> WLSel\<159\> WLSel\<158\> WLSel\<157\> WLSel\<156\> WLSel\<155\> WLSel\<154\> WLSel\<153\> WLSel\<152\> WLSel\<151\> WLSel\<150\> WLSel\<149\> WLSel\<148\> WLSel\<147\> WLSel\<146\> WLSel\<145\> WLSel\<144\> WLSel\<143\> WLSel\<142\> WLSel\<141\> WLSel\<140\> WLSel\<139\> WLSel\<138\> WLSel\<137\> WLSel\<136\> WLSel\<135\> WLSel\<134\> WLSel\<133\> WLSel\<132\> WLSel\<131\> WLSel\<130\> WLSel\<129\> WLSel\<128\> WLSel\<127\> WLSel\<126\> WLSel\<125\> WLSel\<124\> WLSel\<123\> WLSel\<122\> WLSel\<121\> WLSel\<120\> WLSel\<119\> WLSel\<118\> WLSel\<117\> WLSel\<116\> WLSel\<115\> WLSel\<114\> WLSel\<113\> WLSel\<112\> WLSel\<111\> WLSel\<110\> WLSel\<109\> WLSel\<108\> WLSel\<107\> WLSel\<106\> WLSel\<105\> WLSel\<104\> WLSel\<103\> WLSel\<102\> WLSel\<101\> WLSel\<100\> WLSel\<99\> WLSel\<98\> WLSel\<97\> WLSel\<96\> WLSel\<95\> WLSel\<94\> WLSel\<93\> WLSel\<92\> WLSel\<91\> WLSel\<90\> WLSel\<89\> WLSel\<88\> WLSel\<87\> WLSel\<86\> WLSel\<85\> WLSel\<84\> WLSel\<83\> WLSel\<82\> WLSel\<81\> WLSel\<80\> WLSel\<79\> WLSel\<78\> WLSel\<77\> WLSel\<76\> WLSel\<75\> WLSel\<74\> WLSel\<73\> WLSel\<72\> WLSel\<71\> WLSel\<70\> WLSel\<69\> WLSel\<68\> WLSel\<67\> WLSel\<66\> WLSel\<65\> WLSel\<64\> WLSel\<63\> WLSel\<62\> WLSel\<61\> WLSel\<60\> WLSel\<59\> WLSel\<58\> WLSel\<57\> WLSel\<56\> WLSel\<55\> WLSel\<54\> WLSel\<53\> WLSel\<52\> WLSel\<51\> WLSel\<50\> WLSel\<49\> WLSel\<48\> WLSel\<47\> WLSel\<46\> WLSel\<45\> WLSel\<44\> WLSel\<43\> WLSel\<42\> WLSel\<41\> WLSel\<40\> WLSel\<39\> WLSel\<38\> WLSel\<37\> WLSel\<36\> WLSel\<35\> WLSel\<34\> WLSel\<33\> WLSel\<32\> WLSel\<31\> WLSel\<30\> WLSel\<29\> WLSel\<28\> WLSel\<27\> WLSel\<26\> WLSel\<25\> WLSel\<24\> WLSel\<23\> WLSel\<22\> WLSel\<21\> WLSel\<20\> WLSel\<19\> WLSel\<18\> WLSel\<17\> WLSel\<16\> WLSel\<15\> WLSel\<14\> WLSel\<13\> WLSel\<12\> WLSel\<11\> WLSel\<10\> WLSel\<9\> WLSel\<8\> WLSel\<7\> WLSel\<6\> WLSel\<5\> WLSel\<4\> WLSel\<3\> WLSel\<2\> WLSel\<1\> WLSel\<0\>) Post_L2_256t2_Pex
    I11\<3\> (ADDR\<3\> net027\<0\>) BUF gamma=1 beta=2
    I11\<2\> (ADDR\<2\> net027\<1\>) BUF gamma=1 beta=2
    I11\<1\> (ADDR\<1\> net027\<2\>) BUF gamma=1 beta=2
    I11\<0\> (ADDR\<0\> net027\<3\>) BUF gamma=1 beta=2
    I10\<3\> (ADDR\<7\> net020\<0\>) BUF gamma=1 beta=2
    I10\<2\> (ADDR\<6\> net020\<1\>) BUF gamma=1 beta=2
    I10\<1\> (ADDR\<5\> net020\<2\>) BUF gamma=1 beta=2
    I10\<0\> (ADDR\<4\> net020\<3\>) BUF gamma=1 beta=2
ends RowDecoder_256_4xP

// project_4x/RowDecoder_256_4xP_TB/schematic
V0 (vdd! 0) vsource dc=1.2 type=dc
V8 (A\<0\> 0) vsource dc=1.2 type=pulse val0=1.2 val1=0 period=2n delay=0 rise=10f fall=10f width=1n
V7 (A\<1\> 0) vsource dc=1.2 type=pulse val0=1.2 val1=0 period=4n delay=0 rise=10f fall=10f width=2n
V6 (A\<2\> 0) vsource dc=1.2 type=pulse val0=1.2 val1=0 period=8n delay=0 rise=10f fall=10f width=4n
V5 (A\<3\> 0) vsource dc=1.2 type=pulse val0=1.2 val1=0 period=16n delay=0 rise=10f fall=10f width=8n
V4 (A\<4\> 0) vsource dc=1.2 type=pulse val0=1.2 val1=0 period=32n delay=0 rise=10f fall=10f width=16n
V3 (A\<5\> 0) vsource dc=1.2 type=pulse val0=1.2 val1=0 period=64n delay=0 rise=10f fall=10f width=32n
V2 (A\<6\> 0) vsource dc=1.2 type=pulse val0=1.2 val1=0 period=128n delay=0 rise=10f fall=10f width=64n
V1 (A\<7\> 0) vsource dc=1.2 type=pulse val0=1.2 val1=0 period=256n delay=0 rise=10f fall=10f width=128n
I18 (A\<7\> A\<6\> A\<5\> A\<4\> A\<3\> A\<2\> A\<1\> A\<0\> WL\<255\> WL\<254\> WL\<253\> WL\<252\> WL\<251\> WL\<250\> WL\<249\> WL\<248\> WL\<247\> WL\<246\> WL\<245\> WL\<244\> WL\<243\> WL\<242\> WL\<241\> WL\<240\> WL\<239\> WL\<238\> WL\<237\> WL\<236\> WL\<235\> WL\<234\> WL\<233\> WL\<232\> WL\<231\> WL\<230\> WL\<229\> WL\<228\> WL\<227\> WL\<226\> WL\<225\> WL\<224\> WL\<223\> WL\<222\> WL\<221\> WL\<220\> WL\<219\> WL\<218\> WL\<217\> WL\<216\> WL\<215\> WL\<214\> WL\<213\> WL\<212\> WL\<211\> WL\<210\> WL\<209\> WL\<208\> WL\<207\> WL\<206\> WL\<205\> WL\<204\> WL\<203\> WL\<202\> WL\<201\> WL\<200\> WL\<199\> WL\<198\> WL\<197\> WL\<196\> WL\<195\> WL\<194\> WL\<193\> WL\<192\> WL\<191\> WL\<190\> WL\<189\> WL\<188\> WL\<187\> WL\<186\> WL\<185\> WL\<184\> WL\<183\> WL\<182\> WL\<181\> WL\<180\> WL\<179\> WL\<178\> WL\<177\> WL\<176\> WL\<175\> WL\<174\> WL\<173\> WL\<172\> WL\<171\> WL\<170\> WL\<169\> WL\<168\> WL\<167\> WL\<166\> WL\<165\> WL\<164\> WL\<163\> WL\<162\> WL\<161\> WL\<160\> WL\<159\> WL\<158\> WL\<157\> WL\<156\> WL\<155\> WL\<154\> WL\<153\> WL\<152\> WL\<151\> WL\<150\> WL\<149\> WL\<148\> WL\<147\> WL\<146\> WL\<145\> WL\<144\> WL\<143\> WL\<142\> WL\<141\> WL\<140\> WL\<139\> WL\<138\> WL\<137\> WL\<136\> WL\<135\> WL\<134\> WL\<133\> WL\<132\> WL\<131\> WL\<130\> WL\<129\> WL\<128\> WL\<127\> WL\<126\> WL\<125\> WL\<124\> WL\<123\> WL\<122\> WL\<121\> WL\<120\> WL\<119\> WL\<118\> WL\<117\> WL\<116\> WL\<115\> WL\<114\> WL\<113\> WL\<112\> WL\<111\> WL\<110\> WL\<109\> WL\<108\> WL\<107\> WL\<106\> WL\<105\> WL\<104\> WL\<103\> WL\<102\> WL\<101\> WL\<100\> WL\<99\> WL\<98\> WL\<97\> WL\<96\> WL\<95\> WL\<94\> WL\<93\> WL\<92\> WL\<91\> WL\<90\> WL\<89\> WL\<88\> WL\<87\> WL\<86\> WL\<85\> WL\<84\> WL\<83\> WL\<82\> WL\<81\> WL\<80\> WL\<79\> WL\<78\> WL\<77\> WL\<76\> WL\<75\> WL\<74\> WL\<73\> WL\<72\> WL\<71\> WL\<70\> WL\<69\> WL\<68\> WL\<67\> WL\<66\> WL\<65\> WL\<64\> WL\<63\> WL\<62\> WL\<61\> WL\<60\> WL\<59\> WL\<58\> WL\<57\> WL\<56\> WL\<55\> WL\<54\> WL\<53\> WL\<52\> WL\<51\> WL\<50\> WL\<49\> WL\<48\> WL\<47\> WL\<46\> WL\<45\> WL\<44\> WL\<43\> WL\<42\> WL\<41\> WL\<40\> WL\<39\> WL\<38\> WL\<37\> WL\<36\> WL\<35\> WL\<34\> WL\<33\> WL\<32\> WL\<31\> WL\<30\> WL\<29\> WL\<28\> WL\<27\> WL\<26\> WL\<25\> WL\<24\> WL\<23\> WL\<22\> WL\<21\> WL\<20\> WL\<19\> WL\<18\> WL\<17\> WL\<16\> WL\<15\> WL\<14\> WL\<13\> WL\<12\> WL\<11\> WL\<10\> WL\<9\> WL\<8\> WL\<7\> WL\<6\> WL\<5\> WL\<4\> WL\<3\> WL\<2\> WL\<1\> WL\<0\>) RowDecoder_256_4xP
simulatorOptions options temp=27
tran tran stop=10n
include "/home/edauser0/ayigit/RowDecoder_Project/CDS_VISIO/project_pex/BitCellArray_Text/spectreText/spectre.scs"
include "/home/edauser0/ayigit/RowDecoder_Project/CDS_VISIO/project_pex/Post_L2_256t2_Text/spectreText/spectre.scs"
