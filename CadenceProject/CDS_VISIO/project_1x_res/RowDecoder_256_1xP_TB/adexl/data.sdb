ADE simulation setup
Run mode: Single Run, Sweeps and Corners
Tests:
  project_1x:RowDecoder_256_1xP_TB:1: project_1x_res/RowDecoder_256_1xP_TB/schematic, simulator spectre
    Outputs: "/WL<0,1,2,3>"; /A<7:0>; "/"; /; "/I18/I7/I2<0>/I2<0>/I2<0>/I2<0>/I2<0>/I2<0>/I2<0>/WL<0>"; "/I18/I7/I2<0>/I2<0>/I2<0>/I2<0>/I2<0>/I2<0>/I2<0>/WL<1:0>"; "/I18/I7/I2<0>/I2<0>/I2<0>/I2<0>/I2<0>/I2<0>/I2<0>/WL<7:0>"; "/I18/I7/I2<0>/I2<0>/I2<0>/I2<0>/I2<0>/I2<0>/I2<0>/WL<15:0>"; "/I18/I7/I2<0>/I2<0>/I2<0>/I2<0>/I2<0>/I2<0>/I2<0>/I2<0>/WL<15:0>"; "/I18/I7/I2<0>/I2<0>/I2<0>/I2<0>/I2<0>/I2<0>/I2<0>/I2<1>/WL<15:0>"; "/I18/I7/I2<1>/WL<0,1>"; /I18/I7/Sel6_tmp<1>; /I18/I7/Sel5_tmp<1>; /I18/WLSel<1792>; /I18/WLSel<16>; /WL<0,1,2,3>
