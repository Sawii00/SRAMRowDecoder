ADE simulation setup
Run mode: Single Run, Sweeps and Corners
Tests:
  project_2x:RowDecoder_256_2xP_TB:1: project_2x/RowDecoder_256_2xP_TB/schematic, simulator spectre
    Outputs: /WL<0,1>; /A<7:0>; /I18/net028<0:7>; /I18/net045<0:3>
