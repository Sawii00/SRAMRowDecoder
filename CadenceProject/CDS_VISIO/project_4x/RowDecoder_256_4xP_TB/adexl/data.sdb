ADE simulation setup
Run mode: Single Run, Sweeps and Corners
Tests:
  project_4x:RowDecoder_256_4xP_TB:1: project_4x/RowDecoder_256_4xP_TB/schematic, simulator spectre
    Outputs: AddressLines; WordLines; PreDecoderInput; PreDecoderOutput; PostDecoderInput; delay(?wf1 VT("/A<0>") ?value1 0.5 ?edge1 "rising" ?nth1 1 ?td1 0.0 ?tol1 nil ?wf2 VT("/WL<1>") ?value2 0.5 ?edge2 "rising" ?nth2 1 ?tol2 nil ?td2 nil ?stop nil ?multiple nil); delay(?wf1 VT("/I18/net11<59>") ?value1 0.5 ?edge1 "rising" ?nth1 1 ?td1 0.0 ?tol1 nil ?wf2 VT("/WL<1>") ?value2 0.5 ?edge2 "rising" ?nth2 1 ?tol2 nil ?td2 nil ?stop nil ?multiple nil); PreIO; PostIO; /A<1:0>; "/WL<2:0>"; /WL<2:0>
Global variables:
  pre_nand1_gamma = 1
  pre_inv1_gamma = 4
  pre_nand2_gamma = 12
  pre_inv2_gamma = 42
  post_nand_gamma = 8
  post_inv_gamma = 18
